* cell PAD_RING_TOP
.SUBCKT PAD_RING_TOP
* net 2 gf180mcu_gnd
* cell instance $1 r0 *1 355.16,0
X$1 276 237 91 1 90 1 90 gf180mcu_fd_io__fill10
* cell instance $2 r0 *1 365.16,0
X$2 276 91 236 1 90 1 90 gf180mcu_fd_io__fill10
* cell instance $3 r0 *1 375.16,0
X$3 276 236 234 1 90 1 90 gf180mcu_fd_io__fill10
* cell instance $4 r0 *1 385.16,0
X$4 276 234 191 1 90 1 90 gf180mcu_fd_io__fill10
* cell instance $5 r0 *1 395.16,0
X$5 276 191 13 1 90 1 90 gf180mcu_fd_io__fill5
* cell instance $6 r0 *1 400.16,0
X$6 1 90 1 90 276 13 13 gf180mcu_fd_io__fill1
* cell instance $7 r0 *1 401.16,0
X$7 1 90 1 90 276 13 13 gf180mcu_fd_io__fill1
* cell instance $8 r0 *1 402.16,0
X$8 1 90 1 90 276 13 13 gf180mcu_fd_io__fill1
* cell instance $9 r0 *1 403.16,0
X$9 1 90 1 90 276 13 13 gf180mcu_fd_io__fill1
* cell instance $10 r0 *1 404.16,0
X$10 1 90 1 90 276 13 13 1 1 1 gf180mcu_fd_io__fillnc
* cell instance $11 r0 *1 404.26,0
X$11 1 90 1 90 273 273 13 13 276 gf180mcu_fd_io__asig_5p0
* cell instance $12 r0 *1 479.26,0
X$12 276 273 238 1 90 1 90 gf180mcu_fd_io__fill10
* cell instance $13 r0 *1 489.26,0
X$13 276 238 243 1 90 1 90 gf180mcu_fd_io__fill10
* cell instance $14 r0 *1 499.26,0
X$14 276 243 266 1 90 1 90 gf180mcu_fd_io__fill10
* cell instance $15 r0 *1 509.26,0
X$15 276 266 87 1 90 1 90 gf180mcu_fd_io__fill10
* cell instance $16 r0 *1 519.26,0
X$16 276 87 66 1 90 1 90 gf180mcu_fd_io__fill5
* cell instance $17 r0 *1 524.26,0
X$17 1 90 1 90 276 66 66 gf180mcu_fd_io__fill1
* cell instance $18 r0 *1 525.26,0
X$18 1 90 1 90 276 66 66 gf180mcu_fd_io__fill1
* cell instance $19 r0 *1 526.26,0
X$19 1 90 1 90 276 66 66 gf180mcu_fd_io__fill1
* cell instance $20 r0 *1 527.26,0
X$20 1 90 1 90 276 66 66 gf180mcu_fd_io__fill1
* cell instance $21 r0 *1 528.26,0
X$21 1 90 1 90 276 66 66 1 1 1 gf180mcu_fd_io__fillnc
* cell instance $22 r0 *1 528.36,0
X$22 1 90 1 90 268 268 66 66 276 gf180mcu_fd_io__asig_5p0
* cell instance $23 r0 *1 603.36,0
X$23 276 268 269 1 90 1 90 gf180mcu_fd_io__fill10
* cell instance $24 r0 *1 613.36,0
X$24 276 269 270 1 90 1 90 gf180mcu_fd_io__fill10
* cell instance $25 r0 *1 623.36,0
X$25 276 270 271 1 90 1 90 gf180mcu_fd_io__fill10
* cell instance $26 r0 *1 633.36,0
X$26 276 271 81 1 90 1 90 gf180mcu_fd_io__fill10
* cell instance $27 r0 *1 643.36,0
X$27 276 81 65 1 90 1 90 gf180mcu_fd_io__fill5
* cell instance $28 r0 *1 648.36,0
X$28 1 90 1 90 276 65 65 gf180mcu_fd_io__fill1
* cell instance $29 r0 *1 649.36,0
X$29 1 90 1 90 276 65 65 gf180mcu_fd_io__fill1
* cell instance $30 r0 *1 650.36,0
X$30 1 90 1 90 276 65 65 gf180mcu_fd_io__fill1
* cell instance $31 r0 *1 651.36,0
X$31 1 90 1 90 276 65 65 gf180mcu_fd_io__fill1
* cell instance $32 r0 *1 652.36,0
X$32 1 90 1 90 276 65 65 1 1 1 gf180mcu_fd_io__fillnc
* cell instance $33 r0 *1 652.46,0
X$33 1 90 1 90 272 272 65 65 276 gf180mcu_fd_io__asig_5p0
* cell instance $34 r0 *1 727.46,0
X$34 276 272 274 1 90 1 90 gf180mcu_fd_io__fill10
* cell instance $35 r0 *1 737.46,0
X$35 276 274 263 1 90 1 90 gf180mcu_fd_io__fill10
* cell instance $36 r0 *1 747.46,0
X$36 276 263 233 1 90 1 90 gf180mcu_fd_io__fill10
* cell instance $37 r0 *1 757.46,0
X$37 276 233 79 1 90 1 90 gf180mcu_fd_io__fill10
* cell instance $38 r0 *1 767.46,0
X$38 276 79 62 1 90 1 90 gf180mcu_fd_io__fill5
* cell instance $39 r0 *1 772.46,0
X$39 1 90 1 90 276 62 62 gf180mcu_fd_io__fill1
* cell instance $40 r0 *1 773.46,0
X$40 1 90 1 90 276 62 62 gf180mcu_fd_io__fill1
* cell instance $41 r0 *1 774.46,0
X$41 1 90 1 90 276 62 62 gf180mcu_fd_io__fill1
* cell instance $42 r0 *1 775.46,0
X$42 1 90 1 90 276 62 62 gf180mcu_fd_io__fill1
* cell instance $43 r0 *1 776.46,0
X$43 1 90 1 90 276 62 62 1 1 1 gf180mcu_fd_io__fillnc
* cell instance $44 r0 *1 776.56,0
X$44 1 90 1 90 253 253 62 62 276 gf180mcu_fd_io__asig_5p0
* cell instance $45 r0 *1 851.56,0
X$45 276 253 255 1 90 1 90 gf180mcu_fd_io__fill10
* cell instance $46 r0 *1 861.56,0
X$46 276 255 256 1 90 1 90 gf180mcu_fd_io__fill10
* cell instance $47 r0 *1 871.56,0
X$47 276 256 257 1 90 1 90 gf180mcu_fd_io__fill10
* cell instance $48 r0 *1 881.56,0
X$48 276 257 84 1 90 1 90 gf180mcu_fd_io__fill10
* cell instance $49 r0 *1 891.56,0
X$49 276 84 61 1 90 1 90 gf180mcu_fd_io__fill5
* cell instance $50 r0 *1 896.56,0
X$50 1 90 1 90 276 61 61 gf180mcu_fd_io__fill1
* cell instance $51 r0 *1 897.56,0
X$51 1 90 1 90 276 61 61 gf180mcu_fd_io__fill1
* cell instance $52 r0 *1 898.56,0
X$52 1 90 1 90 276 61 61 gf180mcu_fd_io__fill1
* cell instance $53 r0 *1 899.56,0
X$53 1 90 1 90 276 61 61 gf180mcu_fd_io__fill1
* cell instance $54 r0 *1 900.56,0
X$54 1 90 1 90 276 61 61 1 1 1 gf180mcu_fd_io__fillnc
* cell instance $55 r0 *1 900.66,0
X$55 90 1 1 2 260 260 61 61 276 gf180mcu_fd_io__dvdd
* cell instance $56 r0 *1 975.66,0
X$56 276 260 261 1 90 1 90 gf180mcu_fd_io__fill10
* cell instance $57 r0 *1 985.66,0
X$57 276 261 252 1 90 1 90 gf180mcu_fd_io__fill10
* cell instance $58 r0 *1 995.66,0
X$58 276 252 262 1 90 1 90 gf180mcu_fd_io__fill10
* cell instance $59 r0 *1 1005.66,0
X$59 276 262 80 1 90 1 90 gf180mcu_fd_io__fill10
* cell instance $60 r0 *1 1015.66,0
X$60 276 80 69 1 90 1 90 gf180mcu_fd_io__fill5
* cell instance $61 r0 *1 1020.66,0
X$61 1 90 1 90 276 69 69 gf180mcu_fd_io__fill1
* cell instance $62 r0 *1 1021.66,0
X$62 1 90 1 90 276 69 69 gf180mcu_fd_io__fill1
* cell instance $63 r0 *1 1022.66,0
X$63 1 90 1 90 276 69 69 gf180mcu_fd_io__fill1
* cell instance $64 r0 *1 1023.66,0
X$64 1 90 1 90 276 69 69 gf180mcu_fd_io__fill1
* cell instance $65 r0 *1 1024.66,0
X$65 1 90 1 90 276 69 69 1 1 1 gf180mcu_fd_io__fillnc
* cell instance $66 r0 *1 0,0
X$66 6 5 4 1 2 3 gf180mcu_fd_io__cor
* cell instance $67 r0 *1 1024.76,0
X$67 1 90 90 2 267 267 69 69 276 gf180mcu_fd_io__dvss
* cell instance $68 r0 *1 1099.76,0
X$68 276 267 259 1 90 1 90 gf180mcu_fd_io__fill10
* cell instance $69 r0 *1 1109.76,0
X$69 276 259 258 1 90 1 90 gf180mcu_fd_io__fill10
* cell instance $70 r0 *1 1119.76,0
X$70 276 258 265 1 90 1 90 gf180mcu_fd_io__fill10
* cell instance $71 r0 *1 1129.76,0
X$71 276 265 82 1 90 1 90 gf180mcu_fd_io__fill10
* cell instance $72 r0 *1 1139.76,0
X$72 276 82 70 1 90 1 90 gf180mcu_fd_io__fill5
* cell instance $73 r0 *1 1144.76,0
X$73 1 90 1 90 276 70 70 gf180mcu_fd_io__fill1
* cell instance $74 r0 *1 1145.76,0
X$74 1 90 1 90 276 70 70 gf180mcu_fd_io__fill1
* cell instance $75 r0 *1 1146.76,0
X$75 1 90 1 90 276 70 70 gf180mcu_fd_io__fill1
* cell instance $76 r0 *1 1147.76,0
X$76 1 90 1 90 276 70 70 gf180mcu_fd_io__fill1
* cell instance $77 r0 *1 1148.76,0
X$77 1 90 1 90 276 70 70 1 1 1 gf180mcu_fd_io__fillnc
* cell instance $78 r0 *1 1148.86,0
X$78 1 90 1 90 239 239 70 70 276 gf180mcu_fd_io__asig_5p0
* cell instance $79 r0 *1 1223.86,0
X$79 276 239 240 1 90 1 90 gf180mcu_fd_io__fill10
* cell instance $80 r0 *1 1233.86,0
X$80 276 240 241 1 90 1 90 gf180mcu_fd_io__fill10
* cell instance $81 r0 *1 1243.86,0
X$81 276 241 242 1 90 1 90 gf180mcu_fd_io__fill10
* cell instance $82 r0 *1 1253.86,0
X$82 276 242 85 1 90 1 90 gf180mcu_fd_io__fill10
* cell instance $83 r0 *1 1263.86,0
X$83 276 85 68 1 90 1 90 gf180mcu_fd_io__fill5
* cell instance $84 r0 *1 1268.86,0
X$84 1 90 1 90 276 68 68 gf180mcu_fd_io__fill1
* cell instance $85 r0 *1 1269.86,0
X$85 1 90 1 90 276 68 68 gf180mcu_fd_io__fill1
* cell instance $86 r0 *1 1270.86,0
X$86 1 90 1 90 276 68 68 gf180mcu_fd_io__fill1
* cell instance $87 r0 *1 1271.86,0
X$87 1 90 1 90 276 68 68 gf180mcu_fd_io__fill1
* cell instance $88 r0 *1 1272.86,0
X$88 1 90 1 90 276 68 68 1 1 1 gf180mcu_fd_io__fillnc
* cell instance $89 r0 *1 1272.96,0
X$89 1 90 1 90 244 244 68 68 276 gf180mcu_fd_io__asig_5p0
* cell instance $90 r0 *1 1347.96,0
X$90 276 244 245 1 90 1 90 gf180mcu_fd_io__fill10
* cell instance $91 r0 *1 1357.96,0
X$91 276 245 246 1 90 1 90 gf180mcu_fd_io__fill10
* cell instance $92 r0 *1 1367.96,0
X$92 276 246 247 1 90 1 90 gf180mcu_fd_io__fill10
* cell instance $93 r0 *1 1377.96,0
X$93 276 247 86 1 90 1 90 gf180mcu_fd_io__fill10
* cell instance $94 r0 *1 1387.96,0
X$94 276 86 63 1 90 1 90 gf180mcu_fd_io__fill5
* cell instance $95 r0 *1 1392.96,0
X$95 1 90 1 90 276 63 63 gf180mcu_fd_io__fill1
* cell instance $96 r0 *1 1393.96,0
X$96 1 90 1 90 276 63 63 gf180mcu_fd_io__fill1
* cell instance $97 r0 *1 1394.96,0
X$97 1 90 1 90 276 63 63 gf180mcu_fd_io__fill1
* cell instance $98 r0 *1 1395.96,0
X$98 1 90 1 90 276 63 63 gf180mcu_fd_io__fill1
* cell instance $99 r0 *1 1396.96,0
X$99 1 90 1 90 276 63 63 1 1 1 gf180mcu_fd_io__fillnc
* cell instance $100 r0 *1 1397.06,0
X$100 1 90 1 90 251 251 63 63 276 gf180mcu_fd_io__asig_5p0
* cell instance $101 r0 *1 1472.06,0
X$101 276 251 248 1 90 1 90 gf180mcu_fd_io__fill10
* cell instance $102 r0 *1 1482.06,0
X$102 276 248 235 1 90 1 90 gf180mcu_fd_io__fill10
* cell instance $103 r0 *1 1492.06,0
X$103 276 235 254 1 90 1 90 gf180mcu_fd_io__fill10
* cell instance $104 r0 *1 1502.06,0
X$104 276 254 83 1 90 1 90 gf180mcu_fd_io__fill10
* cell instance $105 r0 *1 1512.06,0
X$105 276 83 64 1 90 1 90 gf180mcu_fd_io__fill5
* cell instance $106 r0 *1 1517.06,0
X$106 1 90 1 90 276 64 64 gf180mcu_fd_io__fill1
* cell instance $107 r0 *1 1518.06,0
X$107 1 90 1 90 276 64 64 gf180mcu_fd_io__fill1
* cell instance $108 r0 *1 1519.06,0
X$108 1 90 1 90 276 64 64 gf180mcu_fd_io__fill1
* cell instance $109 r0 *1 1520.06,0
X$109 1 90 1 90 276 64 64 gf180mcu_fd_io__fill1
* cell instance $110 r0 *1 1521.06,0
X$110 1 90 1 90 276 64 64 1 1 1 gf180mcu_fd_io__fillnc
* cell instance $111 r0 *1 1521.16,0
X$111 1 90 1 90 264 264 64 64 276 gf180mcu_fd_io__asig_5p0
* cell instance $112 r0 *1 1596.16,0
X$112 276 264 275 1 90 1 90 gf180mcu_fd_io__fill10
* cell instance $113 r0 *1 1606.16,0
X$113 276 275 250 1 90 1 90 gf180mcu_fd_io__fill10
* cell instance $114 r0 *1 1616.16,0
X$114 276 250 249 1 90 1 90 gf180mcu_fd_io__fill10
* cell instance $115 r0 *1 1626.16,0
X$115 276 249 88 1 90 1 90 gf180mcu_fd_io__fill10
* cell instance $116 r0 *1 1636.16,0
X$116 276 88 67 1 90 1 90 gf180mcu_fd_io__fill5
* cell instance $117 r0 *1 1641.16,0
X$117 1 90 1 90 276 67 67 gf180mcu_fd_io__fill1
* cell instance $118 r0 *1 1642.16,0
X$118 1 90 1 90 276 67 67 gf180mcu_fd_io__fill1
* cell instance $119 r0 *1 1643.16,0
X$119 1 90 1 90 276 67 67 gf180mcu_fd_io__fill1
* cell instance $120 r0 *1 1644.16,0
X$120 1 90 1 90 276 67 67 gf180mcu_fd_io__fill1
* cell instance $121 r90 *1 2000.16,0
X$121 1 90 90 1 2 276 gf180mcu_fd_io__cor
* cell instance $122 r270 *1 0,404.26
X$122 1 12 1 12 71 8 8 1 1 1 gf180mcu_fd_io__fillnc
* cell instance $123 r270 *1 0,479.26
X$123 1 12 1 12 8 8 105 105 71 gf180mcu_fd_io__asig_5p0
* cell instance $124 r270 *1 0,489.26
X$124 71 103 105 1 12 1 12 gf180mcu_fd_io__fill10
* cell instance $125 r270 *1 0,499.26
X$125 71 94 103 1 12 1 12 gf180mcu_fd_io__fill10
* cell instance $126 r270 *1 0,509.26
X$126 71 192 94 1 12 1 12 gf180mcu_fd_io__fill10
* cell instance $127 r270 *1 0,519.26
X$127 71 17 192 1 12 1 12 gf180mcu_fd_io__fill10
* cell instance $128 r270 *1 0,524.26
X$128 71 41 17 1 12 1 12 gf180mcu_fd_io__fill5
* cell instance $129 r270 *1 0,525.26
X$129 1 12 1 12 71 41 41 gf180mcu_fd_io__fill1
* cell instance $130 r270 *1 0,526.26
X$130 1 12 1 12 71 41 41 gf180mcu_fd_io__fill1
* cell instance $131 r270 *1 0,527.26
X$131 1 12 1 12 71 41 41 gf180mcu_fd_io__fill1
* cell instance $132 r270 *1 0,404.16
X$132 1 12 1 12 71 8 8 gf180mcu_fd_io__fill1
* cell instance $133 r270 *1 0,403.16
X$133 1 12 1 12 71 8 8 gf180mcu_fd_io__fill1
* cell instance $134 r270 *1 0,402.16
X$134 1 12 1 12 71 8 8 gf180mcu_fd_io__fill1
* cell instance $135 r270 *1 0,401.16
X$135 1 12 1 12 71 8 8 gf180mcu_fd_io__fill1
* cell instance $136 r270 *1 0,400.16
X$136 71 8 193 1 12 1 12 gf180mcu_fd_io__fill5
* cell instance $137 r270 *1 0,395.16
X$137 71 193 198 1 12 1 12 gf180mcu_fd_io__fill10
* cell instance $138 r270 *1 0,385.16
X$138 71 198 204 1 12 1 12 gf180mcu_fd_io__fill10
* cell instance $139 r270 *1 0,375.16
X$139 71 204 199 1 12 1 12 gf180mcu_fd_io__fill10
* cell instance $140 r270 *1 0,365.16
X$140 71 199 98 1 12 1 12 gf180mcu_fd_io__fill10
* cell instance $141 r270 *1 0,528.36
X$141 1 12 1 12 71 41 41 1 1 1 gf180mcu_fd_io__fillnc
* cell instance $142 r270 *1 0,603.36
X$142 1 12 1 12 41 41 97 97 71 gf180mcu_fd_io__asig_5p0
* cell instance $143 r270 *1 0,528.26
X$143 1 12 1 12 71 41 41 gf180mcu_fd_io__fill1
* cell instance $144 r270 *1 0,613.36
X$144 71 194 97 1 12 1 12 gf180mcu_fd_io__fill10
* cell instance $145 r270 *1 0,776.46
X$145 1 12 1 12 71 39 39 gf180mcu_fd_io__fill1
* cell instance $146 r270 *1 0,851.56
X$146 1 12 1 12 39 39 106 106 71 gf180mcu_fd_io__asig_5p0
* cell instance $147 r270 *1 0,775.46
X$147 1 12 1 12 71 39 39 gf180mcu_fd_io__fill1
* cell instance $148 r270 *1 0,774.46
X$148 1 12 1 12 71 39 39 gf180mcu_fd_io__fill1
* cell instance $149 r270 *1 0,776.56
X$149 1 12 1 12 71 39 39 1 1 1 gf180mcu_fd_io__fillnc
* cell instance $150 r270 *1 0,773.46
X$150 1 12 1 12 71 39 39 gf180mcu_fd_io__fill1
* cell instance $151 r270 *1 0,772.46
X$151 71 39 203 1 12 1 12 gf180mcu_fd_io__fill5
* cell instance $152 r270 *1 0,767.46
X$152 71 203 202 1 12 1 12 gf180mcu_fd_io__fill10
* cell instance $153 r270 *1 0,861.56
X$153 71 107 106 1 12 1 12 gf180mcu_fd_io__fill10
* cell instance $154 r270 *1 0,757.46
X$154 71 202 201 1 12 1 12 gf180mcu_fd_io__fill10
* cell instance $155 r270 *1 0,747.46
X$155 71 201 200 1 12 1 12 gf180mcu_fd_io__fill10
* cell instance $156 r270 *1 0,871.56
X$156 71 102 107 1 12 1 12 gf180mcu_fd_io__fill10
* cell instance $157 r270 *1 0,652.36
X$157 1 12 1 12 71 7 7 gf180mcu_fd_io__fill1
* cell instance $158 r270 *1 0,727.46
X$158 1 12 1 12 7 7 100 100 71 gf180mcu_fd_io__asig_5p0
* cell instance $159 r270 *1 0,737.46
X$159 71 200 100 1 12 1 12 gf180mcu_fd_io__fill10
* cell instance $160 r270 *1 0,652.46
X$160 1 12 1 12 71 7 7 1 1 1 gf180mcu_fd_io__fillnc
* cell instance $161 r270 *1 0,881.56
X$161 71 99 102 1 12 1 12 gf180mcu_fd_io__fill10
* cell instance $162 r270 *1 0,651.36
X$162 1 12 1 12 71 7 7 gf180mcu_fd_io__fill1
* cell instance $163 r270 *1 0,891.56
X$163 71 19 99 1 12 1 12 gf180mcu_fd_io__fill10
* cell instance $164 r270 *1 0,650.36
X$164 1 12 1 12 71 7 7 gf180mcu_fd_io__fill1
* cell instance $165 r270 *1 0,649.36
X$165 1 12 1 12 71 7 7 gf180mcu_fd_io__fill1
* cell instance $166 r270 *1 0,896.56
X$166 71 38 19 1 12 1 12 gf180mcu_fd_io__fill5
* cell instance $167 r270 *1 0,648.36
X$167 71 7 197 1 12 1 12 gf180mcu_fd_io__fill5
* cell instance $168 r270 *1 0,643.36
X$168 71 197 196 1 12 1 12 gf180mcu_fd_io__fill10
* cell instance $169 r270 *1 0,897.56
X$169 1 12 1 12 71 38 38 gf180mcu_fd_io__fill1
* cell instance $170 r270 *1 0,633.36
X$170 71 196 195 1 12 1 12 gf180mcu_fd_io__fill10
* cell instance $171 r270 *1 0,898.56
X$171 1 12 1 12 71 38 38 gf180mcu_fd_io__fill1
* cell instance $172 r270 *1 0,623.36
X$172 71 195 194 1 12 1 12 gf180mcu_fd_io__fill10
* cell instance $173 r270 *1 0,985.66
X$173 71 96 95 1 12 1 12 gf180mcu_fd_io__fill10
* cell instance $174 r270 *1 0,975.66
X$174 12 1 1 2 38 38 95 95 71 gf180mcu_fd_io__dvdd
* cell instance $175 r270 *1 0,995.66
X$175 71 104 96 1 12 1 12 gf180mcu_fd_io__fill10
* cell instance $176 r270 *1 0,900.66
X$176 1 12 1 12 71 38 38 1 1 1 gf180mcu_fd_io__fillnc
* cell instance $177 r270 *1 0,900.56
X$177 1 12 1 12 71 38 38 gf180mcu_fd_io__fill1
* cell instance $178 r270 *1 0,1005.66
X$178 71 93 104 1 12 1 12 gf180mcu_fd_io__fill10
* cell instance $179 r270 *1 0,1015.66
X$179 71 21 93 1 12 1 12 gf180mcu_fd_io__fill10
* cell instance $180 r270 *1 0,1020.66
X$180 71 42 21 1 12 1 12 gf180mcu_fd_io__fill5
* cell instance $181 r270 *1 0,1021.66
X$181 1 12 1 12 71 42 42 gf180mcu_fd_io__fill1
* cell instance $182 r270 *1 0,899.56
X$182 1 12 1 12 71 38 38 gf180mcu_fd_io__fill1
* cell instance $183 r90 *1 2000,355.16
X$183 89 228 189 1 72 1 72 gf180mcu_fd_io__fill10
* cell instance $184 r90 *1 2000,527.26
X$184 1 72 1 72 89 59 59 gf180mcu_fd_io__fill1
* cell instance $185 r90 *1 2000,528.36
X$185 1 72 1 72 216 216 59 59 89 gf180mcu_fd_io__asig_5p0
* cell instance $186 r90 *1 2000,526.26
X$186 1 72 1 72 89 59 59 gf180mcu_fd_io__fill1
* cell instance $187 r90 *1 2000,525.26
X$187 1 72 1 72 89 59 59 gf180mcu_fd_io__fill1
* cell instance $188 r90 *1 2000,524.26
X$188 1 72 1 72 89 59 59 gf180mcu_fd_io__fill1
* cell instance $189 r90 *1 2000,519.26
X$189 89 177 59 1 72 1 72 gf180mcu_fd_io__fill5
* cell instance $190 r90 *1 2000,509.26
X$190 89 180 177 1 72 1 72 gf180mcu_fd_io__fill10
* cell instance $191 r90 *1 2000,499.26
X$191 89 186 180 1 72 1 72 gf180mcu_fd_io__fill10
* cell instance $192 r90 *1 2000,489.26
X$192 89 187 186 1 72 1 72 gf180mcu_fd_io__fill10
* cell instance $193 r90 *1 2000,404.16
X$193 1 72 1 72 89 10 10 1 1 1 gf180mcu_fd_io__fillnc
* cell instance $194 r90 *1 2000,404.26
X$194 1 72 1 72 227 227 10 10 89 gf180mcu_fd_io__asig_5p0
* cell instance $195 r90 *1 2000,479.26
X$195 89 227 187 1 72 1 72 gf180mcu_fd_io__fill10
* cell instance $196 r90 *1 2000,528.26
X$196 1 72 1 72 89 59 59 1 1 1 gf180mcu_fd_io__fillnc
* cell instance $197 r90 *1 2000,403.16
X$197 1 72 1 72 89 10 10 gf180mcu_fd_io__fill1
* cell instance $198 r90 *1 2000,402.16
X$198 1 72 1 72 89 10 10 gf180mcu_fd_io__fill1
* cell instance $199 r90 *1 2000,401.16
X$199 1 72 1 72 89 10 10 gf180mcu_fd_io__fill1
* cell instance $200 r90 *1 2000,400.16
X$200 1 72 1 72 89 10 10 gf180mcu_fd_io__fill1
* cell instance $201 r90 *1 2000,395.16
X$201 89 184 10 1 72 1 72 gf180mcu_fd_io__fill5
* cell instance $202 r90 *1 2000,385.16
X$202 89 185 184 1 72 1 72 gf180mcu_fd_io__fill10
* cell instance $203 r90 *1 2000,375.16
X$203 89 188 185 1 72 1 72 gf180mcu_fd_io__fill10
* cell instance $204 r90 *1 2000,365.16
X$204 89 189 188 1 72 1 72 gf180mcu_fd_io__fill10
* cell instance $205 r90 *1 2000,603.36
X$205 89 216 181 1 72 1 72 gf180mcu_fd_io__fill10
* cell instance $206 r90 *1 2000,1015.66
X$206 89 190 33 1 72 1 72 gf180mcu_fd_io__fill5
* cell instance $207 r90 *1 2000,1020.66
X$207 1 72 1 72 89 33 33 gf180mcu_fd_io__fill1
* cell instance $208 r90 *1 2000,1005.66
X$208 89 171 190 1 72 1 72 gf180mcu_fd_io__fill10
* cell instance $209 r90 *1 2000,995.66
X$209 89 183 171 1 72 1 72 gf180mcu_fd_io__fill10
* cell instance $210 r90 *1 2000,985.66
X$210 89 172 183 1 72 1 72 gf180mcu_fd_io__fill10
* cell instance $211 r90 *1 2000,975.66
X$211 89 212 172 1 72 1 72 gf180mcu_fd_io__fill10
* cell instance $212 r90 *1 2000,900.66
X$212 72 1 1 2 212 212 11 11 89 gf180mcu_fd_io__dvdd
* cell instance $213 r90 *1 2000,900.56
X$213 1 72 1 72 89 11 11 1 1 1 gf180mcu_fd_io__fillnc
* cell instance $214 r90 *1 2000,899.56
X$214 1 72 1 72 89 11 11 gf180mcu_fd_io__fill1
* cell instance $215 r90 *1 2000,898.56
X$215 1 72 1 72 89 11 11 gf180mcu_fd_io__fill1
* cell instance $216 r90 *1 2000,897.56
X$216 1 72 1 72 89 11 11 gf180mcu_fd_io__fill1
* cell instance $217 r90 *1 2000,896.56
X$217 1 72 1 72 89 11 11 gf180mcu_fd_io__fill1
* cell instance $218 r90 *1 2000,891.56
X$218 89 78 11 1 72 1 72 gf180mcu_fd_io__fill5
* cell instance $219 r90 *1 2000,881.56
X$219 89 170 78 1 72 1 72 gf180mcu_fd_io__fill10
* cell instance $220 r90 *1 2000,871.56
X$220 89 205 170 1 72 1 72 gf180mcu_fd_io__fill10
* cell instance $221 r90 *1 2000,776.46
X$221 1 72 1 72 89 60 60 1 1 1 gf180mcu_fd_io__fillnc
* cell instance $222 r90 *1 2000,776.56
X$222 1 72 1 72 208 208 60 60 89 gf180mcu_fd_io__asig_5p0
* cell instance $223 r90 *1 2000,851.56
X$223 89 208 206 1 72 1 72 gf180mcu_fd_io__fill10
* cell instance $224 r90 *1 2000,861.56
X$224 89 206 205 1 72 1 72 gf180mcu_fd_io__fill10
* cell instance $225 r90 *1 2000,775.46
X$225 1 72 1 72 89 60 60 gf180mcu_fd_io__fill1
* cell instance $226 r90 *1 2000,773.46
X$226 1 72 1 72 89 60 60 gf180mcu_fd_io__fill1
* cell instance $227 r90 *1 2000,774.46
X$227 1 72 1 72 89 60 60 gf180mcu_fd_io__fill1
* cell instance $228 r90 *1 2000,772.46
X$228 1 72 1 72 89 60 60 gf180mcu_fd_io__fill1
* cell instance $229 r90 *1 2000,767.46
X$229 89 173 60 1 72 1 72 gf180mcu_fd_io__fill5
* cell instance $230 r90 *1 2000,757.46
X$230 89 174 173 1 72 1 72 gf180mcu_fd_io__fill10
* cell instance $231 r90 *1 2000,747.46
X$231 89 175 174 1 72 1 72 gf180mcu_fd_io__fill10
* cell instance $232 r90 *1 2000,737.46
X$232 89 176 175 1 72 1 72 gf180mcu_fd_io__fill10
* cell instance $233 r90 *1 2000,651.36
X$233 1 72 1 72 89 9 9 gf180mcu_fd_io__fill1
* cell instance $234 r90 *1 2000,652.46
X$234 1 72 1 72 213 213 9 9 89 gf180mcu_fd_io__asig_5p0
* cell instance $235 r90 *1 2000,727.46
X$235 89 213 176 1 72 1 72 gf180mcu_fd_io__fill10
* cell instance $236 r90 *1 2000,652.36
X$236 1 72 1 72 89 9 9 1 1 1 gf180mcu_fd_io__fillnc
* cell instance $237 r90 *1 2000,650.36
X$237 1 72 1 72 89 9 9 gf180mcu_fd_io__fill1
* cell instance $238 r90 *1 2000,649.36
X$238 1 72 1 72 89 9 9 gf180mcu_fd_io__fill1
* cell instance $239 r90 *1 2000,648.36
X$239 1 72 1 72 89 9 9 gf180mcu_fd_io__fill1
* cell instance $240 r90 *1 2000,643.36
X$240 89 178 9 1 72 1 72 gf180mcu_fd_io__fill5
* cell instance $241 r90 *1 2000,633.36
X$241 89 179 178 1 72 1 72 gf180mcu_fd_io__fill10
* cell instance $242 r90 *1 2000,623.36
X$242 89 182 179 1 72 1 72 gf180mcu_fd_io__fill10
* cell instance $243 r90 *1 2000,613.36
X$243 89 181 182 1 72 1 72 gf180mcu_fd_io__fill10
* cell instance $244 r270 *1 0,1022.66
X$244 1 12 1 12 71 42 42 gf180mcu_fd_io__fill1
* cell instance $245 r270 *1 0,1023.66
X$245 1 12 1 12 71 42 42 gf180mcu_fd_io__fill1
* cell instance $246 r90 *1 2000,1021.66
X$246 1 72 1 72 89 33 33 gf180mcu_fd_io__fill1
* cell instance $247 r90 *1 2000,1022.66
X$247 1 72 1 72 89 33 33 gf180mcu_fd_io__fill1
* cell instance $248 r270 *1 0,1024.66
X$248 1 12 1 12 71 42 42 gf180mcu_fd_io__fill1
* cell instance $249 r270 *1 0,1024.76
X$249 1 12 1 12 71 42 42 1 1 1 gf180mcu_fd_io__fillnc
* cell instance $250 r90 *1 2000,1023.66
X$250 1 72 1 72 89 33 33 gf180mcu_fd_io__fill1
* cell instance $251 r90 *1 2000,1024.66
X$251 1 72 1 72 89 33 33 1 1 1 gf180mcu_fd_io__fillnc
* cell instance $252 r270 *1 0,1099.76
X$252 1 12 12 2 42 42 110 110 71 gf180mcu_fd_io__dvss
* cell instance $253 r270 *1 0,1109.76
X$253 71 111 110 1 12 1 12 gf180mcu_fd_io__fill10
* cell instance $254 r90 *1 2000,1024.76
X$254 1 72 72 2 226 226 33 33 89 gf180mcu_fd_io__dvss
* cell instance $255 r90 *1 2000,1099.76
X$255 89 226 225 1 72 1 72 gf180mcu_fd_io__fill10
* cell instance $256 r270 *1 0,1119.76
X$256 71 112 111 1 12 1 12 gf180mcu_fd_io__fill10
* cell instance $257 r270 *1 0,1129.76
X$257 71 113 112 1 12 1 12 gf180mcu_fd_io__fill10
* cell instance $258 r90 *1 2000,1109.76
X$258 89 225 224 1 72 1 72 gf180mcu_fd_io__fill10
* cell instance $259 r90 *1 2000,1119.76
X$259 89 224 231 1 72 1 72 gf180mcu_fd_io__fill10
* cell instance $260 r270 *1 0,1139.76
X$260 71 16 113 1 12 1 12 gf180mcu_fd_io__fill10
* cell instance $261 r270 *1 0,1144.76
X$261 71 36 16 1 12 1 12 gf180mcu_fd_io__fill5
* cell instance $262 r90 *1 2000,1129.76
X$262 89 231 73 1 72 1 72 gf180mcu_fd_io__fill10
* cell instance $263 r90 *1 2000,1139.76
X$263 89 73 55 1 72 1 72 gf180mcu_fd_io__fill5
* cell instance $264 r270 *1 0,1145.76
X$264 1 12 1 12 71 36 36 gf180mcu_fd_io__fill1
* cell instance $265 r270 *1 0,1146.76
X$265 1 12 1 12 71 36 36 gf180mcu_fd_io__fill1
* cell instance $266 r90 *1 2000,1144.76
X$266 1 72 1 72 89 55 55 gf180mcu_fd_io__fill1
* cell instance $267 r90 *1 2000,1145.76
X$267 1 72 1 72 89 55 55 gf180mcu_fd_io__fill1
* cell instance $268 r270 *1 0,1147.76
X$268 1 12 1 12 71 36 36 gf180mcu_fd_io__fill1
* cell instance $269 r270 *1 0,1148.76
X$269 1 12 1 12 71 36 36 gf180mcu_fd_io__fill1
* cell instance $270 r90 *1 2000,1146.76
X$270 1 72 1 72 89 55 55 gf180mcu_fd_io__fill1
* cell instance $271 r90 *1 2000,1147.76
X$271 1 72 1 72 89 55 55 gf180mcu_fd_io__fill1
* cell instance $272 r270 *1 0,1223.86
X$272 1 12 1 12 36 36 114 114 71 gf180mcu_fd_io__asig_5p0
* cell instance $273 r270 *1 0,1148.86
X$273 1 12 1 12 71 36 36 1 1 1 gf180mcu_fd_io__fillnc
* cell instance $274 r90 *1 2000,1148.86
X$274 1 72 1 72 232 232 55 55 89 gf180mcu_fd_io__asig_5p0
* cell instance $275 r90 *1 2000,1148.76
X$275 1 72 1 72 89 55 55 1 1 1 gf180mcu_fd_io__fillnc
* cell instance $276 r270 *1 0,1233.86
X$276 71 115 114 1 12 1 12 gf180mcu_fd_io__fill10
* cell instance $277 r270 *1 0,1243.86
X$277 71 117 115 1 12 1 12 gf180mcu_fd_io__fill10
* cell instance $278 r270 *1 0,1253.86
X$278 71 118 117 1 12 1 12 gf180mcu_fd_io__fill10
* cell instance $279 r90 *1 2000,1223.86
X$279 89 232 217 1 72 1 72 gf180mcu_fd_io__fill10
* cell instance $280 r90 *1 2000,1233.86
X$280 89 217 218 1 72 1 72 gf180mcu_fd_io__fill10
* cell instance $281 r90 *1 2000,1243.86
X$281 89 218 219 1 72 1 72 gf180mcu_fd_io__fill10
* cell instance $282 r270 *1 0,1263.86
X$282 71 20 118 1 12 1 12 gf180mcu_fd_io__fill10
* cell instance $283 r270 *1 0,1268.86
X$283 71 35 20 1 12 1 12 gf180mcu_fd_io__fill5
* cell instance $284 r90 *1 2000,1253.86
X$284 89 219 77 1 72 1 72 gf180mcu_fd_io__fill10
* cell instance $285 r90 *1 2000,1263.86
X$285 89 77 56 1 72 1 72 gf180mcu_fd_io__fill5
* cell instance $286 r270 *1 0,1269.86
X$286 1 12 1 12 71 35 35 gf180mcu_fd_io__fill1
* cell instance $287 r270 *1 0,1270.86
X$287 1 12 1 12 71 35 35 gf180mcu_fd_io__fill1
* cell instance $288 r90 *1 2000,1268.86
X$288 1 72 1 72 89 56 56 gf180mcu_fd_io__fill1
* cell instance $289 r90 *1 2000,1269.86
X$289 1 72 1 72 89 56 56 gf180mcu_fd_io__fill1
* cell instance $290 r270 *1 0,1271.86
X$290 1 12 1 12 71 35 35 gf180mcu_fd_io__fill1
* cell instance $291 r270 *1 0,1272.86
X$291 1 12 1 12 71 35 35 gf180mcu_fd_io__fill1
* cell instance $292 r90 *1 2000,1270.86
X$292 1 72 1 72 89 56 56 gf180mcu_fd_io__fill1
* cell instance $293 r90 *1 2000,1271.86
X$293 1 72 1 72 89 56 56 gf180mcu_fd_io__fill1
* cell instance $294 r270 *1 0,1347.96
X$294 1 12 1 12 35 35 121 121 71 gf180mcu_fd_io__asig_5p0
* cell instance $295 r270 *1 0,1272.96
X$295 1 12 1 12 71 35 35 1 1 1 gf180mcu_fd_io__fillnc
* cell instance $296 r90 *1 2000,1272.96
X$296 1 72 1 72 220 220 56 56 89 gf180mcu_fd_io__asig_5p0
* cell instance $297 r90 *1 2000,1272.86
X$297 1 72 1 72 89 56 56 1 1 1 gf180mcu_fd_io__fillnc
* cell instance $298 r270 *1 0,1357.96
X$298 71 123 121 1 12 1 12 gf180mcu_fd_io__fill10
* cell instance $299 r270 *1 0,1367.96
X$299 71 124 123 1 12 1 12 gf180mcu_fd_io__fill10
* cell instance $300 r270 *1 0,1377.96
X$300 71 92 124 1 12 1 12 gf180mcu_fd_io__fill10
* cell instance $301 r90 *1 2000,1347.96
X$301 89 220 221 1 72 1 72 gf180mcu_fd_io__fill10
* cell instance $302 r90 *1 2000,1357.96
X$302 89 221 222 1 72 1 72 gf180mcu_fd_io__fill10
* cell instance $303 r90 *1 2000,1367.96
X$303 89 222 223 1 72 1 72 gf180mcu_fd_io__fill10
* cell instance $304 r270 *1 0,1387.96
X$304 71 14 92 1 12 1 12 gf180mcu_fd_io__fill10
* cell instance $305 r270 *1 0,1392.96
X$305 71 34 14 1 12 1 12 gf180mcu_fd_io__fill5
* cell instance $306 r90 *1 2000,1377.96
X$306 89 223 74 1 72 1 72 gf180mcu_fd_io__fill10
* cell instance $307 r90 *1 2000,1387.96
X$307 89 74 54 1 72 1 72 gf180mcu_fd_io__fill5
* cell instance $308 r270 *1 0,1393.96
X$308 1 12 1 12 71 34 34 gf180mcu_fd_io__fill1
* cell instance $309 r270 *1 0,1394.96
X$309 1 12 1 12 71 34 34 gf180mcu_fd_io__fill1
* cell instance $310 r90 *1 2000,1392.96
X$310 1 72 1 72 89 54 54 gf180mcu_fd_io__fill1
* cell instance $311 r90 *1 2000,1393.96
X$311 1 72 1 72 89 54 54 gf180mcu_fd_io__fill1
* cell instance $312 r270 *1 0,1395.96
X$312 1 12 1 12 71 34 34 gf180mcu_fd_io__fill1
* cell instance $313 r270 *1 0,1396.96
X$313 1 12 1 12 71 34 34 gf180mcu_fd_io__fill1
* cell instance $314 r90 *1 2000,1394.96
X$314 1 72 1 72 89 54 54 gf180mcu_fd_io__fill1
* cell instance $315 r90 *1 2000,1395.96
X$315 1 72 1 72 89 54 54 gf180mcu_fd_io__fill1
* cell instance $316 r270 *1 0,1472.06
X$316 1 12 1 12 34 34 108 108 71 gf180mcu_fd_io__asig_5p0
* cell instance $317 r270 *1 0,1397.06
X$317 1 12 1 12 71 34 34 1 1 1 gf180mcu_fd_io__fillnc
* cell instance $318 r90 *1 2000,1397.06
X$318 1 72 1 72 229 229 54 54 89 gf180mcu_fd_io__asig_5p0
* cell instance $319 r90 *1 2000,1396.96
X$319 1 72 1 72 89 54 54 1 1 1 gf180mcu_fd_io__fillnc
* cell instance $320 r270 *1 0,1482.06
X$320 71 109 108 1 12 1 12 gf180mcu_fd_io__fill10
* cell instance $321 r270 *1 0,1492.06
X$321 71 101 109 1 12 1 12 gf180mcu_fd_io__fill10
* cell instance $322 r270 *1 0,1502.06
X$322 71 119 101 1 12 1 12 gf180mcu_fd_io__fill10
* cell instance $323 r90 *1 2000,1472.06
X$323 89 229 230 1 72 1 72 gf180mcu_fd_io__fill10
* cell instance $324 r90 *1 2000,1482.06
X$324 89 230 207 1 72 1 72 gf180mcu_fd_io__fill10
* cell instance $325 r90 *1 2000,1492.06
X$325 89 207 215 1 72 1 72 gf180mcu_fd_io__fill10
* cell instance $326 r270 *1 0,1512.06
X$326 71 18 119 1 12 1 12 gf180mcu_fd_io__fill10
* cell instance $327 r270 *1 0,1517.06
X$327 71 40 18 1 12 1 12 gf180mcu_fd_io__fill5
* cell instance $328 r90 *1 2000,1502.06
X$328 89 215 75 1 72 1 72 gf180mcu_fd_io__fill10
* cell instance $329 r90 *1 2000,1512.06
X$329 89 75 57 1 72 1 72 gf180mcu_fd_io__fill5
* cell instance $330 r270 *1 0,1518.06
X$330 1 12 1 12 71 40 40 gf180mcu_fd_io__fill1
* cell instance $331 r270 *1 0,1519.06
X$331 1 12 1 12 71 40 40 gf180mcu_fd_io__fill1
* cell instance $332 r90 *1 2000,1517.06
X$332 1 72 1 72 89 57 57 gf180mcu_fd_io__fill1
* cell instance $333 r90 *1 2000,1518.06
X$333 1 72 1 72 89 57 57 gf180mcu_fd_io__fill1
* cell instance $334 r270 *1 0,1520.06
X$334 1 12 1 12 71 40 40 gf180mcu_fd_io__fill1
* cell instance $335 r270 *1 0,1521.06
X$335 1 12 1 12 71 40 40 gf180mcu_fd_io__fill1
* cell instance $336 r90 *1 2000,1519.06
X$336 1 72 1 72 89 57 57 gf180mcu_fd_io__fill1
* cell instance $337 r90 *1 2000,1520.06
X$337 1 72 1 72 89 57 57 gf180mcu_fd_io__fill1
* cell instance $338 r270 *1 0,1596.16
X$338 1 12 1 12 40 40 125 125 71 gf180mcu_fd_io__asig_5p0
* cell instance $339 r270 *1 0,1521.16
X$339 1 12 1 12 71 40 40 1 1 1 gf180mcu_fd_io__fillnc
* cell instance $340 r90 *1 2000,1521.16
X$340 1 72 1 72 214 214 57 57 89 gf180mcu_fd_io__asig_5p0
* cell instance $341 r90 *1 2000,1521.06
X$341 1 72 1 72 89 57 57 1 1 1 gf180mcu_fd_io__fillnc
* cell instance $342 r270 *1 0,1606.16
X$342 71 122 125 1 12 1 12 gf180mcu_fd_io__fill10
* cell instance $343 r270 *1 0,1616.16
X$343 71 120 122 1 12 1 12 gf180mcu_fd_io__fill10
* cell instance $344 r270 *1 0,1626.16
X$344 71 116 120 1 12 1 12 gf180mcu_fd_io__fill10
* cell instance $345 r90 *1 2000,1596.16
X$345 89 214 211 1 72 1 72 gf180mcu_fd_io__fill10
* cell instance $346 r90 *1 2000,1606.16
X$346 89 211 210 1 72 1 72 gf180mcu_fd_io__fill10
* cell instance $347 r90 *1 2000,1616.16
X$347 89 210 209 1 72 1 72 gf180mcu_fd_io__fill10
* cell instance $348 r270 *1 0,1636.16
X$348 71 15 116 1 12 1 12 gf180mcu_fd_io__fill10
* cell instance $349 r270 *1 0,1641.16
X$349 71 37 15 1 12 1 12 gf180mcu_fd_io__fill5
* cell instance $350 r90 *1 2000,1626.16
X$350 89 209 76 1 72 1 72 gf180mcu_fd_io__fill10
* cell instance $351 r90 *1 2000,1636.16
X$351 89 76 58 1 72 1 72 gf180mcu_fd_io__fill5
* cell instance $352 r270 *1 0,1642.16
X$352 1 12 1 12 71 37 37 gf180mcu_fd_io__fill1
* cell instance $353 r270 *1 0,1643.16
X$353 1 12 1 12 71 37 37 gf180mcu_fd_io__fill1
* cell instance $354 r90 *1 2000,1641.16
X$354 1 72 1 72 89 58 58 gf180mcu_fd_io__fill1
* cell instance $355 r90 *1 2000,1642.16
X$355 1 72 1 72 89 58 58 gf180mcu_fd_io__fill1
* cell instance $356 r270 *1 0,1644.16
X$356 1 12 1 12 71 37 37 gf180mcu_fd_io__fill1
* cell instance $357 r270 *1 0,1645.16
X$357 1 12 1 12 71 37 37 gf180mcu_fd_io__fill1
* cell instance $358 r90 *1 2000,1643.16
X$358 1 72 1 72 89 58 58 gf180mcu_fd_io__fill1
* cell instance $359 r90 *1 2000,1644.16
X$359 1 72 1 72 89 58 58 gf180mcu_fd_io__fill1
* cell instance $360 r270 *1 0,2000.16
X$360 1 12 12 1 2 71 gf180mcu_fd_io__cor
* cell instance $361 r180 *1 2000.16,2000.16
X$361 1 72 72 1 2 89 gf180mcu_fd_io__cor
* cell instance $362 r180 *1 365.16,2000
X$362 89 166 164 1 72 1 72 gf180mcu_fd_io__fill10
* cell instance $363 r180 *1 375.16,2000
X$363 89 161 166 1 72 1 72 gf180mcu_fd_io__fill10
* cell instance $364 r180 *1 385.16,2000
X$364 89 158 161 1 72 1 72 gf180mcu_fd_io__fill10
* cell instance $365 r180 *1 395.16,2000
X$365 89 24 158 1 72 1 72 gf180mcu_fd_io__fill10
* cell instance $366 r180 *1 400.16,2000
X$366 89 50 24 1 72 1 72 gf180mcu_fd_io__fill5
* cell instance $367 r180 *1 401.16,2000
X$367 1 72 1 72 89 50 50 gf180mcu_fd_io__fill1
* cell instance $368 r180 *1 402.16,2000
X$368 1 72 1 72 89 50 50 gf180mcu_fd_io__fill1
* cell instance $369 r180 *1 403.16,2000
X$369 1 72 1 72 89 50 50 gf180mcu_fd_io__fill1
* cell instance $370 r180 *1 404.16,2000
X$370 1 72 1 72 89 50 50 gf180mcu_fd_io__fill1
* cell instance $371 r180 *1 404.26,2000
X$371 1 72 1 72 89 50 50 1 1 1 gf180mcu_fd_io__fillnc
* cell instance $372 r180 *1 479.26,2000
X$372 1 72 1 72 50 50 162 162 89 gf180mcu_fd_io__asig_5p0
* cell instance $373 r180 *1 489.26,2000
X$373 89 163 162 1 72 1 72 gf180mcu_fd_io__fill10
* cell instance $374 r180 *1 499.26,2000
X$374 89 167 163 1 72 1 72 gf180mcu_fd_io__fill10
* cell instance $375 r180 *1 509.26,2000
X$375 89 169 167 1 72 1 72 gf180mcu_fd_io__fill10
* cell instance $376 r180 *1 519.26,2000
X$376 89 22 169 1 72 1 72 gf180mcu_fd_io__fill10
* cell instance $377 r180 *1 524.26,2000
X$377 89 46 22 1 72 1 72 gf180mcu_fd_io__fill5
* cell instance $378 r180 *1 525.26,2000
X$378 1 72 1 72 89 46 46 gf180mcu_fd_io__fill1
* cell instance $379 r180 *1 526.26,2000
X$379 1 72 1 72 89 46 46 gf180mcu_fd_io__fill1
* cell instance $380 r180 *1 527.26,2000
X$380 1 72 1 72 89 46 46 gf180mcu_fd_io__fill1
* cell instance $381 r180 *1 528.26,2000
X$381 1 72 1 72 89 46 46 gf180mcu_fd_io__fill1
* cell instance $382 r180 *1 528.36,2000
X$382 1 72 1 72 89 46 46 1 1 1 gf180mcu_fd_io__fillnc
* cell instance $383 r180 *1 603.36,2000
X$383 1 72 1 72 46 46 155 155 89 gf180mcu_fd_io__asig_5p0
* cell instance $384 r180 *1 613.36,2000
X$384 89 147 155 1 72 1 72 gf180mcu_fd_io__fill10
* cell instance $385 r180 *1 623.36,2000
X$385 89 148 147 1 72 1 72 gf180mcu_fd_io__fill10
* cell instance $386 r180 *1 633.36,2000
X$386 89 149 148 1 72 1 72 gf180mcu_fd_io__fill10
* cell instance $387 r180 *1 643.36,2000
X$387 89 30 149 1 72 1 72 gf180mcu_fd_io__fill10
* cell instance $388 r180 *1 648.36,2000
X$388 89 45 30 1 72 1 72 gf180mcu_fd_io__fill5
* cell instance $389 r180 *1 649.36,2000
X$389 1 72 1 72 89 45 45 gf180mcu_fd_io__fill1
* cell instance $390 r180 *1 650.36,2000
X$390 1 72 1 72 89 45 45 gf180mcu_fd_io__fill1
* cell instance $391 r180 *1 651.36,2000
X$391 1 72 1 72 89 45 45 gf180mcu_fd_io__fill1
* cell instance $392 r180 *1 652.36,2000
X$392 1 72 1 72 89 45 45 gf180mcu_fd_io__fill1
* cell instance $393 r180 *1 652.46,2000
X$393 1 72 1 72 89 45 45 1 1 1 gf180mcu_fd_io__fillnc
* cell instance $394 r180 *1 727.46,2000
X$394 1 72 1 72 45 45 150 150 89 gf180mcu_fd_io__asig_5p0
* cell instance $395 r180 *1 737.46,2000
X$395 89 151 150 1 72 1 72 gf180mcu_fd_io__fill10
* cell instance $396 r180 *1 747.46,2000
X$396 89 152 151 1 72 1 72 gf180mcu_fd_io__fill10
* cell instance $397 r180 *1 757.46,2000
X$397 89 153 152 1 72 1 72 gf180mcu_fd_io__fill10
* cell instance $398 r180 *1 767.46,2000
X$398 89 32 153 1 72 1 72 gf180mcu_fd_io__fill10
* cell instance $399 r180 *1 772.46,2000
X$399 89 52 32 1 72 1 72 gf180mcu_fd_io__fill5
* cell instance $400 r180 *1 773.46,2000
X$400 1 72 1 72 89 52 52 gf180mcu_fd_io__fill1
* cell instance $401 r180 *1 774.46,2000
X$401 1 72 1 72 89 52 52 gf180mcu_fd_io__fill1
* cell instance $402 r180 *1 775.46,2000
X$402 1 72 1 72 89 52 52 gf180mcu_fd_io__fill1
* cell instance $403 r180 *1 776.46,2000
X$403 1 72 1 72 89 52 52 gf180mcu_fd_io__fill1
* cell instance $404 r180 *1 776.56,2000
X$404 1 72 1 72 89 52 52 1 1 1 gf180mcu_fd_io__fillnc
* cell instance $405 r180 *1 851.56,2000
X$405 1 72 1 72 52 52 154 154 89 gf180mcu_fd_io__asig_5p0
* cell instance $406 r180 *1 861.56,2000
X$406 89 165 154 1 72 1 72 gf180mcu_fd_io__fill10
* cell instance $407 r180 *1 871.56,2000
X$407 89 156 165 1 72 1 72 gf180mcu_fd_io__fill10
* cell instance $408 r180 *1 881.56,2000
X$408 89 157 156 1 72 1 72 gf180mcu_fd_io__fill10
* cell instance $409 r180 *1 891.56,2000
X$409 89 27 157 1 72 1 72 gf180mcu_fd_io__fill10
* cell instance $410 r180 *1 896.56,2000
X$410 89 53 27 1 72 1 72 gf180mcu_fd_io__fill5
* cell instance $411 r180 *1 897.56,2000
X$411 1 72 1 72 89 53 53 gf180mcu_fd_io__fill1
* cell instance $412 r180 *1 898.56,2000
X$412 1 72 1 72 89 53 53 gf180mcu_fd_io__fill1
* cell instance $413 r180 *1 899.56,2000
X$413 1 72 1 72 89 53 53 gf180mcu_fd_io__fill1
* cell instance $414 r180 *1 900.56,2000
X$414 1 72 1 72 89 53 53 gf180mcu_fd_io__fill1
* cell instance $415 r180 *1 900.66,2000
X$415 1 72 1 72 89 53 53 1 1 1 gf180mcu_fd_io__fillnc
* cell instance $416 r180 *1 975.66,2000
X$416 72 1 1 2 53 53 159 159 89 gf180mcu_fd_io__dvdd
* cell instance $417 r180 *1 985.66,2000
X$417 89 160 159 1 72 1 72 gf180mcu_fd_io__fill10
* cell instance $418 r180 *1 995.66,2000
X$418 89 168 160 1 72 1 72 gf180mcu_fd_io__fill10
* cell instance $419 r180 *1 1005.66,2000
X$419 89 130 168 1 72 1 72 gf180mcu_fd_io__fill10
* cell instance $420 r180 *1 1015.66,2000
X$420 89 28 130 1 72 1 72 gf180mcu_fd_io__fill10
* cell instance $421 r180 *1 1020.66,2000
X$421 89 47 28 1 72 1 72 gf180mcu_fd_io__fill5
* cell instance $422 r180 *1 1021.66,2000
X$422 1 72 1 72 89 47 47 gf180mcu_fd_io__fill1
* cell instance $423 r180 *1 1022.66,2000
X$423 1 72 1 72 89 47 47 gf180mcu_fd_io__fill1
* cell instance $424 r180 *1 1023.66,2000
X$424 1 72 1 72 89 47 47 gf180mcu_fd_io__fill1
* cell instance $425 r180 *1 1024.66,2000
X$425 1 72 1 72 89 47 47 gf180mcu_fd_io__fill1
* cell instance $426 r180 *1 1024.76,2000
X$426 1 72 1 72 89 47 47 1 1 1 gf180mcu_fd_io__fillnc
* cell instance $427 r180 *1 1099.76,2000
X$427 1 72 72 2 47 47 146 146 89 gf180mcu_fd_io__dvss
* cell instance $428 r180 *1 1109.76,2000
X$428 89 131 146 1 72 1 72 gf180mcu_fd_io__fill10
* cell instance $429 r180 *1 1119.76,2000
X$429 89 132 131 1 72 1 72 gf180mcu_fd_io__fill10
* cell instance $430 r180 *1 1129.76,2000
X$430 89 144 132 1 72 1 72 gf180mcu_fd_io__fill10
* cell instance $431 r180 *1 1139.76,2000
X$431 89 31 144 1 72 1 72 gf180mcu_fd_io__fill10
* cell instance $432 r180 *1 1144.76,2000
X$432 89 44 31 1 72 1 72 gf180mcu_fd_io__fill5
* cell instance $433 r180 *1 1145.76,2000
X$433 1 72 1 72 89 44 44 gf180mcu_fd_io__fill1
* cell instance $434 r180 *1 1146.76,2000
X$434 1 72 1 72 89 44 44 gf180mcu_fd_io__fill1
* cell instance $435 r180 *1 1147.76,2000
X$435 1 72 1 72 89 44 44 gf180mcu_fd_io__fill1
* cell instance $436 r180 *1 1148.76,2000
X$436 1 72 1 72 89 44 44 gf180mcu_fd_io__fill1
* cell instance $437 r180 *1 1148.86,2000
X$437 1 72 1 72 89 44 44 1 1 1 gf180mcu_fd_io__fillnc
* cell instance $438 r180 *1 1223.86,2000
X$438 1 72 1 72 44 44 133 133 89 gf180mcu_fd_io__asig_5p0
* cell instance $439 r180 *1 1233.86,2000
X$439 89 128 133 1 72 1 72 gf180mcu_fd_io__fill10
* cell instance $440 r180 *1 1243.86,2000
X$440 89 129 128 1 72 1 72 gf180mcu_fd_io__fill10
* cell instance $441 r180 *1 1253.86,2000
X$441 89 126 129 1 72 1 72 gf180mcu_fd_io__fill10
* cell instance $442 r180 *1 1263.86,2000
X$442 89 26 126 1 72 1 72 gf180mcu_fd_io__fill10
* cell instance $443 r180 *1 1268.86,2000
X$443 89 49 26 1 72 1 72 gf180mcu_fd_io__fill5
* cell instance $444 r180 *1 1269.86,2000
X$444 1 72 1 72 89 49 49 gf180mcu_fd_io__fill1
* cell instance $445 r180 *1 1270.86,2000
X$445 1 72 1 72 89 49 49 gf180mcu_fd_io__fill1
* cell instance $446 r180 *1 1271.86,2000
X$446 1 72 1 72 89 49 49 gf180mcu_fd_io__fill1
* cell instance $447 r180 *1 1272.86,2000
X$447 1 72 1 72 89 49 49 gf180mcu_fd_io__fill1
* cell instance $448 r180 *1 1272.96,2000
X$448 1 72 1 72 89 49 49 1 1 1 gf180mcu_fd_io__fillnc
* cell instance $449 r180 *1 1347.96,2000
X$449 1 72 1 72 49 49 137 137 89 gf180mcu_fd_io__asig_5p0
* cell instance $450 r180 *1 1357.96,2000
X$450 89 138 137 1 72 1 72 gf180mcu_fd_io__fill10
* cell instance $451 r180 *1 1367.96,2000
X$451 89 139 138 1 72 1 72 gf180mcu_fd_io__fill10
* cell instance $452 r180 *1 1377.96,2000
X$452 89 140 139 1 72 1 72 gf180mcu_fd_io__fill10
* cell instance $453 r180 *1 1387.96,2000
X$453 89 23 140 1 72 1 72 gf180mcu_fd_io__fill10
* cell instance $454 r180 *1 1392.96,2000
X$454 89 51 23 1 72 1 72 gf180mcu_fd_io__fill5
* cell instance $455 r180 *1 1393.96,2000
X$455 1 72 1 72 89 51 51 gf180mcu_fd_io__fill1
* cell instance $456 r180 *1 1394.96,2000
X$456 1 72 1 72 89 51 51 gf180mcu_fd_io__fill1
* cell instance $457 r180 *1 1395.96,2000
X$457 1 72 1 72 89 51 51 gf180mcu_fd_io__fill1
* cell instance $458 r180 *1 1396.96,2000
X$458 1 72 1 72 89 51 51 gf180mcu_fd_io__fill1
* cell instance $459 r180 *1 1397.06,2000
X$459 1 72 1 72 89 51 51 1 1 1 gf180mcu_fd_io__fillnc
* cell instance $460 r180 *1 1472.06,2000
X$460 1 72 1 72 51 51 143 143 89 gf180mcu_fd_io__asig_5p0
* cell instance $461 r180 *1 1482.06,2000
X$461 89 145 143 1 72 1 72 gf180mcu_fd_io__fill10
* cell instance $462 r180 *1 1492.06,2000
X$462 89 127 145 1 72 1 72 gf180mcu_fd_io__fill10
* cell instance $463 r180 *1 1502.06,2000
X$463 89 134 127 1 72 1 72 gf180mcu_fd_io__fill10
* cell instance $464 r180 *1 1512.06,2000
X$464 89 25 134 1 72 1 72 gf180mcu_fd_io__fill10
* cell instance $465 r180 *1 1517.06,2000
X$465 89 48 25 1 72 1 72 gf180mcu_fd_io__fill5
* cell instance $466 r180 *1 1518.06,2000
X$466 1 72 1 72 89 48 48 gf180mcu_fd_io__fill1
* cell instance $467 r180 *1 1519.06,2000
X$467 1 72 1 72 89 48 48 gf180mcu_fd_io__fill1
* cell instance $468 r180 *1 1520.06,2000
X$468 1 72 1 72 89 48 48 gf180mcu_fd_io__fill1
* cell instance $469 r180 *1 1521.06,2000
X$469 1 72 1 72 89 48 48 gf180mcu_fd_io__fill1
* cell instance $470 r180 *1 1521.16,2000
X$470 1 72 1 72 89 48 48 1 1 1 gf180mcu_fd_io__fillnc
* cell instance $471 r180 *1 1596.16,2000
X$471 1 72 1 72 48 48 135 135 89 gf180mcu_fd_io__asig_5p0
* cell instance $472 r180 *1 1606.16,2000
X$472 89 136 135 1 72 1 72 gf180mcu_fd_io__fill10
* cell instance $473 r180 *1 1616.16,2000
X$473 89 141 136 1 72 1 72 gf180mcu_fd_io__fill10
* cell instance $474 r180 *1 1626.16,2000
X$474 89 142 141 1 72 1 72 gf180mcu_fd_io__fill10
* cell instance $475 r180 *1 1636.16,2000
X$475 89 29 142 1 72 1 72 gf180mcu_fd_io__fill10
* cell instance $476 r180 *1 1641.16,2000
X$476 89 43 29 1 72 1 72 gf180mcu_fd_io__fill5
* cell instance $477 r180 *1 1642.16,2000
X$477 1 72 1 72 89 43 43 gf180mcu_fd_io__fill1
* cell instance $478 r180 *1 1643.16,2000
X$478 1 72 1 72 89 43 43 gf180mcu_fd_io__fill1
* cell instance $479 r180 *1 1644.16,2000
X$479 1 72 1 72 89 43 43 gf180mcu_fd_io__fill1
* cell instance $480 r180 *1 1645.16,2000
X$480 1 72 1 72 89 43 43 gf180mcu_fd_io__fill1
.ENDS PAD_RING_TOP

* cell gf180mcu_fd_io__dvdd
* pin DVDD
* pin DVSS
* pin VSS
* pin gf180mcu_gnd
* pin
* pin
* pin
* pin
* pin
.SUBCKT gf180mcu_fd_io__dvdd 1 2 3 4 5 6 7 8 9
* net 1 DVDD
* net 2 DVSS
* net 3 VSS
* net 4 gf180mcu_gnd
* cell instance $1 r0 *1 0,0
X$1 9 1 10 3 3 1 1 2 3LM_METAL_RAIL_PAD_60
* cell instance $2 r0 *1 0.055,62
X$2 3 3 10 1 2 10 10 10 10 10 8 6 2 3 3 7 3 5 4 GF_NI_DVDD_BASE
.ENDS gf180mcu_fd_io__dvdd

* cell gf180mcu_fd_io__dvss
* pin DVSS
* pin VDD
* pin DVDD
* pin gf180mcu_gnd
* pin
* pin
* pin
* pin
* pin
.SUBCKT gf180mcu_fd_io__dvss 1 2 3 4 5 6 7 8 9
* net 1 DVSS
* net 2 VDD
* net 3 DVDD
* net 4 gf180mcu_gnd
* cell instance $1 r0 *1 0,0
X$1 9 1 10 1 1 3 2 1 3LM_METAL_RAIL_PAD_60
* cell instance $2 r0 *1 0.055,62
X$2 1 1 10 1 10 10 10 10 10 3 8 6 2 1 1 1 1 2 3 1 7 1 5 1 1 4 GF_NI_DVSS_BASE
.ENDS gf180mcu_fd_io__dvss

* cell gf180mcu_fd_io__cor
* pin DVSS
* pin VDD
* pin DVDD
* pin VSS
* pin gf180mcu_gnd
* pin
.SUBCKT gf180mcu_fd_io__cor 1 2 3 4 5 6
* net 1 DVSS
* net 2 VDD
* net 3 DVDD
* net 4 VSS
* net 5 gf180mcu_gnd
* cell instance $1 r0 *1 0,0
X$1 6 4 1 3 4 2 POWER_RAIL_COR
* cell instance $2 r0 *1 0,0
X$2 1 3 1 1 2 1 5 1 4 3 3 1 4 4 4 4 1 3 3 3 3 3 3 3 GF_NI_COR_BASE
.ENDS gf180mcu_fd_io__cor

* cell gf180mcu_fd_io__asig_5p0
* pin VSS
* pin VDD
* pin DVSS
* pin DVDD
* pin
* pin
* pin
* pin
* pin
.SUBCKT gf180mcu_fd_io__asig_5p0 2 3 4 5 6 7 8 9 10
* net 1 ASIG5V
* net 2 VSS
* net 3 VDD
* net 4 DVSS
* net 5 DVDD
* cell instance $1 r0 *1 0,0
X$1 10 1 11 2 2 5 3 4 3LM_METAL_RAIL_PAD_60
* cell instance $2 r0 *1 -0.16,63.515
X$2 2 2 4 5 9 8 3 2 7 6 11 11 11 11 11 11 11 11 1 GF_NI_ASIG_5P0_BASE
.ENDS gf180mcu_fd_io__asig_5p0

* cell gf180mcu_fd_io__fillnc
* pin VSS
* pin VDD
* pin DVSS
* pin DVDD
* pin
* pin
* pin
* pin
* pin
* pin
.SUBCKT gf180mcu_fd_io__fillnc 1 2 3 4 5 6 7 8 9 10
* net 1 VSS
* net 2 VDD
* net 3 DVSS
* net 4 DVDD
.ENDS gf180mcu_fd_io__fillnc

* cell gf180mcu_fd_io__fill1
* pin VSS
* pin VDD
* pin DVSS
* pin DVDD
* pin
* pin
* pin
.SUBCKT gf180mcu_fd_io__fill1 1 2 3 4 5 6 7
* net 1 VSS
* net 2 VDD
* net 3 DVSS
* net 4 DVDD
* cell instance $1 r0 *1 0.5,207.57
X$1 1 5 M1_PSUB_CDNS_40661956134167
* cell instance $2 r0 *1 0.505,321.5
X$2 1 6 M2_M1_CDNS_40661956134169
* cell instance $3 r0 *1 0.51,249.47
X$3 1 7 M2_M1_CDNS_40661956134168
* cell instance $4 r0 *1 0.505,321.5
X$4 1 6 M3_M2_CDNS_40661956134171
* cell instance $5 r0 *1 0.51,249.47
X$5 1 7 M3_M2_CDNS_40661956134170
.ENDS gf180mcu_fd_io__fill1

* cell gf180mcu_fd_io__fill5
* pin
* pin
* pin
* pin VSS
* pin VDD
* pin DVSS
* pin DVDD
.SUBCKT gf180mcu_fd_io__fill5 1 2 3 4 5 6 7
* net 4 VSS
* net 5 VDD
* net 6 DVSS
* net 7 DVDD
* cell instance $1 r0 *1 2.5,349.365
X$1 4 1 M1_PSUB_CDNS_40661956134174
* cell instance $2 m0 *1 2.5,65.96
X$2 4 1 M1_PSUB_CDNS_40661956134174
* cell instance $3 m90 *1 0.24,207.62
X$3 4 1 M1_PSUB_CDNS_40661956134176
* cell instance $4 r0 *1 4.76,207.62
X$4 4 1 M1_PSUB_CDNS_40661956134176
* cell instance $5 r0 *1 0.425,249.5
X$5 4 2 M3_M2_CDNS_40661956134177
* cell instance $6 r0 *1 0.425,249.5
X$6 4 2 M2_M1_CDNS_40661956134173
* cell instance $7 r0 *1 0.425,321.5
X$7 4 2 M3_M2_CDNS_40661956134177
* cell instance $8 r0 *1 0.425,321.5
X$8 4 2 M2_M1_CDNS_40661956134173
* cell instance $9 r0 *1 4.385,249.5
X$9 4 3 M3_M2_CDNS_40661956134177
* cell instance $10 r0 *1 4.385,249.5
X$10 4 3 M2_M1_CDNS_40661956134173
* cell instance $11 r0 *1 4.385,321.5
X$11 4 3 M3_M2_CDNS_40661956134177
* cell instance $12 r0 *1 4.385,321.5
X$12 4 3 M2_M1_CDNS_40661956134173
* cell instance $13 r0 *1 -4.03,69.095
X$13 5 4 10 POLY_SUB_FILL
* cell instance $14 r0 *1 -4.03,77.095
X$14 5 4 10 POLY_SUB_FILL
* cell instance $15 r0 *1 -4.03,85.095
X$15 5 4 10 POLY_SUB_FILL
* cell instance $16 r0 *1 -4.03,93.095
X$16 5 4 10 POLY_SUB_FILL
* cell instance $17 r0 *1 -4.03,101.095
X$17 5 4 10 POLY_SUB_FILL
* cell instance $18 r0 *1 -4.03,109.095
X$18 5 4 10 POLY_SUB_FILL
* cell instance $19 r0 *1 -4.03,117.095
X$19 5 4 10 POLY_SUB_FILL
* cell instance $20 r0 *1 -4.03,125.095
X$20 5 4 10 POLY_SUB_FILL
* cell instance $21 r0 *1 -4.03,133.095
X$21 5 4 10 POLY_SUB_FILL
* cell instance $22 r0 *1 -4.03,141.095
X$22 5 4 10 POLY_SUB_FILL
* cell instance $23 r0 *1 -4.03,149.095
X$23 5 4 10 POLY_SUB_FILL
* cell instance $24 r0 *1 -4.03,157.095
X$24 5 4 10 POLY_SUB_FILL
* cell instance $25 r0 *1 -4.03,165.095
X$25 5 4 10 POLY_SUB_FILL
* cell instance $26 r0 *1 -4.03,173.095
X$26 5 4 10 POLY_SUB_FILL
* cell instance $27 r0 *1 -4.03,181.095
X$27 5 4 10 POLY_SUB_FILL
* cell instance $28 r0 *1 -4.03,189.095
X$28 5 4 10 POLY_SUB_FILL
* cell instance $29 r0 *1 -4.03,197.095
X$29 5 4 10 POLY_SUB_FILL
* cell instance $30 r0 *1 -4.03,205.095
X$30 5 4 10 POLY_SUB_FILL
* cell instance $31 r0 *1 -4.03,213.095
X$31 5 4 10 POLY_SUB_FILL
* cell instance $32 r0 *1 -4.03,221.095
X$32 5 4 10 POLY_SUB_FILL
* cell instance $33 r0 *1 -4.03,229.095
X$33 5 4 10 POLY_SUB_FILL
* cell instance $34 r0 *1 -4.03,237.095
X$34 5 4 10 POLY_SUB_FILL
* cell instance $35 r0 *1 -4.03,245.095
X$35 5 4 10 POLY_SUB_FILL
* cell instance $36 r0 *1 -4.03,253.095
X$36 5 4 10 POLY_SUB_FILL
* cell instance $37 r0 *1 -4.03,261.095
X$37 5 4 10 POLY_SUB_FILL
* cell instance $38 r0 *1 -4.03,269.095
X$38 5 4 10 POLY_SUB_FILL
* cell instance $39 r0 *1 -4.03,277.095
X$39 5 4 10 POLY_SUB_FILL
* cell instance $40 r0 *1 -4.03,285.095
X$40 5 4 10 POLY_SUB_FILL
* cell instance $41 r0 *1 -4.03,293.095
X$41 5 4 10 POLY_SUB_FILL
* cell instance $42 r0 *1 -4.03,301.095
X$42 5 4 10 POLY_SUB_FILL
* cell instance $43 r0 *1 -4.03,309.095
X$43 5 4 10 POLY_SUB_FILL
* cell instance $44 r0 *1 -4.03,317.095
X$44 5 4 10 POLY_SUB_FILL
* cell instance $45 r0 *1 -4.03,325.095
X$45 5 4 10 POLY_SUB_FILL
* cell instance $46 r0 *1 -4.03,333.095
X$46 5 4 10 POLY_SUB_FILL
* cell instance $47 r0 *1 -4.03,341.095
X$47 5 4 10 POLY_SUB_FILL
* cell instance $48 r0 *1 2.55,257.52
X$48 5 10 M3_M2_CDNS_40661956134172
* cell instance $49 r0 *1 2.55,313.485
X$49 5 10 M3_M2_CDNS_40661956134172
* cell instance $50 r0 *1 3.47,93.48
X$50 6 8 M3_M2_CDNS_40661956134175
* cell instance $51 r0 *1 3.47,77.48
X$51 6 8 M3_M2_CDNS_40661956134175
* cell instance $52 r0 *1 3.47,109.54
X$52 6 8 M3_M2_CDNS_40661956134175
* cell instance $53 r0 *1 3.47,237.64
X$53 6 8 M3_M2_CDNS_40661956134175
* cell instance $54 r0 *1 3.47,345.115
X$54 6 8 M3_M2_CDNS_40661956134172
* cell instance $55 r0 *1 3.47,329.55
X$55 6 8 M3_M2_CDNS_40661956134172
* cell instance $56 r0 *1 3.47,129.645
X$56 6 8 M3_M2_CDNS_40661956134172
* cell instance $57 r0 *1 3.47,201.635
X$57 6 8 M3_M2_CDNS_40661956134172
* cell instance $58 r0 *1 3.47,289.485
X$58 6 8 M3_M2_CDNS_40661956134172
* cell instance $59 r0 *1 3.47,305.54
X$59 6 8 M3_M2_CDNS_40661956134172
* cell instance $60 r0 *1 1.59,141.715
X$60 7 9 M3_M2_CDNS_40661956134175
* cell instance $61 r0 *1 1.59,157.565
X$61 7 9 M3_M2_CDNS_40661956134175
* cell instance $62 r0 *1 1.59,173.59
X$62 7 9 M3_M2_CDNS_40661956134175
* cell instance $63 r0 *1 1.59,189.44
X$63 7 9 M3_M2_CDNS_40661956134175
* cell instance $64 r0 *1 1.59,221.555
X$64 7 9 M3_M2_CDNS_40661956134175
* cell instance $65 r0 *1 1.59,121.49
X$65 7 9 M3_M2_CDNS_40661956134172
* cell instance $66 r0 *1 1.59,209.475
X$66 7 9 M3_M2_CDNS_40661956134172
* cell instance $67 r0 *1 1.59,265.565
X$67 7 9 M3_M2_CDNS_40661956134172
* cell instance $68 r0 *1 1.59,273.52
X$68 7 9 M3_M2_CDNS_40661956134172
* cell instance $69 r0 *1 1.59,281.615
X$69 7 9 M3_M2_CDNS_40661956134172
* cell instance $70 r0 *1 1.59,297.525
X$70 7 9 M3_M2_CDNS_40661956134172
* cell instance $71 r0 *1 1.59,337.47
X$71 7 9 M3_M2_CDNS_40661956134172
.ENDS gf180mcu_fd_io__fill5

* cell gf180mcu_fd_io__fill10
* pin
* pin
* pin
* pin VSS
* pin VDD
* pin DVSS
* pin DVDD
.SUBCKT gf180mcu_fd_io__fill10 1 2 3 4 5 6 7
* net 4 VSS
* net 5 VDD
* net 6 DVSS
* net 7 DVDD
* cell instance $1 r0 *1 5.005,349.365
X$1 4 1 M1_PSUB_CDNS_40661956134182
* cell instance $2 m0 *1 5.005,65.96
X$2 4 1 M1_PSUB_CDNS_40661956134182
* cell instance $3 m90 *1 0.24,207.62
X$3 4 1 M1_PSUB_CDNS_40661956134176
* cell instance $4 r0 *1 9.76,207.62
X$4 4 1 M1_PSUB_CDNS_40661956134176
* cell instance $5 r0 *1 0.91,321.5
X$5 4 2 M3_M2_CDNS_40661956134180
* cell instance $6 r0 *1 0.91,321.5
X$6 4 2 M2_M1_CDNS_40661956134179
* cell instance $7 r0 *1 0.91,249.505
X$7 4 2 M3_M2_CDNS_40661956134180
* cell instance $8 r0 *1 0.91,249.505
X$8 4 2 M2_M1_CDNS_40661956134179
* cell instance $9 r0 *1 9.09,321.5
X$9 4 3 M3_M2_CDNS_40661956134180
* cell instance $10 r0 *1 9.09,321.5
X$10 4 3 M2_M1_CDNS_40661956134179
* cell instance $11 r0 *1 9.09,249.505
X$11 4 3 M3_M2_CDNS_40661956134180
* cell instance $12 r0 *1 9.09,249.505
X$12 4 3 M2_M1_CDNS_40661956134179
* cell instance $13 m90 *1 11.435,71.96
X$13 4 5 10 POLY_SUB_FILL_1
* cell instance $14 m90 *1 11.435,89.02
X$14 4 5 10 POLY_SUB_FILL_1
* cell instance $15 m90 *1 11.435,106.08
X$15 4 5 10 POLY_SUB_FILL_1
* cell instance $16 m90 *1 11.435,123.14
X$16 4 5 10 POLY_SUB_FILL_1
* cell instance $17 m90 *1 11.435,140.2
X$17 4 5 10 POLY_SUB_FILL_1
* cell instance $18 m90 *1 11.435,157.26
X$18 4 5 10 POLY_SUB_FILL_1
* cell instance $19 m90 *1 11.435,174.32
X$19 4 5 10 POLY_SUB_FILL_1
* cell instance $20 m90 *1 11.435,191.38
X$20 4 5 10 POLY_SUB_FILL_1
* cell instance $21 m90 *1 11.435,208.44
X$21 4 5 10 POLY_SUB_FILL_1
* cell instance $22 m90 *1 11.435,225.5
X$22 4 5 10 POLY_SUB_FILL_1
* cell instance $23 m90 *1 11.435,242.56
X$23 4 5 10 POLY_SUB_FILL_1
* cell instance $24 m90 *1 11.435,259.62
X$24 4 5 10 POLY_SUB_FILL_1
* cell instance $25 m90 *1 11.435,276.68
X$25 4 5 10 POLY_SUB_FILL_1
* cell instance $26 m90 *1 11.435,293.74
X$26 4 5 10 POLY_SUB_FILL_1
* cell instance $27 m90 *1 11.435,310.8
X$27 4 5 10 POLY_SUB_FILL_1
* cell instance $28 m90 *1 11.435,327.86
X$28 4 5 10 POLY_SUB_FILL_1
* cell instance $29 r0 *1 5.125,257.585
X$29 5 10 M3_M2_CDNS_40661956134181
* cell instance $30 r0 *1 5.13,313.495
X$30 5 10 M3_M2_CDNS_40661956134181
* cell instance $31 r0 *1 7.375,77.66
X$31 6 9 M3_M2_CDNS_40661956134175
* cell instance $32 r0 *1 7.375,93.61
X$32 6 9 M3_M2_CDNS_40661956134175
* cell instance $33 r0 *1 7.375,109.345
X$33 6 9 M3_M2_CDNS_40661956134175
* cell instance $34 r0 *1 7.375,237.415
X$34 6 9 M3_M2_CDNS_40661956134175
* cell instance $35 r0 *1 7.375,329.585
X$35 6 9 M3_M2_CDNS_40661956134172
* cell instance $36 r0 *1 7.375,129.67
X$36 6 9 M3_M2_CDNS_40661956134172
* cell instance $37 r0 *1 7.375,201.64
X$37 6 9 M3_M2_CDNS_40661956134172
* cell instance $38 r0 *1 7.375,289.415
X$38 6 9 M3_M2_CDNS_40661956134172
* cell instance $39 r0 *1 7.375,305.605
X$39 6 9 M3_M2_CDNS_40661956134172
* cell instance $40 r0 *1 7.375,345.27
X$40 6 9 M3_M2_CDNS_40661956134172
* cell instance $41 r0 *1 2.76,221.295
X$41 7 8 M3_M2_CDNS_40661956134175
* cell instance $42 r0 *1 2.76,141.75
X$42 7 8 M3_M2_CDNS_40661956134175
* cell instance $43 r0 *1 2.76,157.46
X$43 7 8 M3_M2_CDNS_40661956134175
* cell instance $44 r0 *1 2.76,173.585
X$44 7 8 M3_M2_CDNS_40661956134175
* cell instance $45 r0 *1 2.76,189.69
X$45 7 8 M3_M2_CDNS_40661956134175
* cell instance $46 r0 *1 2.76,209.5
X$46 7 8 M3_M2_CDNS_40661956134172
* cell instance $47 r0 *1 2.76,265.455
X$47 7 8 M3_M2_CDNS_40661956134172
* cell instance $48 r0 *1 2.76,273.525
X$48 7 8 M3_M2_CDNS_40661956134172
* cell instance $49 r0 *1 2.76,281.64
X$49 7 8 M3_M2_CDNS_40661956134172
* cell instance $50 r0 *1 2.76,297.4
X$50 7 8 M3_M2_CDNS_40661956134172
* cell instance $51 r0 *1 2.76,337.285
X$51 7 8 M3_M2_CDNS_40661956134172
* cell instance $52 r0 *1 2.76,121.505
X$52 7 8 M3_M2_CDNS_40661956134172
.ENDS gf180mcu_fd_io__fill10

* cell GF_NI_DVDD_BASE
* pin
* pin
* pin
* pin DVDD
* pin DVSS
* pin
* pin
* pin
* pin
* pin
* pin
* pin
* pin
* pin
* pin
* pin
* pin
* pin
* pin gf180mcu_gnd
.SUBCKT GF_NI_DVDD_BASE 1 2 3 4 5 6 7 8 9 10 11 12 14 15 16 18 21 27 28
* net 4 DVDD
* net 5 DVSS
* net 28 gf180mcu_gnd
* cell instance $1 r0 *1 67.48,174.62
X$1 1 M1_PSUB_CDNS_40661956134228
* cell instance $2 r0 *1 72.435,109.62
X$2 1 M1_PSUB_CDNS_40661956134229
* cell instance $3 r0 *1 74.65,187.5
X$3 1 12 M3_M2_CDNS_40661956134114
* cell instance $4 r0 *1 74.65,187.5
X$4 1 12 M2_M1_CDNS_40661956134115
* cell instance $5 r0 *1 2.455,109.62
X$5 2 M1_PSUB_CDNS_40661956134229
* cell instance $6 r0 *1 0.24,187.5
X$6 2 11 M2_M1_CDNS_40661956134115
* cell instance $7 r0 *1 0.24,187.5
X$7 2 11 M3_M2_CDNS_40661956134114
* cell instance $8 r0 *1 6.055,275.5
X$8 4 3 M3_M2_CDNS_40661956134119
* cell instance $9 r0 *1 6.885,275.775
X$9 4 3 M2_M1_CDNS_40661956134214
* cell instance $10 r0 *1 6.055,251.5
X$10 4 3 M3_M2_CDNS_40661956134119
* cell instance $11 r0 *1 6.055,59.5
X$11 4 3 M3_M2_CDNS_40661956134119
* cell instance $12 r0 *1 5.04,5.735
X$12 14 4 3 20 23 6 7 24 8 25 9 26 10 28 comp018green_esd_clamp_v5p0_DVDD
* cell instance $13 r0 *1 6.055,95.5
X$13 4 3 M3_M2_CDNS_40661956134156
* cell instance $14 r0 *1 6.055,79.5
X$14 4 3 M3_M2_CDNS_40661956134156
* cell instance $15 r0 *1 6.055,127.5
X$15 4 3 M3_M2_CDNS_40661956134156
* cell instance $16 r0 *1 6.055,111.5
X$16 4 3 M3_M2_CDNS_40661956134156
* cell instance $17 r0 *1 6.055,147.5
X$17 4 3 M3_M2_CDNS_40661956134119
* cell instance $18 r0 *1 6.055,159.5
X$18 4 3 M3_M2_CDNS_40661956134156
* cell instance $19 r0 *1 6.055,195.5
X$19 4 3 M3_M2_CDNS_40661956134119
* cell instance $20 r0 *1 6.055,211.5
X$20 4 3 M3_M2_CDNS_40661956134119
* cell instance $21 r0 *1 6.055,203.5
X$21 4 3 M3_M2_CDNS_40661956134119
* cell instance $22 r0 *1 6.055,219.5
X$22 4 3 M3_M2_CDNS_40661956134119
* cell instance $23 r0 *1 6.055,235.5
X$23 4 3 M3_M2_CDNS_40661956134119
* cell instance $24 r0 *1 41.415,275.775
X$24 4 8 M2_M1_CDNS_40661956134208
* cell instance $25 r0 *1 38.535,268.275
X$25 14 4 nmoscap_6p0_CDNS_406619561348
* cell instance $26 r0 *1 44.21,275.5
X$26 4 8 M3_M2_CDNS_40661956134221
* cell instance $27 r0 *1 52.13,275.775
X$27 4 9 M2_M1_CDNS_40661956134213
* cell instance $28 r0 *1 56.06,275.5
X$28 4 9 M3_M2_CDNS_40661956134221
* cell instance $29 m90 *1 58.425,275.775
X$29 4 9 M2_M1_CDNS_40661956134214
* cell instance $30 r0 *1 55.715,268.275
X$30 14 4 nmoscap_6p0_CDNS_406619561348
* cell instance $31 m90 *1 68.005,275.775
X$31 4 10 M2_M1_CDNS_40661956134214
* cell instance $32 r0 *1 68.835,275.5
X$32 4 10 M3_M2_CDNS_40661956134119
* cell instance $33 r0 *1 20.715,243.685
X$33 4 6 M2_M1_CDNS_40661956134211
* cell instance $34 r0 *1 17.445,243.185
X$34 4 np_6p0_CDNS_406619561349
* cell instance $35 r0 *1 30.68,243.685
X$35 4 7 M2_M1_CDNS_40661956134212
* cell instance $36 m90 *1 44.21,243.685
X$36 4 8 M2_M1_CDNS_40661956134212
* cell instance $37 m90 *1 54.175,243.685
X$37 4 9 M2_M1_CDNS_40661956134211
* cell instance $38 r0 *1 20.715,248.355
X$38 4 6 M2_M1_CDNS_40661956134211
* cell instance $39 r0 *1 18.83,251.5
X$39 4 6 M3_M2_CDNS_40661956134221
* cell instance $40 r0 *1 17.445,247.855
X$40 4 np_6p0_CDNS_406619561349
* cell instance $41 r0 *1 30.68,248.355
X$41 4 7 M2_M1_CDNS_40661956134212
* cell instance $42 r0 *1 30.68,251.5
X$42 4 7 M3_M2_CDNS_40661956134221
* cell instance $43 m90 *1 44.21,248.355
X$43 4 8 M2_M1_CDNS_40661956134212
* cell instance $44 r0 *1 44.21,251.5
X$44 4 8 M3_M2_CDNS_40661956134221
* cell instance $45 m90 *1 54.175,248.355
X$45 4 9 M2_M1_CDNS_40661956134211
* cell instance $46 r0 *1 56.06,251.5
X$46 4 9 M3_M2_CDNS_40661956134221
* cell instance $47 r0 *1 20.715,253.025
X$47 4 6 M2_M1_CDNS_40661956134211
* cell instance $48 r0 *1 17.445,252.525
X$48 4 np_6p0_CDNS_406619561349
* cell instance $49 r0 *1 30.68,253.025
X$49 4 7 M2_M1_CDNS_40661956134212
* cell instance $50 m90 *1 44.21,253.025
X$50 4 8 M2_M1_CDNS_40661956134212
* cell instance $51 m90 *1 54.175,253.025
X$51 4 9 M2_M1_CDNS_40661956134211
* cell instance $52 r0 *1 20.715,257.695
X$52 4 6 M2_M1_CDNS_40661956134211
* cell instance $53 r0 *1 17.445,257.195
X$53 4 np_6p0_CDNS_406619561349
* cell instance $54 r0 *1 30.68,257.695
X$54 4 7 M2_M1_CDNS_40661956134212
* cell instance $55 m90 *1 44.21,257.695
X$55 4 8 M2_M1_CDNS_40661956134212
* cell instance $56 m90 *1 54.175,257.695
X$56 4 9 M2_M1_CDNS_40661956134211
* cell instance $57 r0 *1 37.445,239.19
X$57 4 4 29 17 M1_NWELL_CDNS_40661956134205
* cell instance $58 r0 *1 13.675,250.69
X$58 4 17 4 29 M1_NWELL_CDNS_40661956134204
* cell instance $59 r0 *1 61.215,250.69
X$59 4 17 4 29 M1_NWELL_CDNS_40661956134204
* cell instance $60 r0 *1 37.445,262.19
X$60 4 4 29 17 M1_NWELL_CDNS_40661956134205
* cell instance $61 r0 *1 68.835,251.5
X$61 4 10 M3_M2_CDNS_40661956134119
* cell instance $62 r0 *1 4.175,268.275
X$62 14 4 nmoscap_6p0_CDNS_406619561348
* cell instance $63 r0 *1 16.465,275.775
X$63 4 6 M2_M1_CDNS_40661956134214
* cell instance $64 r0 *1 18.83,275.5
X$64 4 6 M3_M2_CDNS_40661956134221
* cell instance $65 r0 *1 22.76,275.775
X$65 4 6 M2_M1_CDNS_40661956134213
* cell instance $66 r0 *1 21.355,268.275
X$66 14 4 nmoscap_6p0_CDNS_406619561348
* cell instance $67 r0 *1 33.475,275.775
X$67 4 7 M2_M1_CDNS_40661956134208
* cell instance $68 r0 *1 30.68,275.5
X$68 4 7 M3_M2_CDNS_40661956134221
* cell instance $69 r0 *1 18.83,59.5
X$69 4 6 M3_M2_CDNS_40661956134221
* cell instance $70 r0 *1 30.68,59.5
X$70 4 7 M3_M2_CDNS_40661956134221
* cell instance $71 r0 *1 44.21,59.5
X$71 4 8 M3_M2_CDNS_40661956134221
* cell instance $72 r0 *1 56.06,59.5
X$72 4 9 M3_M2_CDNS_40661956134221
* cell instance $73 r0 *1 68.835,59.5
X$73 4 10 M3_M2_CDNS_40661956134119
* cell instance $74 r0 *1 18.83,95.5
X$74 4 6 M3_M2_CDNS_40661956134222
* cell instance $75 r0 *1 18.83,79.5
X$75 4 6 M3_M2_CDNS_40661956134222
* cell instance $76 r0 *1 30.68,79.5
X$76 4 7 M3_M2_CDNS_40661956134222
* cell instance $77 r0 *1 30.68,95.5
X$77 4 7 M3_M2_CDNS_40661956134222
* cell instance $78 r0 *1 44.21,79.5
X$78 4 8 M3_M2_CDNS_40661956134222
* cell instance $79 r0 *1 44.21,95.5
X$79 4 8 M3_M2_CDNS_40661956134222
* cell instance $80 r0 *1 56.06,79.5
X$80 4 9 M3_M2_CDNS_40661956134222
* cell instance $81 r0 *1 56.06,95.5
X$81 4 9 M3_M2_CDNS_40661956134222
* cell instance $82 r0 *1 68.835,79.5
X$82 4 10 M3_M2_CDNS_40661956134156
* cell instance $83 r0 *1 68.835,95.5
X$83 4 10 M3_M2_CDNS_40661956134156
* cell instance $84 r0 *1 18.83,127.5
X$84 4 6 M3_M2_CDNS_40661956134222
* cell instance $85 r0 *1 18.83,111.5
X$85 4 6 M3_M2_CDNS_40661956134222
* cell instance $86 r0 *1 30.68,127.5
X$86 4 7 M3_M2_CDNS_40661956134222
* cell instance $87 r0 *1 30.68,111.5
X$87 4 7 M3_M2_CDNS_40661956134222
* cell instance $88 r0 *1 44.21,127.5
X$88 4 8 M3_M2_CDNS_40661956134222
* cell instance $89 r0 *1 44.21,111.5
X$89 4 8 M3_M2_CDNS_40661956134222
* cell instance $90 r0 *1 56.06,111.5
X$90 4 9 M3_M2_CDNS_40661956134222
* cell instance $91 r0 *1 56.06,127.5
X$91 4 9 M3_M2_CDNS_40661956134222
* cell instance $92 r0 *1 68.835,127.5
X$92 4 10 M3_M2_CDNS_40661956134156
* cell instance $93 r0 *1 68.835,111.5
X$93 4 10 M3_M2_CDNS_40661956134156
* cell instance $94 r0 *1 18.83,147.5
X$94 4 6 M3_M2_CDNS_40661956134221
* cell instance $95 r0 *1 30.68,147.5
X$95 4 7 M3_M2_CDNS_40661956134221
* cell instance $96 r0 *1 44.21,147.5
X$96 4 8 M3_M2_CDNS_40661956134221
* cell instance $97 r0 *1 56.06,147.5
X$97 4 9 M3_M2_CDNS_40661956134221
* cell instance $98 r0 *1 68.835,147.5
X$98 4 10 M3_M2_CDNS_40661956134119
* cell instance $99 r0 *1 18.83,159.5
X$99 4 6 M3_M2_CDNS_40661956134222
* cell instance $100 r0 *1 30.68,159.5
X$100 4 7 M3_M2_CDNS_40661956134222
* cell instance $101 r0 *1 44.21,159.5
X$101 4 8 M3_M2_CDNS_40661956134222
* cell instance $102 r0 *1 56.06,159.5
X$102 4 9 M3_M2_CDNS_40661956134222
* cell instance $103 r0 *1 68.835,159.5
X$103 4 10 M3_M2_CDNS_40661956134156
* cell instance $104 r0 *1 18.83,195.5
X$104 4 6 M3_M2_CDNS_40661956134221
* cell instance $105 r0 *1 30.68,195.5
X$105 4 7 M3_M2_CDNS_40661956134221
* cell instance $106 r0 *1 44.21,195.5
X$106 4 8 M3_M2_CDNS_40661956134221
* cell instance $107 r0 *1 56.06,195.5
X$107 4 9 M3_M2_CDNS_40661956134221
* cell instance $108 r0 *1 68.835,195.5
X$108 4 10 M3_M2_CDNS_40661956134119
* cell instance $109 r0 *1 18.83,211.5
X$109 4 6 M3_M2_CDNS_40661956134221
* cell instance $110 r0 *1 18.83,203.5
X$110 4 6 M3_M2_CDNS_40661956134221
* cell instance $111 r0 *1 30.68,211.5
X$111 4 7 M3_M2_CDNS_40661956134221
* cell instance $112 r0 *1 30.68,203.5
X$112 4 7 M3_M2_CDNS_40661956134221
* cell instance $113 r0 *1 44.21,211.5
X$113 4 8 M3_M2_CDNS_40661956134221
* cell instance $114 r0 *1 44.21,203.5
X$114 4 8 M3_M2_CDNS_40661956134221
* cell instance $115 r0 *1 56.06,203.5
X$115 4 9 M3_M2_CDNS_40661956134221
* cell instance $116 r0 *1 56.06,211.5
X$116 4 9 M3_M2_CDNS_40661956134221
* cell instance $117 r0 *1 68.835,203.5
X$117 4 10 M3_M2_CDNS_40661956134119
* cell instance $118 r0 *1 68.835,211.5
X$118 4 10 M3_M2_CDNS_40661956134119
* cell instance $119 r0 *1 18.83,219.5
X$119 4 6 M3_M2_CDNS_40661956134221
* cell instance $120 r0 *1 30.68,219.5
X$120 4 7 M3_M2_CDNS_40661956134221
* cell instance $121 r0 *1 44.21,219.5
X$121 4 8 M3_M2_CDNS_40661956134221
* cell instance $122 r0 *1 56.06,219.5
X$122 4 9 M3_M2_CDNS_40661956134221
* cell instance $123 r0 *1 68.835,219.5
X$123 4 10 M3_M2_CDNS_40661956134119
* cell instance $124 r0 *1 18.83,235.5
X$124 4 6 M3_M2_CDNS_40661956134221
* cell instance $125 r0 *1 30.68,235.5
X$125 4 7 M3_M2_CDNS_40661956134221
* cell instance $126 r0 *1 44.21,235.5
X$126 4 8 M3_M2_CDNS_40661956134221
* cell instance $127 r0 *1 56.06,235.5
X$127 4 9 M3_M2_CDNS_40661956134221
* cell instance $128 r0 *1 68.835,235.5
X$128 4 10 M3_M2_CDNS_40661956134119
* cell instance $129 r0 *1 18.83,239.19
X$129 4 6 M2_M1_CDNS_40661956134210
* cell instance $130 r0 *1 30.68,239.19
X$130 4 7 M2_M1_CDNS_40661956134210
* cell instance $131 m90 *1 44.21,239.19
X$131 4 8 M2_M1_CDNS_40661956134210
* cell instance $132 m90 *1 56.06,239.19
X$132 4 9 M2_M1_CDNS_40661956134210
* cell instance $133 r0 *1 18.83,262.19
X$133 4 6 M2_M1_CDNS_40661956134210
* cell instance $134 r0 *1 30.68,262.19
X$134 4 7 M2_M1_CDNS_40661956134210
* cell instance $135 m90 *1 44.21,262.19
X$135 4 8 M2_M1_CDNS_40661956134210
* cell instance $136 m90 *1 56.06,262.19
X$136 4 9 M2_M1_CDNS_40661956134210
* cell instance $137 r0 *1 15.695,250.69
X$137 14 13 M1_PSUB_CDNS_40661956134203
* cell instance $138 r0 *1 37.445,241.35
X$138 14 13 M1_PSUB_CDNS_40661956134202
* cell instance $139 r0 *1 37.445,242.12
X$139 14 13 M1_PSUB_CDNS_40661956134200
* cell instance $140 r0 *1 16.465,253.025
X$140 14 13 M1_PSUB_CDNS_40661956134199
* cell instance $141 r0 *1 37.445,250.69
X$141 14 13 M1_PSUB_CDNS_40661956134201
* cell instance $142 r0 *1 37.445,255.36
X$142 14 13 M1_PSUB_CDNS_40661956134201
* cell instance $143 r0 *1 37.445,246.02
X$143 14 13 M1_PSUB_CDNS_40661956134201
* cell instance $144 m90 *1 58.425,248.355
X$144 14 13 M1_PSUB_CDNS_40661956134199
* cell instance $145 m90 *1 58.425,257.695
X$145 14 13 M1_PSUB_CDNS_40661956134199
* cell instance $146 m90 *1 58.425,253.025
X$146 14 13 M1_PSUB_CDNS_40661956134199
* cell instance $147 m90 *1 58.425,243.685
X$147 14 13 M1_PSUB_CDNS_40661956134199
* cell instance $148 r0 *1 16.465,257.695
X$148 14 13 M1_PSUB_CDNS_40661956134199
* cell instance $149 r0 *1 16.465,248.355
X$149 14 13 M1_PSUB_CDNS_40661956134199
* cell instance $150 r0 *1 16.465,243.685
X$150 14 13 M1_PSUB_CDNS_40661956134199
* cell instance $151 m0 *1 37.445,259.26
X$151 14 13 M1_PSUB_CDNS_40661956134200
* cell instance $152 r0 *1 37.445,249.92
X$152 14 13 M1_PSUB_CDNS_40661956134200
* cell instance $153 r0 *1 37.445,245.25
X$153 14 13 M1_PSUB_CDNS_40661956134200
* cell instance $154 r0 *1 37.445,246.79
X$154 14 13 M1_PSUB_CDNS_40661956134200
* cell instance $155 r0 *1 37.445,251.46
X$155 14 13 M1_PSUB_CDNS_40661956134200
* cell instance $156 r0 *1 37.445,254.59
X$156 14 13 M1_PSUB_CDNS_40661956134200
* cell instance $157 r0 *1 37.445,256.13
X$157 14 13 M1_PSUB_CDNS_40661956134200
* cell instance $158 m0 *1 37.445,260.03
X$158 14 13 M1_PSUB_CDNS_40661956134202
* cell instance $159 m90 *1 59.195,250.69
X$159 14 13 M1_PSUB_CDNS_40661956134203
* cell instance $160 r0 *1 1.895,275.775
X$160 14 19 M1_PSUB_CDNS_40661956134197
* cell instance $161 r0 *1 72.995,275.775
X$161 14 19 M1_PSUB_CDNS_40661956134197
* cell instance $162 r0 *1 24.755,250.69
X$162 14 23 M2_M1_CDNS_40661956134216
* cell instance $163 m90 *1 37.445,250.69
X$163 14 24 M2_M1_CDNS_40661956134220
* cell instance $164 m90 *1 50.135,250.69
X$164 14 25 M2_M1_CDNS_40661956134216
* cell instance $165 r0 *1 24.755,255.36
X$165 14 23 M2_M1_CDNS_40661956134216
* cell instance $166 m90 *1 37.445,255.36
X$166 14 24 M2_M1_CDNS_40661956134220
* cell instance $167 m90 *1 50.135,255.36
X$167 14 25 M2_M1_CDNS_40661956134216
* cell instance $168 r0 *1 24.755,241.735
X$168 14 23 M2_M1_CDNS_40661956134209
* cell instance $169 r0 *1 24.755,243.5
X$169 14 23 M3_M2_CDNS_40661956134223
* cell instance $170 m90 *1 37.445,241.735
X$170 14 24 M2_M1_CDNS_40661956134215
* cell instance $171 r0 *1 37.445,243.5
X$171 14 24 M3_M2_CDNS_40661956134225
* cell instance $172 m90 *1 50.135,241.735
X$172 14 25 M2_M1_CDNS_40661956134209
* cell instance $173 r0 *1 50.135,243.5
X$173 14 25 M3_M2_CDNS_40661956134223
* cell instance $174 r0 *1 24.755,246.02
X$174 14 23 M2_M1_CDNS_40661956134216
* cell instance $175 m90 *1 37.445,246.02
X$175 14 24 M2_M1_CDNS_40661956134220
* cell instance $176 m90 *1 50.135,246.02
X$176 14 25 M2_M1_CDNS_40661956134216
* cell instance $177 r0 *1 24.755,259.645
X$177 14 23 M2_M1_CDNS_40661956134209
* cell instance $178 m90 *1 37.445,259.645
X$178 14 24 M2_M1_CDNS_40661956134215
* cell instance $179 m90 *1 50.135,259.645
X$179 14 25 M2_M1_CDNS_40661956134209
* cell instance $180 r0 *1 61.985,243.5
X$180 14 26 M3_M2_CDNS_40661956134223
* cell instance $181 r0 *1 12.905,243.5
X$181 14 20 M3_M2_CDNS_40661956134223
* cell instance $182 r0 *1 12.905,15.5
X$182 14 20 M3_M2_CDNS_40661956134226
* cell instance $183 r0 *1 24.755,15.5
X$183 14 23 M3_M2_CDNS_40661956134226
* cell instance $184 r0 *1 37.445,15.5
X$184 14 24 M3_M2_CDNS_40661956134227
* cell instance $185 r0 *1 50.135,15.5
X$185 14 25 M3_M2_CDNS_40661956134226
* cell instance $186 r0 *1 61.985,15.5
X$186 14 26 M3_M2_CDNS_40661956134226
* cell instance $187 r0 *1 12.905,47.5
X$187 14 20 M3_M2_CDNS_40661956134226
* cell instance $188 r0 *1 12.905,31.5
X$188 14 20 M3_M2_CDNS_40661956134226
* cell instance $189 r0 *1 24.755,47.5
X$189 14 23 M3_M2_CDNS_40661956134226
* cell instance $190 r0 *1 24.755,31.5
X$190 14 23 M3_M2_CDNS_40661956134226
* cell instance $191 r0 *1 37.445,31.5
X$191 14 24 M3_M2_CDNS_40661956134227
* cell instance $192 r0 *1 37.445,47.5
X$192 14 24 M3_M2_CDNS_40661956134227
* cell instance $193 r0 *1 50.135,31.5
X$193 14 25 M3_M2_CDNS_40661956134226
* cell instance $194 r0 *1 50.135,47.5
X$194 14 25 M3_M2_CDNS_40661956134226
* cell instance $195 r0 *1 61.985,31.5
X$195 14 26 M3_M2_CDNS_40661956134226
* cell instance $196 r0 *1 61.985,47.5
X$196 14 26 M3_M2_CDNS_40661956134226
* cell instance $197 r0 *1 12.905,67.5
X$197 14 20 M3_M2_CDNS_40661956134223
* cell instance $198 r0 *1 24.755,67.5
X$198 14 23 M3_M2_CDNS_40661956134223
* cell instance $199 r0 *1 37.445,67.5
X$199 14 24 M3_M2_CDNS_40661956134225
* cell instance $200 r0 *1 50.135,67.5
X$200 14 25 M3_M2_CDNS_40661956134223
* cell instance $201 r0 *1 61.985,67.5
X$201 14 26 M3_M2_CDNS_40661956134223
* cell instance $202 r0 *1 12.905,139.5
X$202 14 20 M3_M2_CDNS_40661956134223
* cell instance $203 r0 *1 24.755,139.5
X$203 14 23 M3_M2_CDNS_40661956134223
* cell instance $204 r0 *1 37.445,139.5
X$204 14 24 M3_M2_CDNS_40661956134225
* cell instance $205 r0 *1 50.135,139.5
X$205 14 25 M3_M2_CDNS_40661956134223
* cell instance $206 r0 *1 61.985,139.5
X$206 14 26 M3_M2_CDNS_40661956134223
* cell instance $207 r0 *1 12.905,175.5
X$207 14 20 M3_M2_CDNS_40661956134226
* cell instance $208 r0 *1 24.755,175.5
X$208 14 23 M3_M2_CDNS_40661956134226
* cell instance $209 r0 *1 37.445,175.5
X$209 14 24 M3_M2_CDNS_40661956134227
* cell instance $210 r0 *1 50.135,175.5
X$210 14 25 M3_M2_CDNS_40661956134226
* cell instance $211 r0 *1 61.985,175.5
X$211 14 26 M3_M2_CDNS_40661956134226
* cell instance $212 r0 *1 12.905,227.5
X$212 14 20 M3_M2_CDNS_40661956134223
* cell instance $213 r0 *1 24.755,227.5
X$213 14 23 M3_M2_CDNS_40661956134223
* cell instance $214 r0 *1 37.445,227.5
X$214 14 24 M3_M2_CDNS_40661956134225
* cell instance $215 r0 *1 50.135,227.5
X$215 14 25 M3_M2_CDNS_40661956134223
* cell instance $216 r0 *1 61.985,227.5
X$216 14 26 M3_M2_CDNS_40661956134223
* cell instance $217 r0 *1 12.905,285.41
X$217 14 20 M2_M1_CDNS_40661956134218
* cell instance $218 r0 *1 37.445,285.41
X$218 14 19 M1_PSUB_CDNS_40661956134198
* cell instance $219 r0 *1 12.905,283.195
X$219 14 20 M3_M2_CDNS_40661956134180
* cell instance $220 r0 *1 24.755,285.41
X$220 14 23 M2_M1_CDNS_40661956134218
* cell instance $221 r0 *1 24.755,283.195
X$221 14 23 M3_M2_CDNS_40661956134180
* cell instance $222 r0 *1 37.445,285.41
X$222 14 24 M2_M1_CDNS_40661956134217
* cell instance $223 r0 *1 37.445,283.195
X$223 14 24 M3_M2_CDNS_40661956134224
* cell instance $224 r0 *1 50.135,285.41
X$224 14 25 M2_M1_CDNS_40661956134218
* cell instance $225 r0 *1 50.135,283.195
X$225 14 25 M3_M2_CDNS_40661956134180
* cell instance $226 r0 *1 61.985,285.41
X$226 14 26 M2_M1_CDNS_40661956134218
* cell instance $227 r0 *1 61.985,283.195
X$227 14 26 M3_M2_CDNS_40661956134180
* cell instance $228 r0 *1 12.905,266.75
X$228 14 20 M2_M1_CDNS_40661956134206
* cell instance $229 r0 *1 37.445,266.14
X$229 14 19 M1_PSUB_CDNS_40661956134198
* cell instance $230 r0 *1 12.905,267.5
X$230 14 20 M3_M2_CDNS_40661956134223
* cell instance $231 r0 *1 24.755,266.75
X$231 14 23 M2_M1_CDNS_40661956134206
* cell instance $232 r0 *1 24.755,267.5
X$232 14 23 M3_M2_CDNS_40661956134223
* cell instance $233 r0 *1 37.445,266.75
X$233 14 24 M2_M1_CDNS_40661956134207
* cell instance $234 r0 *1 37.445,267.5
X$234 14 24 M3_M2_CDNS_40661956134225
* cell instance $235 r0 *1 50.135,266.75
X$235 14 25 M2_M1_CDNS_40661956134206
* cell instance $236 r0 *1 50.135,267.5
X$236 14 25 M3_M2_CDNS_40661956134223
* cell instance $237 r0 *1 61.985,266.75
X$237 14 26 M2_M1_CDNS_40661956134206
* cell instance $238 r0 *1 61.985,267.5
X$238 14 26 M3_M2_CDNS_40661956134223
* cell instance $239 r0 *1 68.685,250.69
X$239 15 M1_PSUB_CDNS_40661956134230
* cell instance $240 r0 *1 74.65,259.5
X$240 15 27 M3_M2_CDNS_40661956134114
* cell instance $241 r0 *1 74.65,259.5
X$241 15 27 M2_M1_CDNS_40661956134115
* cell instance $242 r0 *1 6.205,250.69
X$242 16 M1_PSUB_CDNS_40661956134230
* cell instance $243 r0 *1 0.24,259.5
X$243 16 18 M2_M1_CDNS_40661956134115
* cell instance $244 r0 *1 0.24,259.5
X$244 16 18 M3_M2_CDNS_40661956134114
* cell instance $245 r0 *1 11.585,187.565
X$245 21 22 M3_M2_CDNS_40661956134219
* cell instance $246 r0 *1 11.585,259.495
X$246 21 22 M3_M2_CDNS_40661956134219
.ENDS GF_NI_DVDD_BASE

* cell GF_NI_DVSS_BASE
* pin
* pin
* pin
* pin DVSS
* pin
* pin
* pin
* pin
* pin
* pin DVDD
* pin
* pin
* pin VDD
* pin
* pin
* pin
* pin
* pin
* pin
* pin
* pin
* pin
* pin
* pin
* pin
* pin gf180mcu_gnd
.SUBCKT GF_NI_DVSS_BASE 1 3 4 5 6 7 8 9 10 16 23 24 25 26 28 31 34 36 38 39 41
+ 42 50 51 53 55
* net 5 DVSS
* net 16 DVDD
* net 25 VDD
* net 55 gf180mcu_gnd
* cell instance $1 r0 *1 0.24,15.5
X$1 1 2 M3_M2_CDNS_40661956134259
* cell instance $2 r0 *1 0.24,15.5
X$2 1 2 M2_M1_CDNS_40661956134258
* cell instance $3 r0 *1 0.24,47.5
X$3 1 14 M2_M1_CDNS_40661956134258
* cell instance $4 r0 *1 0.24,47.5
X$4 1 14 M3_M2_CDNS_40661956134259
* cell instance $5 r0 *1 0.24,175.5
X$5 1 21 M2_M1_CDNS_40661956134258
* cell instance $6 r0 *1 0.24,175.5
X$6 1 21 M3_M2_CDNS_40661956134259
* cell instance $7 r0 *1 0.24,31.5
X$7 1 12 M3_M2_CDNS_40661956134259
* cell instance $8 r0 *1 0.24,31.5
X$8 1 12 M2_M1_CDNS_40661956134258
* cell instance $9 r0 *1 2.455,109.62
X$9 1 M1_PSUB_CDNS_40661956134229
* cell instance $10 r0 *1 0.24,67.5
X$10 1 17 M2_M1_CDNS_40661956134115
* cell instance $11 r0 *1 0.24,67.5
X$11 1 17 M3_M2_CDNS_40661956134114
* cell instance $12 r0 *1 0.24,139.5
X$12 1 19 M3_M2_CDNS_40661956134114
* cell instance $13 r0 *1 0.24,139.5
X$13 1 19 M2_M1_CDNS_40661956134115
* cell instance $14 r0 *1 0.24,187.5
X$14 1 23 M3_M2_CDNS_40661956134114
* cell instance $15 r0 *1 0.24,187.5
X$15 1 23 M2_M1_CDNS_40661956134115
* cell instance $16 r0 *1 74.65,31.5
X$16 3 13 M2_M1_CDNS_40661956134258
* cell instance $17 r0 *1 74.65,31.5
X$17 3 13 M3_M2_CDNS_40661956134259
* cell instance $18 r0 *1 74.65,47.5
X$18 3 15 M2_M1_CDNS_40661956134258
* cell instance $19 r0 *1 74.65,47.5
X$19 3 15 M3_M2_CDNS_40661956134259
* cell instance $20 r0 *1 74.65,175.5
X$20 3 22 M3_M2_CDNS_40661956134259
* cell instance $21 r0 *1 74.65,175.5
X$21 3 22 M2_M1_CDNS_40661956134258
* cell instance $22 r0 *1 74.65,15.5
X$22 3 11 M3_M2_CDNS_40661956134259
* cell instance $23 r0 *1 74.65,15.5
X$23 3 11 M2_M1_CDNS_40661956134258
* cell instance $24 m90 *1 67.48,174.62
X$24 3 M1_PSUB_CDNS_40661956134228
* cell instance $25 m90 *1 72.435,109.62
X$25 3 M1_PSUB_CDNS_40661956134229
* cell instance $26 r0 *1 74.65,139.5
X$26 3 20 M2_M1_CDNS_40661956134115
* cell instance $27 r0 *1 74.65,139.5
X$27 3 20 M3_M2_CDNS_40661956134114
* cell instance $28 r0 *1 74.65,67.5
X$28 3 18 M2_M1_CDNS_40661956134115
* cell instance $29 r0 *1 74.65,67.5
X$29 3 18 M3_M2_CDNS_40661956134114
* cell instance $30 r0 *1 74.65,187.5
X$30 3 24 M2_M1_CDNS_40661956134115
* cell instance $31 r0 *1 74.65,187.5
X$31 3 24 M3_M2_CDNS_40661956134114
* cell instance $32 r0 *1 6.055,15.5
X$32 5 4 M3_M2_CDNS_40661956134156
* cell instance $33 r0 *1 5.04,5.45
X$33 5 38 4 45 46 6 7 48 8 47 9 49 10 55 comp018green_esd_clamp_v5p0_DVSS
* cell instance $34 r0 *1 6.055,31.5
X$34 5 4 M3_M2_CDNS_40661956134156
* cell instance $35 r0 *1 6.055,47.5
X$35 5 4 M3_M2_CDNS_40661956134156
* cell instance $36 r0 *1 6.055,67.5
X$36 5 4 M3_M2_CDNS_40661956134119
* cell instance $37 r0 *1 6.055,139.5
X$37 5 4 M3_M2_CDNS_40661956134119
* cell instance $38 r0 *1 6.055,175.5
X$38 5 4 M3_M2_CDNS_40661956134156
* cell instance $39 r0 *1 6.055,187.5
X$39 5 4 M3_M2_CDNS_40661956134119
* cell instance $40 r0 *1 6.055,227.5
X$40 5 4 M3_M2_CDNS_40661956134119
* cell instance $41 r0 *1 6.055,259.5
X$41 5 4 M3_M2_CDNS_40661956134119
* cell instance $42 r0 *1 6.055,243.5
X$42 5 4 M3_M2_CDNS_40661956134119
* cell instance $43 r0 *1 6.055,267.5
X$43 5 4 M3_M2_CDNS_40661956134119
* cell instance $44 r0 *1 7.445,266.745
X$44 5 4 M2_M1_CDNS_40661956134253
* cell instance $45 r0 *1 2.905,274.715
X$45 5 4 M2_M1_CDNS_40661956134264
* cell instance $46 r0 *1 6.055,283.195
X$46 5 4 M3_M2_CDNS_40661956134257
* cell instance $47 r0 *1 6.055,285.39
X$47 5 4 M2_M1_CDNS_40661956134252
* cell instance $48 r0 *1 6.055,287.365
X$48 5 4 M2_M1_CDNS_40661956134140
* cell instance $49 r0 *1 6.055,3.96
X$49 5 4 M2_M1_CDNS_40661956134140
* cell instance $50 m90 *1 58.425,248.355
X$50 5 30 M1_PSUB_CDNS_40661956134199
* cell instance $51 m90 *1 58.425,253.025
X$51 5 30 M1_PSUB_CDNS_40661956134199
* cell instance $52 r0 *1 16.465,248.355
X$52 5 30 M1_PSUB_CDNS_40661956134199
* cell instance $53 r0 *1 16.465,253.025
X$53 5 30 M1_PSUB_CDNS_40661956134199
* cell instance $54 r0 *1 18.83,243.5
X$54 5 6 M3_M2_CDNS_40661956134221
* cell instance $55 r0 *1 19.715,246.02
X$55 5 6 M2_M1_CDNS_40661956134251
* cell instance $56 r0 *1 15.695,250.69
X$56 5 30 M1_PSUB_CDNS_40661956134203
* cell instance $57 r0 *1 19.715,241.735
X$57 5 6 M2_M1_CDNS_40661956134152
* cell instance $58 r0 *1 37.445,241.35
X$58 5 30 M1_PSUB_CDNS_40661956134202
* cell instance $59 r0 *1 16.465,243.685
X$59 5 30 M1_PSUB_CDNS_40661956134199
* cell instance $60 r0 *1 37.445,245.25
X$60 5 30 M1_PSUB_CDNS_40661956134200
* cell instance $61 r0 *1 37.445,242.12
X$61 5 30 M1_PSUB_CDNS_40661956134200
* cell instance $62 r0 *1 30.68,246.02
X$62 5 7 M2_M1_CDNS_40661956134247
* cell instance $63 r0 *1 30.68,241.735
X$63 5 7 M2_M1_CDNS_40661956134255
* cell instance $64 r0 *1 30.68,243.5
X$64 5 7 M3_M2_CDNS_40661956134221
* cell instance $65 r0 *1 44.21,241.735
X$65 5 8 M2_M1_CDNS_40661956134255
* cell instance $66 r0 *1 44.21,246.02
X$66 5 8 M2_M1_CDNS_40661956134247
* cell instance $67 m90 *1 44.21,243.5
X$67 5 8 M3_M2_CDNS_40661956134221
* cell instance $68 m90 *1 55.175,241.735
X$68 5 9 M2_M1_CDNS_40661956134152
* cell instance $69 m90 *1 55.175,246.02
X$69 5 9 M2_M1_CDNS_40661956134251
* cell instance $70 m90 *1 56.06,243.5
X$70 5 9 M3_M2_CDNS_40661956134221
* cell instance $71 m90 *1 58.425,243.685
X$71 5 30 M1_PSUB_CDNS_40661956134199
* cell instance $72 m90 *1 59.195,250.69
X$72 5 30 M1_PSUB_CDNS_40661956134203
* cell instance $73 r0 *1 19.715,255.36
X$73 5 6 M2_M1_CDNS_40661956134251
* cell instance $74 r0 *1 19.715,250.69
X$74 5 6 M2_M1_CDNS_40661956134251
* cell instance $75 r0 *1 37.445,250.69
X$75 5 30 M1_PSUB_CDNS_40661956134201
* cell instance $76 r0 *1 37.445,246.02
X$76 5 30 M1_PSUB_CDNS_40661956134201
* cell instance $77 r0 *1 37.445,251.46
X$77 5 30 M1_PSUB_CDNS_40661956134200
* cell instance $78 r0 *1 37.445,249.92
X$78 5 30 M1_PSUB_CDNS_40661956134200
* cell instance $79 r0 *1 37.445,254.59
X$79 5 30 M1_PSUB_CDNS_40661956134200
* cell instance $80 r0 *1 37.445,246.79
X$80 5 30 M1_PSUB_CDNS_40661956134200
* cell instance $81 r0 *1 30.68,250.69
X$81 5 7 M2_M1_CDNS_40661956134247
* cell instance $82 r0 *1 30.68,255.36
X$82 5 7 M2_M1_CDNS_40661956134247
* cell instance $83 r0 *1 44.21,255.36
X$83 5 8 M2_M1_CDNS_40661956134247
* cell instance $84 r0 *1 44.21,250.69
X$84 5 8 M2_M1_CDNS_40661956134247
* cell instance $85 m90 *1 55.175,255.36
X$85 5 9 M2_M1_CDNS_40661956134251
* cell instance $86 m90 *1 55.175,250.69
X$86 5 9 M2_M1_CDNS_40661956134251
* cell instance $87 r0 *1 37.445,255.36
X$87 5 30 M1_PSUB_CDNS_40661956134201
* cell instance $88 r0 *1 37.445,256.13
X$88 5 30 M1_PSUB_CDNS_40661956134200
* cell instance $89 r0 *1 19.715,259.645
X$89 5 6 M2_M1_CDNS_40661956134152
* cell instance $90 r0 *1 18.83,259.5
X$90 5 6 M3_M2_CDNS_40661956134221
* cell instance $91 m0 *1 37.445,260.03
X$91 5 30 M1_PSUB_CDNS_40661956134202
* cell instance $92 r0 *1 16.465,257.695
X$92 5 30 M1_PSUB_CDNS_40661956134199
* cell instance $93 m0 *1 37.445,259.26
X$93 5 30 M1_PSUB_CDNS_40661956134200
* cell instance $94 r0 *1 30.68,259.645
X$94 5 7 M2_M1_CDNS_40661956134255
* cell instance $95 r0 *1 30.68,259.5
X$95 5 7 M3_M2_CDNS_40661956134221
* cell instance $96 r0 *1 44.21,259.645
X$96 5 8 M2_M1_CDNS_40661956134255
* cell instance $97 m90 *1 44.21,259.5
X$97 5 8 M3_M2_CDNS_40661956134221
* cell instance $98 m90 *1 55.175,259.645
X$98 5 9 M2_M1_CDNS_40661956134152
* cell instance $99 m90 *1 56.06,259.5
X$99 5 9 M3_M2_CDNS_40661956134221
* cell instance $100 m90 *1 58.425,257.695
X$100 5 30 M1_PSUB_CDNS_40661956134199
* cell instance $101 r0 *1 18.83,15.5
X$101 5 6 M3_M2_CDNS_40661956134222
* cell instance $102 r0 *1 30.68,15.5
X$102 5 7 M3_M2_CDNS_40661956134222
* cell instance $103 m90 *1 44.21,15.5
X$103 5 8 M3_M2_CDNS_40661956134222
* cell instance $104 m90 *1 56.06,15.5
X$104 5 9 M3_M2_CDNS_40661956134222
* cell instance $105 m90 *1 68.835,15.5
X$105 5 10 M3_M2_CDNS_40661956134156
* cell instance $106 r0 *1 18.83,31.5
X$106 5 6 M3_M2_CDNS_40661956134222
* cell instance $107 r0 *1 30.68,31.5
X$107 5 7 M3_M2_CDNS_40661956134222
* cell instance $108 m90 *1 44.21,31.5
X$108 5 8 M3_M2_CDNS_40661956134222
* cell instance $109 m90 *1 56.06,31.5
X$109 5 9 M3_M2_CDNS_40661956134222
* cell instance $110 m90 *1 68.835,31.5
X$110 5 10 M3_M2_CDNS_40661956134156
* cell instance $111 r0 *1 18.83,47.5
X$111 5 6 M3_M2_CDNS_40661956134222
* cell instance $112 r0 *1 30.68,47.5
X$112 5 7 M3_M2_CDNS_40661956134222
* cell instance $113 m90 *1 44.21,47.5
X$113 5 8 M3_M2_CDNS_40661956134222
* cell instance $114 m90 *1 56.06,47.5
X$114 5 9 M3_M2_CDNS_40661956134222
* cell instance $115 m90 *1 68.835,47.5
X$115 5 10 M3_M2_CDNS_40661956134156
* cell instance $116 r0 *1 18.83,67.5
X$116 5 6 M3_M2_CDNS_40661956134221
* cell instance $117 r0 *1 30.68,67.5
X$117 5 7 M3_M2_CDNS_40661956134221
* cell instance $118 m90 *1 44.21,67.5
X$118 5 8 M3_M2_CDNS_40661956134221
* cell instance $119 m90 *1 56.06,67.5
X$119 5 9 M3_M2_CDNS_40661956134221
* cell instance $120 m90 *1 68.835,67.5
X$120 5 10 M3_M2_CDNS_40661956134119
* cell instance $121 r0 *1 18.83,139.5
X$121 5 6 M3_M2_CDNS_40661956134221
* cell instance $122 r0 *1 30.68,139.5
X$122 5 7 M3_M2_CDNS_40661956134221
* cell instance $123 m90 *1 44.21,139.5
X$123 5 8 M3_M2_CDNS_40661956134221
* cell instance $124 m90 *1 56.06,139.5
X$124 5 9 M3_M2_CDNS_40661956134221
* cell instance $125 m90 *1 68.835,139.5
X$125 5 10 M3_M2_CDNS_40661956134119
* cell instance $126 r0 *1 18.83,175.5
X$126 5 6 M3_M2_CDNS_40661956134222
* cell instance $127 r0 *1 30.68,175.5
X$127 5 7 M3_M2_CDNS_40661956134222
* cell instance $128 m90 *1 44.21,175.5
X$128 5 8 M3_M2_CDNS_40661956134222
* cell instance $129 m90 *1 56.06,175.5
X$129 5 9 M3_M2_CDNS_40661956134222
* cell instance $130 m90 *1 68.835,175.5
X$130 5 10 M3_M2_CDNS_40661956134156
* cell instance $131 r0 *1 18.83,187.5
X$131 5 6 M3_M2_CDNS_40661956134221
* cell instance $132 r0 *1 30.68,187.5
X$132 5 7 M3_M2_CDNS_40661956134221
* cell instance $133 m90 *1 44.21,187.5
X$133 5 8 M3_M2_CDNS_40661956134221
* cell instance $134 m90 *1 56.06,187.5
X$134 5 9 M3_M2_CDNS_40661956134221
* cell instance $135 m90 *1 68.835,187.5
X$135 5 10 M3_M2_CDNS_40661956134119
* cell instance $136 r0 *1 18.83,227.5
X$136 5 6 M3_M2_CDNS_40661956134221
* cell instance $137 r0 *1 30.68,227.5
X$137 5 7 M3_M2_CDNS_40661956134221
* cell instance $138 m90 *1 44.21,227.5
X$138 5 8 M3_M2_CDNS_40661956134221
* cell instance $139 m90 *1 56.06,227.5
X$139 5 9 M3_M2_CDNS_40661956134221
* cell instance $140 m90 *1 68.835,227.5
X$140 5 10 M3_M2_CDNS_40661956134119
* cell instance $141 m90 *1 68.835,259.5
X$141 5 10 M3_M2_CDNS_40661956134119
* cell instance $142 m90 *1 68.835,243.5
X$142 5 10 M3_M2_CDNS_40661956134119
* cell instance $143 r0 *1 37.445,266.14
X$143 5 44 M1_PSUB_CDNS_40661956134198
* cell instance $144 r0 *1 16.375,266.745
X$144 5 6 M2_M1_CDNS_40661956134145
* cell instance $145 r0 *1 18.83,267.5
X$145 5 6 M3_M2_CDNS_40661956134221
* cell instance $146 m90 *1 30.68,266.745
X$146 5 7 M2_M1_CDNS_40661956134247
* cell instance $147 r0 *1 30.68,267.5
X$147 5 7 M3_M2_CDNS_40661956134221
* cell instance $148 m90 *1 44.21,266.745
X$148 5 8 M2_M1_CDNS_40661956134247
* cell instance $149 m90 *1 44.21,267.5
X$149 5 8 M3_M2_CDNS_40661956134221
* cell instance $150 m90 *1 58.515,266.745
X$150 5 9 M2_M1_CDNS_40661956134145
* cell instance $151 m90 *1 56.06,267.5
X$151 5 9 M3_M2_CDNS_40661956134221
* cell instance $152 m90 *1 67.445,266.745
X$152 5 10 M2_M1_CDNS_40661956134253
* cell instance $153 m90 *1 68.835,267.5
X$153 5 10 M3_M2_CDNS_40661956134119
* cell instance $154 r0 *1 1.895,275.775
X$154 5 44 M1_PSUB_CDNS_40661956134197
* cell instance $155 r0 *1 4.175,268.275
X$155 5 38 nmoscap_6p0_CDNS_406619561348
* cell instance $156 r0 *1 20.265,274.715
X$156 5 6 M2_M1_CDNS_40661956134263
* cell instance $157 r0 *1 21.355,268.275
X$157 5 38 nmoscap_6p0_CDNS_406619561348
* cell instance $158 r0 *1 38.535,268.275
X$158 5 38 nmoscap_6p0_CDNS_406619561348
* cell instance $159 m90 *1 54.625,274.715
X$159 5 9 M2_M1_CDNS_40661956134263
* cell instance $160 r0 *1 55.715,268.275
X$160 5 38 nmoscap_6p0_CDNS_406619561348
* cell instance $161 m90 *1 71.985,274.715
X$161 5 10 M2_M1_CDNS_40661956134264
* cell instance $162 r0 *1 72.995,275.775
X$162 5 44 M1_PSUB_CDNS_40661956134197
* cell instance $163 r0 *1 37.445,285.41
X$163 5 44 M1_PSUB_CDNS_40661956134198
* cell instance $164 r0 *1 18.83,285.39
X$164 5 6 M2_M1_CDNS_40661956134249
* cell instance $165 r0 *1 18.83,283.195
X$165 5 6 M3_M2_CDNS_40661956134262
* cell instance $166 m90 *1 30.68,285.39
X$166 5 7 M2_M1_CDNS_40661956134249
* cell instance $167 r0 *1 30.68,283.195
X$167 5 7 M3_M2_CDNS_40661956134262
* cell instance $168 m90 *1 44.21,285.39
X$168 5 8 M2_M1_CDNS_40661956134249
* cell instance $169 m90 *1 44.21,283.195
X$169 5 8 M3_M2_CDNS_40661956134262
* cell instance $170 m90 *1 56.06,285.39
X$170 5 9 M2_M1_CDNS_40661956134249
* cell instance $171 m90 *1 56.06,283.195
X$171 5 9 M3_M2_CDNS_40661956134262
* cell instance $172 m90 *1 68.835,285.39
X$172 5 10 M2_M1_CDNS_40661956134252
* cell instance $173 m90 *1 68.835,283.195
X$173 5 10 M3_M2_CDNS_40661956134257
* cell instance $174 r0 *1 56.06,3.96
X$174 5 9 M2_M1_CDNS_40661956134140
* cell instance $175 r0 *1 68.835,3.96
X$175 5 10 M2_M1_CDNS_40661956134140
* cell instance $176 r0 *1 44.21,3.96
X$176 5 8 M2_M1_CDNS_40661956134140
* cell instance $177 r0 *1 30.68,287.365
X$177 5 7 M2_M1_CDNS_40661956134140
* cell instance $178 r0 *1 18.83,287.365
X$178 5 6 M2_M1_CDNS_40661956134140
* cell instance $179 r0 *1 30.68,3.96
X$179 5 7 M2_M1_CDNS_40661956134140
* cell instance $180 r0 *1 18.83,3.96
X$180 5 6 M2_M1_CDNS_40661956134140
* cell instance $181 r0 *1 68.835,287.365
X$181 5 10 M2_M1_CDNS_40661956134140
* cell instance $182 r0 *1 44.21,287.365
X$182 5 8 M2_M1_CDNS_40661956134140
* cell instance $183 r0 *1 56.06,287.365
X$183 5 9 M2_M1_CDNS_40661956134140
* cell instance $184 r0 *1 0.24,227.5
X$184 26 27 M2_M1_CDNS_40661956134115
* cell instance $185 r0 *1 0.24,227.5
X$185 26 27 M3_M2_CDNS_40661956134114
* cell instance $186 r0 *1 74.65,227.5
X$186 28 29 M3_M2_CDNS_40661956134114
* cell instance $187 r0 *1 74.65,227.5
X$187 28 29 M2_M1_CDNS_40661956134115
* cell instance $188 r0 *1 6.205,250.69
X$188 31 M1_PSUB_CDNS_40661956134230
* cell instance $189 r0 *1 0.24,243.5
X$189 31 32 M2_M1_CDNS_40661956134115
* cell instance $190 r0 *1 0.24,243.5
X$190 31 32 M3_M2_CDNS_40661956134114
* cell instance $191 r0 *1 0.24,259.5
X$191 31 41 M2_M1_CDNS_40661956134115
* cell instance $192 r0 *1 0.24,259.5
X$192 31 41 M3_M2_CDNS_40661956134114
* cell instance $193 r0 *1 74.65,243.5
X$193 34 33 M2_M1_CDNS_40661956134115
* cell instance $194 r0 *1 74.65,243.5
X$194 34 33 M3_M2_CDNS_40661956134114
* cell instance $195 m90 *1 68.685,250.69
X$195 34 M1_PSUB_CDNS_40661956134230
* cell instance $196 r0 *1 74.65,259.5
X$196 34 50 M2_M1_CDNS_40661956134115
* cell instance $197 r0 *1 74.65,259.5
X$197 34 50 M3_M2_CDNS_40661956134114
* cell instance $198 r0 *1 37.445,262.19
X$198 38 38 56 35 M1_NWELL_CDNS_40661956134205
* cell instance $199 r0 *1 37.445,239.19
X$199 38 38 56 35 M1_NWELL_CDNS_40661956134205
* cell instance $200 r0 *1 13.675,250.69
X$200 38 35 38 56 M1_NWELL_CDNS_40661956134204
* cell instance $201 r0 *1 61.215,250.69
X$201 38 35 38 56 M1_NWELL_CDNS_40661956134204
* cell instance $202 r0 *1 11.65,251.52
X$202 36 37 M3_M2_CDNS_40661956134219
* cell instance $203 r0 *1 11.65,195.525
X$203 36 37 M3_M2_CDNS_40661956134219
* cell instance $204 r0 *1 50.135,275.775
X$204 38 47 M2_M1_CDNS_40661956134254
* cell instance $205 m90 *1 50.135,275.5
X$205 38 47 M3_M2_CDNS_40661956134223
* cell instance $206 r0 *1 24.755,275.775
X$206 38 46 M2_M1_CDNS_40661956134254
* cell instance $207 r0 *1 24.755,275.5
X$207 38 46 M3_M2_CDNS_40661956134223
* cell instance $208 r0 *1 37.445,275.5
X$208 38 48 M3_M2_CDNS_40661956134225
* cell instance $209 m90 *1 61.985,275.5
X$209 38 49 M3_M2_CDNS_40661956134223
* cell instance $210 r0 *1 12.905,59.5
X$210 38 45 M3_M2_CDNS_40661956134223
* cell instance $211 r0 *1 24.755,59.5
X$211 38 46 M3_M2_CDNS_40661956134223
* cell instance $212 r0 *1 37.445,59.5
X$212 38 48 M3_M2_CDNS_40661956134225
* cell instance $213 m90 *1 50.135,59.5
X$213 38 47 M3_M2_CDNS_40661956134223
* cell instance $214 m90 *1 61.985,59.5
X$214 38 49 M3_M2_CDNS_40661956134223
* cell instance $215 r0 *1 12.905,111.5
X$215 38 45 M3_M2_CDNS_40661956134226
* cell instance $216 r0 *1 12.905,95.5
X$216 38 45 M3_M2_CDNS_40661956134226
* cell instance $217 r0 *1 12.905,79.5
X$217 38 45 M3_M2_CDNS_40661956134226
* cell instance $218 r0 *1 24.755,111.5
X$218 38 46 M3_M2_CDNS_40661956134226
* cell instance $219 r0 *1 24.755,95.5
X$219 38 46 M3_M2_CDNS_40661956134226
* cell instance $220 r0 *1 24.755,79.5
X$220 38 46 M3_M2_CDNS_40661956134226
* cell instance $221 r0 *1 37.445,79.5
X$221 38 48 M3_M2_CDNS_40661956134227
* cell instance $222 r0 *1 37.445,111.5
X$222 38 48 M3_M2_CDNS_40661956134227
* cell instance $223 r0 *1 37.445,95.5
X$223 38 48 M3_M2_CDNS_40661956134227
* cell instance $224 m90 *1 50.135,79.5
X$224 38 47 M3_M2_CDNS_40661956134226
* cell instance $225 m90 *1 50.135,95.5
X$225 38 47 M3_M2_CDNS_40661956134226
* cell instance $226 m90 *1 50.135,111.5
X$226 38 47 M3_M2_CDNS_40661956134226
* cell instance $227 m90 *1 61.985,79.5
X$227 38 49 M3_M2_CDNS_40661956134226
* cell instance $228 m90 *1 61.985,95.5
X$228 38 49 M3_M2_CDNS_40661956134226
* cell instance $229 m90 *1 61.985,111.5
X$229 38 49 M3_M2_CDNS_40661956134226
* cell instance $230 r0 *1 12.905,127.5
X$230 38 45 M3_M2_CDNS_40661956134226
* cell instance $231 r0 *1 24.755,127.5
X$231 38 46 M3_M2_CDNS_40661956134226
* cell instance $232 r0 *1 37.445,127.5
X$232 38 48 M3_M2_CDNS_40661956134227
* cell instance $233 m90 *1 50.135,127.5
X$233 38 47 M3_M2_CDNS_40661956134226
* cell instance $234 m90 *1 61.985,127.5
X$234 38 49 M3_M2_CDNS_40661956134226
* cell instance $235 r0 *1 12.905,147.5
X$235 38 45 M3_M2_CDNS_40661956134223
* cell instance $236 r0 *1 24.755,147.5
X$236 38 46 M3_M2_CDNS_40661956134223
* cell instance $237 r0 *1 37.445,147.5
X$237 38 48 M3_M2_CDNS_40661956134225
* cell instance $238 m90 *1 50.135,147.5
X$238 38 47 M3_M2_CDNS_40661956134223
* cell instance $239 m90 *1 61.985,147.5
X$239 38 49 M3_M2_CDNS_40661956134223
* cell instance $240 r0 *1 12.905,159.5
X$240 38 45 M3_M2_CDNS_40661956134226
* cell instance $241 r0 *1 24.755,159.5
X$241 38 46 M3_M2_CDNS_40661956134226
* cell instance $242 r0 *1 37.445,159.5
X$242 38 48 M3_M2_CDNS_40661956134227
* cell instance $243 m90 *1 50.135,159.5
X$243 38 47 M3_M2_CDNS_40661956134226
* cell instance $244 m90 *1 61.985,159.5
X$244 38 49 M3_M2_CDNS_40661956134226
* cell instance $245 r0 *1 12.905,203.5
X$245 38 45 M3_M2_CDNS_40661956134223
* cell instance $246 r0 *1 24.755,203.5
X$246 38 46 M3_M2_CDNS_40661956134223
* cell instance $247 r0 *1 37.445,203.5
X$247 38 48 M3_M2_CDNS_40661956134225
* cell instance $248 m90 *1 50.135,203.5
X$248 38 47 M3_M2_CDNS_40661956134223
* cell instance $249 m90 *1 61.985,203.5
X$249 38 49 M3_M2_CDNS_40661956134223
* cell instance $250 r0 *1 12.905,219.5
X$250 38 45 M3_M2_CDNS_40661956134223
* cell instance $251 r0 *1 12.905,211.5
X$251 38 45 M3_M2_CDNS_40661956134223
* cell instance $252 r0 *1 24.755,219.5
X$252 38 46 M3_M2_CDNS_40661956134223
* cell instance $253 r0 *1 24.755,211.5
X$253 38 46 M3_M2_CDNS_40661956134223
* cell instance $254 r0 *1 37.445,219.5
X$254 38 48 M3_M2_CDNS_40661956134225
* cell instance $255 r0 *1 37.445,211.5
X$255 38 48 M3_M2_CDNS_40661956134225
* cell instance $256 m90 *1 50.135,211.5
X$256 38 47 M3_M2_CDNS_40661956134223
* cell instance $257 m90 *1 50.135,219.5
X$257 38 47 M3_M2_CDNS_40661956134223
* cell instance $258 m90 *1 61.985,211.5
X$258 38 49 M3_M2_CDNS_40661956134223
* cell instance $259 m90 *1 61.985,219.5
X$259 38 49 M3_M2_CDNS_40661956134223
* cell instance $260 r0 *1 12.905,235.5
X$260 38 45 M3_M2_CDNS_40661956134223
* cell instance $261 r0 *1 13.08,250.69
X$261 38 45 M2_M1_CDNS_40661956134256
* cell instance $262 r0 *1 24.755,235.5
X$262 38 46 M3_M2_CDNS_40661956134223
* cell instance $263 r0 *1 37.445,235.5
X$263 38 48 M3_M2_CDNS_40661956134225
* cell instance $264 m90 *1 50.135,235.5
X$264 38 47 M3_M2_CDNS_40661956134223
* cell instance $265 m90 *1 61.985,235.5
X$265 38 49 M3_M2_CDNS_40661956134223
* cell instance $266 r0 *1 61.81,250.69
X$266 38 49 M2_M1_CDNS_40661956134256
* cell instance $267 r0 *1 24.755,239.19
X$267 38 46 M2_M1_CDNS_40661956134206
* cell instance $268 r0 *1 37.445,239.19
X$268 38 48 M2_M1_CDNS_40661956134207
* cell instance $269 r0 *1 50.135,239.19
X$269 38 47 M2_M1_CDNS_40661956134206
* cell instance $270 r0 *1 12.905,275.5
X$270 38 45 M3_M2_CDNS_40661956134223
* cell instance $271 r0 *1 24.755,257.695
X$271 38 46 M2_M1_CDNS_40661956134126
* cell instance $272 r0 *1 17.445,257.195
X$272 38 np_6p0_CDNS_406619561349
* cell instance $273 r0 *1 37.445,257.695
X$273 38 48 M2_M1_CDNS_40661956134250
* cell instance $274 r0 *1 50.135,257.695
X$274 38 47 M2_M1_CDNS_40661956134126
* cell instance $275 r0 *1 24.755,248.355
X$275 38 46 M2_M1_CDNS_40661956134126
* cell instance $276 r0 *1 17.445,247.855
X$276 38 np_6p0_CDNS_406619561349
* cell instance $277 r0 *1 37.445,248.355
X$277 38 48 M2_M1_CDNS_40661956134250
* cell instance $278 r0 *1 50.135,248.355
X$278 38 47 M2_M1_CDNS_40661956134126
* cell instance $279 r0 *1 24.755,243.685
X$279 38 46 M2_M1_CDNS_40661956134126
* cell instance $280 r0 *1 17.445,243.185
X$280 38 np_6p0_CDNS_406619561349
* cell instance $281 r0 *1 37.445,243.685
X$281 38 48 M2_M1_CDNS_40661956134250
* cell instance $282 r0 *1 50.135,243.685
X$282 38 47 M2_M1_CDNS_40661956134126
* cell instance $283 r0 *1 24.755,253.025
X$283 38 46 M2_M1_CDNS_40661956134126
* cell instance $284 r0 *1 17.445,252.525
X$284 38 np_6p0_CDNS_406619561349
* cell instance $285 r0 *1 37.445,253.025
X$285 38 48 M2_M1_CDNS_40661956134250
* cell instance $286 r0 *1 50.135,253.025
X$286 38 47 M2_M1_CDNS_40661956134126
* cell instance $287 r0 *1 61.985,267.975
X$287 38 49 M2_M1_CDNS_40661956134218
* cell instance $288 r0 *1 61.985,283.575
X$288 38 49 M2_M1_CDNS_40661956134218
* cell instance $289 r0 *1 12.905,267.975
X$289 38 45 M2_M1_CDNS_40661956134218
* cell instance $290 r0 *1 12.905,283.575
X$290 38 45 M2_M1_CDNS_40661956134218
* cell instance $291 r0 *1 24.755,262.19
X$291 38 46 M2_M1_CDNS_40661956134206
* cell instance $292 r0 *1 37.445,262.19
X$292 38 48 M2_M1_CDNS_40661956134207
* cell instance $293 r0 *1 50.135,262.19
X$293 38 47 M2_M1_CDNS_40661956134206
* cell instance $294 r0 *1 0.24,267.5
X$294 39 40 M3_M2_CDNS_40661956134114
* cell instance $295 r0 *1 0.24,267.5
X$295 39 40 M2_M1_CDNS_40661956134115
* cell instance $296 r0 *1 0.24,283.195
X$296 42 43 M2_M1_CDNS_40661956134261
* cell instance $297 r0 *1 0.24,283.195
X$297 42 43 M3_M2_CDNS_40661956134260
* cell instance $298 r0 *1 74.65,283.195
X$298 51 54 M3_M2_CDNS_40661956134260
* cell instance $299 r0 *1 74.65,283.195
X$299 51 54 M2_M1_CDNS_40661956134261
* cell instance $300 r0 *1 74.65,267.5
X$300 53 52 M3_M2_CDNS_40661956134114
* cell instance $301 r0 *1 74.65,267.5
X$301 53 52 M2_M1_CDNS_40661956134115
.ENDS GF_NI_DVSS_BASE

* cell GF_NI_COR_BASE
* pin DVSS
* pin DVDD
* pin
* pin
* pin VDD
* pin
* pin gf180mcu_gnd
* pin
* pin VSS
* pin
* pin
* pin
* pin
* pin
* pin
* pin
* pin
* pin
* pin
* pin
* pin
* pin
* pin
* pin
.SUBCKT GF_NI_COR_BASE 1 2 3 4 5 6 7 8 9 10 11 12 13 14 15 16 17 18 19 20 21 24
+ 26 28
* net 1 DVSS
* net 2 DVDD
* net 5 VDD
* net 7 gf180mcu_gnd
* net 9 VSS
* cell instance $1 r0 *1 302.78,344.52
X$1 4 28 27 4 4 4 4 17 3 26 25 3 25 25 3 3 3 25 24 3 20 18 6 6 6 19 6 19 21 6 6
+ 18 18 18 3 20 3 3 20 18 18 20 3 24 3 3 3 4 3 3 26 24 24 24 26 26 24 24 4 4 4
+ 3 4 3 3 4 4 4 3 3 3 4 4 4 moscap_routing
* cell instance $2 r0 *1 106.05,215.665
X$2 25 3 20 18 moscap_corner
* cell instance $3 r0 *1 157.75,215.665
X$3 25 3 20 18 moscap_corner
* cell instance $4 r0 *1 209.45,215.665
X$4 25 3 20 18 moscap_corner
* cell instance $5 r0 *1 54.35,215.665
X$5 25 3 20 18 moscap_corner_1
* cell instance $6 r0 *1 126.49,143.515
X$6 3 25 26 24 moscap_corner_2
* cell instance $7 r0 *1 178.19,143.515
X$7 25 3 26 24 moscap_corner
* cell instance $8 r0 *1 229.89,143.515
X$8 25 3 26 24 moscap_corner
* cell instance $9 r0 *1 176.85,81.755
X$9 4 27 28 28 moscap_corner_3
* cell instance $10 r0 *1 229.89,81.755
X$10 23 4 28 28 moscap_corner
* cell instance $11 r0 *1 67.5,67.5
X$11 7 16 15 14 13 8 9 11 10 12 5 ESD_CLAMP_COR
* cell instance $12 r0 *1 299.385,283.635
X$12 22 6 21 19 moscap_corner
* cell instance $13 r0 *1 324.195,348.715
X$13 6 22 M1_PSUB_CDNS_406619561348
.ENDS GF_NI_COR_BASE

* cell POWER_RAIL_COR
* pin
* pin
* pin DVSS
* pin DVDD
* pin VSS
* pin VDD
.SUBCKT POWER_RAIL_COR 1 2 3 4 5 6
* net 3 DVSS
* net 4 DVDD
* net 5 VSS
* net 6 VDD
* cell instance $1 r180 *1 290.035,65.97
X$1 2 1 M1_PSUB_CDNS_406619561340
* cell instance $2 r0 *1 224.365,66.165
X$2 2 1 M1_PSUB_CDNS_406619561345
* cell instance $3 r90 *1 65.97,290.02
X$3 2 1 M1_PSUB_CDNS_406619561344
* cell instance $4 r90 *1 354.495,208.245
X$4 2 1 M1_PSUB_CDNS_406619561343
* cell instance $5 r0 *1 351.175,349.355
X$5 2 1 M1_PSUB_CDNS_406619561342
* cell instance $6 r90 *1 349.355,351.925
X$6 2 1 M1_PSUB_CDNS_406619561341
* cell instance $7 r0 *1 208.18,354.5
X$7 2 1 M1_PSUB_CDNS_406619561343
* cell instance $8 r0 *1 126.445,163.945
X$8 2 1 M1_PSUB_CDNS_406619561345
* cell instance $9 r0 *1 105.985,184.405
X$9 2 1 M1_PSUB_CDNS_406619561345
* cell instance $10 r0 *1 127.105,163.285
X$10 2 1 M1_PSUB_CDNS_406619561345
* cell instance $11 r0 *1 127.765,162.625
X$11 2 1 M1_PSUB_CDNS_406619561345
* cell instance $12 r0 *1 128.425,161.965
X$12 2 1 M1_PSUB_CDNS_406619561345
* cell instance $13 r0 *1 129.745,160.645
X$13 2 1 M1_PSUB_CDNS_406619561345
* cell instance $14 r0 *1 130.405,159.985
X$14 2 1 M1_PSUB_CDNS_406619561345
* cell instance $15 r0 *1 131.065,159.325
X$15 2 1 M1_PSUB_CDNS_406619561345
* cell instance $16 r0 *1 131.725,158.665
X$16 2 1 M1_PSUB_CDNS_406619561345
* cell instance $17 r0 *1 132.385,158.005
X$17 2 1 M1_PSUB_CDNS_406619561345
* cell instance $18 r0 *1 133.045,157.345
X$18 2 1 M1_PSUB_CDNS_406619561345
* cell instance $19 r0 *1 133.705,156.685
X$19 2 1 M1_PSUB_CDNS_406619561345
* cell instance $20 r0 *1 129.085,161.305
X$20 2 1 M1_PSUB_CDNS_406619561345
* cell instance $21 r0 *1 125.785,164.605
X$21 2 1 M1_PSUB_CDNS_406619561345
* cell instance $22 r0 *1 135.025,155.365
X$22 2 1 M1_PSUB_CDNS_406619561345
* cell instance $23 r0 *1 85.525,204.865
X$23 2 1 M1_PSUB_CDNS_406619561345
* cell instance $24 r0 *1 84.205,206.185
X$24 2 1 M1_PSUB_CDNS_406619561345
* cell instance $25 r0 *1 83.545,206.845
X$25 2 1 M1_PSUB_CDNS_406619561345
* cell instance $26 r0 *1 82.885,207.505
X$26 2 1 M1_PSUB_CDNS_406619561345
* cell instance $27 r0 *1 82.225,208.165
X$27 2 1 M1_PSUB_CDNS_406619561345
* cell instance $28 r0 *1 81.565,208.825
X$28 2 1 M1_PSUB_CDNS_406619561345
* cell instance $29 r0 *1 80.905,209.485
X$29 2 1 M1_PSUB_CDNS_406619561345
* cell instance $30 r0 *1 95.425,194.965
X$30 2 1 M1_PSUB_CDNS_406619561345
* cell instance $31 r0 *1 104.665,185.725
X$31 2 1 M1_PSUB_CDNS_406619561345
* cell instance $32 r0 *1 104.005,186.385
X$32 2 1 M1_PSUB_CDNS_406619561345
* cell instance $33 r0 *1 103.345,187.045
X$33 2 1 M1_PSUB_CDNS_406619561345
* cell instance $34 r0 *1 102.685,187.705
X$34 2 1 M1_PSUB_CDNS_406619561345
* cell instance $35 r0 *1 101.365,189.025
X$35 2 1 M1_PSUB_CDNS_406619561345
* cell instance $36 r0 *1 134.365,156.025
X$36 2 1 M1_PSUB_CDNS_406619561345
* cell instance $37 r0 *1 114.565,175.825
X$37 2 1 M1_PSUB_CDNS_406619561345
* cell instance $38 r0 *1 113.245,177.145
X$38 2 1 M1_PSUB_CDNS_406619561345
* cell instance $39 r0 *1 112.585,177.805
X$39 2 1 M1_PSUB_CDNS_406619561345
* cell instance $40 r0 *1 111.925,178.465
X$40 2 1 M1_PSUB_CDNS_406619561345
* cell instance $41 r0 *1 111.265,179.125
X$41 2 1 M1_PSUB_CDNS_406619561345
* cell instance $42 r0 *1 110.605,179.785
X$42 2 1 M1_PSUB_CDNS_406619561345
* cell instance $43 r0 *1 109.945,180.445
X$43 2 1 M1_PSUB_CDNS_406619561345
* cell instance $44 r0 *1 109.285,181.105
X$44 2 1 M1_PSUB_CDNS_406619561345
* cell instance $45 r0 *1 108.625,181.765
X$45 2 1 M1_PSUB_CDNS_406619561345
* cell instance $46 r0 *1 107.965,182.425
X$46 2 1 M1_PSUB_CDNS_406619561345
* cell instance $47 r0 *1 107.305,183.085
X$47 2 1 M1_PSUB_CDNS_406619561345
* cell instance $48 r0 *1 106.645,183.745
X$48 2 1 M1_PSUB_CDNS_406619561345
* cell instance $49 r0 *1 105.325,185.065
X$49 2 1 M1_PSUB_CDNS_406619561345
* cell instance $50 r0 *1 102.025,188.365
X$50 2 1 M1_PSUB_CDNS_406619561345
* cell instance $51 r0 *1 92.785,197.605
X$51 2 1 M1_PSUB_CDNS_406619561345
* cell instance $52 r0 *1 92.125,198.265
X$52 2 1 M1_PSUB_CDNS_406619561345
* cell instance $53 r0 *1 91.465,198.925
X$53 2 1 M1_PSUB_CDNS_406619561345
* cell instance $54 r0 *1 90.805,199.585
X$54 2 1 M1_PSUB_CDNS_406619561345
* cell instance $55 r0 *1 84.865,205.525
X$55 2 1 M1_PSUB_CDNS_406619561345
* cell instance $56 r0 *1 90.145,200.245
X$56 2 1 M1_PSUB_CDNS_406619561345
* cell instance $57 r0 *1 89.485,200.905
X$57 2 1 M1_PSUB_CDNS_406619561345
* cell instance $58 r0 *1 88.825,201.565
X$58 2 1 M1_PSUB_CDNS_406619561345
* cell instance $59 r0 *1 88.165,202.225
X$59 2 1 M1_PSUB_CDNS_406619561345
* cell instance $60 r0 *1 87.505,202.885
X$60 2 1 M1_PSUB_CDNS_406619561345
* cell instance $61 r0 *1 86.845,203.545
X$61 2 1 M1_PSUB_CDNS_406619561345
* cell instance $62 r0 *1 137.005,153.385
X$62 2 1 M1_PSUB_CDNS_406619561345
* cell instance $63 r0 *1 136.345,154.045
X$63 2 1 M1_PSUB_CDNS_406619561345
* cell instance $64 r0 *1 135.685,154.705
X$64 2 1 M1_PSUB_CDNS_406619561345
* cell instance $65 r0 *1 124.465,165.925
X$65 2 1 M1_PSUB_CDNS_406619561345
* cell instance $66 r0 *1 148.885,141.505
X$66 2 1 M1_PSUB_CDNS_406619561345
* cell instance $67 r0 *1 148.225,142.165
X$67 2 1 M1_PSUB_CDNS_406619561345
* cell instance $68 r0 *1 147.565,142.825
X$68 2 1 M1_PSUB_CDNS_406619561345
* cell instance $69 r0 *1 146.905,143.485
X$69 2 1 M1_PSUB_CDNS_406619561345
* cell instance $70 r0 *1 137.665,152.725
X$70 2 1 M1_PSUB_CDNS_406619561345
* cell instance $71 r0 *1 152.845,137.545
X$71 2 1 M1_PSUB_CDNS_406619561345
* cell instance $72 r0 *1 68.365,222.025
X$72 2 1 M1_PSUB_CDNS_406619561345
* cell instance $73 r0 *1 67.705,222.685
X$73 2 1 M1_PSUB_CDNS_406619561345
* cell instance $74 r0 *1 67.045,223.345
X$74 2 1 M1_PSUB_CDNS_406619561345
* cell instance $75 r0 *1 66.385,224.005
X$75 2 1 M1_PSUB_CDNS_406619561345
* cell instance $76 r0 *1 75.625,214.765
X$76 2 1 M1_PSUB_CDNS_406619561345
* cell instance $77 r0 *1 79.585,210.805
X$77 2 1 M1_PSUB_CDNS_406619561345
* cell instance $78 r0 *1 78.925,211.465
X$78 2 1 M1_PSUB_CDNS_406619561345
* cell instance $79 r0 *1 113.905,176.485
X$79 2 1 M1_PSUB_CDNS_406619561345
* cell instance $80 r0 *1 77.605,212.785
X$80 2 1 M1_PSUB_CDNS_406619561345
* cell instance $81 r0 *1 76.945,213.445
X$81 2 1 M1_PSUB_CDNS_406619561345
* cell instance $82 r0 *1 76.285,214.105
X$82 2 1 M1_PSUB_CDNS_406619561345
* cell instance $83 r0 *1 74.965,215.425
X$83 2 1 M1_PSUB_CDNS_406619561345
* cell instance $84 r0 *1 74.305,216.085
X$84 2 1 M1_PSUB_CDNS_406619561345
* cell instance $85 r0 *1 73.645,216.745
X$85 2 1 M1_PSUB_CDNS_406619561345
* cell instance $86 r0 *1 72.985,217.405
X$86 2 1 M1_PSUB_CDNS_406619561345
* cell instance $87 r0 *1 72.325,218.065
X$87 2 1 M1_PSUB_CDNS_406619561345
* cell instance $88 r0 *1 71.665,218.725
X$88 2 1 M1_PSUB_CDNS_406619561345
* cell instance $89 r0 *1 71.005,219.385
X$89 2 1 M1_PSUB_CDNS_406619561345
* cell instance $90 r0 *1 70.345,220.045
X$90 2 1 M1_PSUB_CDNS_406619561345
* cell instance $91 r0 *1 69.685,220.705
X$91 2 1 M1_PSUB_CDNS_406619561345
* cell instance $92 r0 *1 69.025,221.365
X$92 2 1 M1_PSUB_CDNS_406619561345
* cell instance $93 r0 *1 80.245,210.145
X$93 2 1 M1_PSUB_CDNS_406619561345
* cell instance $94 r0 *1 78.265,212.125
X$94 2 1 M1_PSUB_CDNS_406619561345
* cell instance $95 r0 *1 100.705,189.685
X$95 2 1 M1_PSUB_CDNS_406619561345
* cell instance $96 r0 *1 100.045,190.345
X$96 2 1 M1_PSUB_CDNS_406619561345
* cell instance $97 r0 *1 99.385,191.005
X$97 2 1 M1_PSUB_CDNS_406619561345
* cell instance $98 r0 *1 98.725,191.665
X$98 2 1 M1_PSUB_CDNS_406619561345
* cell instance $99 r0 *1 98.065,192.325
X$99 2 1 M1_PSUB_CDNS_406619561345
* cell instance $100 r0 *1 97.405,192.985
X$100 2 1 M1_PSUB_CDNS_406619561345
* cell instance $101 r0 *1 96.745,193.645
X$101 2 1 M1_PSUB_CDNS_406619561345
* cell instance $102 r0 *1 96.085,194.305
X$102 2 1 M1_PSUB_CDNS_406619561345
* cell instance $103 r0 *1 86.185,204.205
X$103 2 1 M1_PSUB_CDNS_406619561345
* cell instance $104 r0 *1 94.765,195.625
X$104 2 1 M1_PSUB_CDNS_406619561345
* cell instance $105 r0 *1 94.105,196.285
X$105 2 1 M1_PSUB_CDNS_406619561345
* cell instance $106 r0 *1 93.445,196.945
X$106 2 1 M1_PSUB_CDNS_406619561345
* cell instance $107 r0 *1 145.585,144.805
X$107 2 1 M1_PSUB_CDNS_406619561345
* cell instance $108 r0 *1 144.265,146.125
X$108 2 1 M1_PSUB_CDNS_406619561345
* cell instance $109 r0 *1 149.545,140.845
X$109 2 1 M1_PSUB_CDNS_406619561345
* cell instance $110 r0 *1 142.285,148.105
X$110 2 1 M1_PSUB_CDNS_406619561345
* cell instance $111 r0 *1 141.625,148.765
X$111 2 1 M1_PSUB_CDNS_406619561345
* cell instance $112 r0 *1 140.965,149.425
X$112 2 1 M1_PSUB_CDNS_406619561345
* cell instance $113 r0 *1 140.305,150.085
X$113 2 1 M1_PSUB_CDNS_406619561345
* cell instance $114 r0 *1 139.645,150.745
X$114 2 1 M1_PSUB_CDNS_406619561345
* cell instance $115 r0 *1 138.985,151.405
X$115 2 1 M1_PSUB_CDNS_406619561345
* cell instance $116 r0 *1 138.325,152.065
X$116 2 1 M1_PSUB_CDNS_406619561345
* cell instance $117 r0 *1 143.605,146.785
X$117 2 1 M1_PSUB_CDNS_406619561345
* cell instance $118 r0 *1 144.925,145.465
X$118 2 1 M1_PSUB_CDNS_406619561345
* cell instance $119 r0 *1 146.245,144.145
X$119 2 1 M1_PSUB_CDNS_406619561345
* cell instance $120 r0 *1 152.185,138.205
X$120 2 1 M1_PSUB_CDNS_406619561345
* cell instance $121 r0 *1 151.525,138.865
X$121 2 1 M1_PSUB_CDNS_406619561345
* cell instance $122 r0 *1 150.865,139.525
X$122 2 1 M1_PSUB_CDNS_406619561345
* cell instance $123 r0 *1 150.205,140.185
X$123 2 1 M1_PSUB_CDNS_406619561345
* cell instance $124 r0 *1 142.945,147.445
X$124 2 1 M1_PSUB_CDNS_406619561345
* cell instance $125 r0 *1 172.645,117.745
X$125 2 1 M1_PSUB_CDNS_406619561345
* cell instance $126 r0 *1 173.305,117.085
X$126 2 1 M1_PSUB_CDNS_406619561345
* cell instance $127 r0 *1 173.965,116.425
X$127 2 1 M1_PSUB_CDNS_406619561345
* cell instance $128 r0 *1 166.045,124.345
X$128 2 1 M1_PSUB_CDNS_406619561345
* cell instance $129 r0 *1 206.305,84.085
X$129 2 1 M1_PSUB_CDNS_406619561345
* cell instance $130 r0 *1 181.225,109.165
X$130 2 1 M1_PSUB_CDNS_406619561345
* cell instance $131 r0 *1 186.505,103.885
X$131 2 1 M1_PSUB_CDNS_406619561345
* cell instance $132 r0 *1 185.845,104.545
X$132 2 1 M1_PSUB_CDNS_406619561345
* cell instance $133 r0 *1 185.185,105.205
X$133 2 1 M1_PSUB_CDNS_406619561345
* cell instance $134 r0 *1 184.525,105.865
X$134 2 1 M1_PSUB_CDNS_406619561345
* cell instance $135 r0 *1 183.865,106.525
X$135 2 1 M1_PSUB_CDNS_406619561345
* cell instance $136 r0 *1 183.205,107.185
X$136 2 1 M1_PSUB_CDNS_406619561345
* cell instance $137 r0 *1 182.545,107.845
X$137 2 1 M1_PSUB_CDNS_406619561345
* cell instance $138 r0 *1 181.885,108.505
X$138 2 1 M1_PSUB_CDNS_406619561345
* cell instance $139 r0 *1 154.825,135.565
X$139 2 1 M1_PSUB_CDNS_406619561345
* cell instance $140 r0 *1 164.065,126.325
X$140 2 1 M1_PSUB_CDNS_406619561345
* cell instance $141 r0 *1 163.405,126.985
X$141 2 1 M1_PSUB_CDNS_406619561345
* cell instance $142 r0 *1 162.745,127.645
X$142 2 1 M1_PSUB_CDNS_406619561345
* cell instance $143 r0 *1 162.085,128.305
X$143 2 1 M1_PSUB_CDNS_406619561345
* cell instance $144 r0 *1 161.425,128.965
X$144 2 1 M1_PSUB_CDNS_406619561345
* cell instance $145 r0 *1 160.765,129.625
X$145 2 1 M1_PSUB_CDNS_406619561345
* cell instance $146 r0 *1 160.105,130.285
X$146 2 1 M1_PSUB_CDNS_406619561345
* cell instance $147 r0 *1 159.445,130.945
X$147 2 1 M1_PSUB_CDNS_406619561345
* cell instance $148 r0 *1 158.785,131.605
X$148 2 1 M1_PSUB_CDNS_406619561345
* cell instance $149 r0 *1 158.125,132.265
X$149 2 1 M1_PSUB_CDNS_406619561345
* cell instance $150 r0 *1 157.465,132.925
X$150 2 1 M1_PSUB_CDNS_406619561345
* cell instance $151 r0 *1 156.805,133.585
X$151 2 1 M1_PSUB_CDNS_406619561345
* cell instance $152 r0 *1 156.145,134.245
X$152 2 1 M1_PSUB_CDNS_406619561345
* cell instance $153 r0 *1 165.385,125.005
X$153 2 1 M1_PSUB_CDNS_406619561345
* cell instance $154 r0 *1 164.725,125.665
X$154 2 1 M1_PSUB_CDNS_406619561345
* cell instance $155 r0 *1 223.465,66.925
X$155 2 1 M1_PSUB_CDNS_406619561345
* cell instance $156 r0 *1 222.805,67.585
X$156 2 1 M1_PSUB_CDNS_406619561345
* cell instance $157 r0 *1 222.145,68.245
X$157 2 1 M1_PSUB_CDNS_406619561345
* cell instance $158 r0 *1 221.485,68.905
X$158 2 1 M1_PSUB_CDNS_406619561345
* cell instance $159 r0 *1 220.825,69.565
X$159 2 1 M1_PSUB_CDNS_406619561345
* cell instance $160 r0 *1 220.165,70.225
X$160 2 1 M1_PSUB_CDNS_406619561345
* cell instance $161 r0 *1 219.505,70.885
X$161 2 1 M1_PSUB_CDNS_406619561345
* cell instance $162 r0 *1 218.845,71.545
X$162 2 1 M1_PSUB_CDNS_406619561345
* cell instance $163 r0 *1 218.185,72.205
X$163 2 1 M1_PSUB_CDNS_406619561345
* cell instance $164 r0 *1 217.525,72.865
X$164 2 1 M1_PSUB_CDNS_406619561345
* cell instance $165 r0 *1 216.865,73.525
X$165 2 1 M1_PSUB_CDNS_406619561345
* cell instance $166 r0 *1 216.205,74.185
X$166 2 1 M1_PSUB_CDNS_406619561345
* cell instance $167 r0 *1 215.545,74.845
X$167 2 1 M1_PSUB_CDNS_406619561345
* cell instance $168 r0 *1 214.225,76.165
X$168 2 1 M1_PSUB_CDNS_406619561345
* cell instance $169 r0 *1 171.985,118.405
X$169 2 1 M1_PSUB_CDNS_406619561345
* cell instance $170 r0 *1 212.905,77.485
X$170 2 1 M1_PSUB_CDNS_406619561345
* cell instance $171 r0 *1 212.245,78.145
X$171 2 1 M1_PSUB_CDNS_406619561345
* cell instance $172 r0 *1 211.585,78.805
X$172 2 1 M1_PSUB_CDNS_406619561345
* cell instance $173 r0 *1 210.925,79.465
X$173 2 1 M1_PSUB_CDNS_406619561345
* cell instance $174 r0 *1 214.885,75.505
X$174 2 1 M1_PSUB_CDNS_406619561345
* cell instance $175 r0 *1 194.425,95.965
X$175 2 1 M1_PSUB_CDNS_406619561345
* cell instance $176 r0 *1 193.765,96.625
X$176 2 1 M1_PSUB_CDNS_406619561345
* cell instance $177 r0 *1 193.105,97.285
X$177 2 1 M1_PSUB_CDNS_406619561345
* cell instance $178 r0 *1 192.445,97.945
X$178 2 1 M1_PSUB_CDNS_406619561345
* cell instance $179 r0 *1 191.785,98.605
X$179 2 1 M1_PSUB_CDNS_406619561345
* cell instance $180 r0 *1 169.345,121.045
X$180 2 1 M1_PSUB_CDNS_406619561345
* cell instance $181 r0 *1 170.005,120.385
X$181 2 1 M1_PSUB_CDNS_406619561345
* cell instance $182 r0 *1 170.665,119.725
X$182 2 1 M1_PSUB_CDNS_406619561345
* cell instance $183 r0 *1 171.325,119.065
X$183 2 1 M1_PSUB_CDNS_406619561345
* cell instance $184 r0 *1 213.565,76.825
X$184 2 1 M1_PSUB_CDNS_406619561345
* cell instance $185 r0 *1 197.725,92.665
X$185 2 1 M1_PSUB_CDNS_406619561345
* cell instance $186 r0 *1 191.125,99.265
X$186 2 1 M1_PSUB_CDNS_406619561345
* cell instance $187 r0 *1 190.465,99.925
X$187 2 1 M1_PSUB_CDNS_406619561345
* cell instance $188 r0 *1 189.805,100.585
X$188 2 1 M1_PSUB_CDNS_406619561345
* cell instance $189 r0 *1 189.145,101.245
X$189 2 1 M1_PSUB_CDNS_406619561345
* cell instance $190 r0 *1 188.485,101.905
X$190 2 1 M1_PSUB_CDNS_406619561345
* cell instance $191 r0 *1 187.825,102.565
X$191 2 1 M1_PSUB_CDNS_406619561345
* cell instance $192 r0 *1 187.165,103.225
X$192 2 1 M1_PSUB_CDNS_406619561345
* cell instance $193 r0 *1 197.065,93.325
X$193 2 1 M1_PSUB_CDNS_406619561345
* cell instance $194 r0 *1 175.285,115.105
X$194 2 1 M1_PSUB_CDNS_406619561345
* cell instance $195 r0 *1 195.745,94.645
X$195 2 1 M1_PSUB_CDNS_406619561345
* cell instance $196 r0 *1 166.705,123.685
X$196 2 1 M1_PSUB_CDNS_406619561345
* cell instance $197 r0 *1 167.365,123.025
X$197 2 1 M1_PSUB_CDNS_406619561345
* cell instance $198 r0 *1 168.025,122.365
X$198 2 1 M1_PSUB_CDNS_406619561345
* cell instance $199 r0 *1 198.385,92.005
X$199 2 1 M1_PSUB_CDNS_406619561345
* cell instance $200 r0 *1 115.225,175.165
X$200 2 1 M1_PSUB_CDNS_406619561345
* cell instance $201 r0 *1 116.545,173.845
X$201 2 1 M1_PSUB_CDNS_406619561345
* cell instance $202 r0 *1 117.205,173.185
X$202 2 1 M1_PSUB_CDNS_406619561345
* cell instance $203 r0 *1 117.865,172.525
X$203 2 1 M1_PSUB_CDNS_406619561345
* cell instance $204 r0 *1 118.525,171.865
X$204 2 1 M1_PSUB_CDNS_406619561345
* cell instance $205 r0 *1 119.185,171.205
X$205 2 1 M1_PSUB_CDNS_406619561345
* cell instance $206 r0 *1 119.845,170.545
X$206 2 1 M1_PSUB_CDNS_406619561345
* cell instance $207 r0 *1 120.505,169.885
X$207 2 1 M1_PSUB_CDNS_406619561345
* cell instance $208 r0 *1 121.165,169.225
X$208 2 1 M1_PSUB_CDNS_406619561345
* cell instance $209 r0 *1 121.825,168.565
X$209 2 1 M1_PSUB_CDNS_406619561345
* cell instance $210 r0 *1 122.485,167.905
X$210 2 1 M1_PSUB_CDNS_406619561345
* cell instance $211 r0 *1 123.145,167.245
X$211 2 1 M1_PSUB_CDNS_406619561345
* cell instance $212 r0 *1 123.805,166.585
X$212 2 1 M1_PSUB_CDNS_406619561345
* cell instance $213 r0 *1 125.125,165.265
X$213 2 1 M1_PSUB_CDNS_406619561345
* cell instance $214 r0 *1 210.265,80.125
X$214 2 1 M1_PSUB_CDNS_406619561345
* cell instance $215 r0 *1 168.685,121.705
X$215 2 1 M1_PSUB_CDNS_406619561345
* cell instance $216 r0 *1 115.885,174.505
X$216 2 1 M1_PSUB_CDNS_406619561345
* cell instance $217 r0 *1 153.505,136.885
X$217 2 1 M1_PSUB_CDNS_406619561345
* cell instance $218 r0 *1 195.085,95.305
X$218 2 1 M1_PSUB_CDNS_406619561345
* cell instance $219 r0 *1 155.485,134.905
X$219 2 1 M1_PSUB_CDNS_406619561345
* cell instance $220 r0 *1 180.565,109.825
X$220 2 1 M1_PSUB_CDNS_406619561345
* cell instance $221 r0 *1 179.905,110.485
X$221 2 1 M1_PSUB_CDNS_406619561345
* cell instance $222 r0 *1 179.245,111.145
X$222 2 1 M1_PSUB_CDNS_406619561345
* cell instance $223 r0 *1 178.585,111.805
X$223 2 1 M1_PSUB_CDNS_406619561345
* cell instance $224 r0 *1 177.925,112.465
X$224 2 1 M1_PSUB_CDNS_406619561345
* cell instance $225 r0 *1 177.265,113.125
X$225 2 1 M1_PSUB_CDNS_406619561345
* cell instance $226 r0 *1 176.605,113.785
X$226 2 1 M1_PSUB_CDNS_406619561345
* cell instance $227 r0 *1 175.945,114.445
X$227 2 1 M1_PSUB_CDNS_406619561345
* cell instance $228 r0 *1 174.625,115.765
X$228 2 1 M1_PSUB_CDNS_406619561345
* cell instance $229 r0 *1 209.605,80.785
X$229 2 1 M1_PSUB_CDNS_406619561345
* cell instance $230 r0 *1 208.945,81.445
X$230 2 1 M1_PSUB_CDNS_406619561345
* cell instance $231 r0 *1 208.285,82.105
X$231 2 1 M1_PSUB_CDNS_406619561345
* cell instance $232 r0 *1 154.165,136.225
X$232 2 1 M1_PSUB_CDNS_406619561345
* cell instance $233 r0 *1 199.705,90.685
X$233 2 1 M1_PSUB_CDNS_406619561345
* cell instance $234 r0 *1 200.365,90.025
X$234 2 1 M1_PSUB_CDNS_406619561345
* cell instance $235 r0 *1 201.025,89.365
X$235 2 1 M1_PSUB_CDNS_406619561345
* cell instance $236 r0 *1 201.685,88.705
X$236 2 1 M1_PSUB_CDNS_406619561345
* cell instance $237 r0 *1 202.345,88.045
X$237 2 1 M1_PSUB_CDNS_406619561345
* cell instance $238 r0 *1 203.005,87.385
X$238 2 1 M1_PSUB_CDNS_406619561345
* cell instance $239 r0 *1 203.665,86.725
X$239 2 1 M1_PSUB_CDNS_406619561345
* cell instance $240 r0 *1 204.325,86.065
X$240 2 1 M1_PSUB_CDNS_406619561345
* cell instance $241 r0 *1 204.985,85.405
X$241 2 1 M1_PSUB_CDNS_406619561345
* cell instance $242 r0 *1 205.645,84.745
X$242 2 1 M1_PSUB_CDNS_406619561345
* cell instance $243 r0 *1 196.405,93.985
X$243 2 1 M1_PSUB_CDNS_406619561345
* cell instance $244 r0 *1 206.965,83.425
X$244 2 1 M1_PSUB_CDNS_406619561345
* cell instance $245 r0 *1 199.045,91.345
X$245 2 1 M1_PSUB_CDNS_406619561345
* cell instance $246 r0 *1 207.625,82.765
X$246 2 1 M1_PSUB_CDNS_406619561345
* cell instance $247 r0 *1 353.205,121.53
X$247 4 7 M3_M2_CDNS_406619561346
* cell instance $248 r0 *1 353.205,141.6
X$248 4 7 M3_M2_CDNS_406619561347
* cell instance $249 r0 *1 353.205,173.5
X$249 4 7 M3_M2_CDNS_406619561347
* cell instance $250 r0 *1 353.205,189.5
X$250 4 7 M3_M2_CDNS_406619561347
* cell instance $251 r0 *1 353.205,221.535
X$251 4 7 M3_M2_CDNS_406619561347
* cell instance $252 r0 *1 353.205,157.44
X$252 4 7 M3_M2_CDNS_406619561347
* cell instance $253 r0 *1 353.205,281.55
X$253 4 7 M3_M2_CDNS_406619561346
* cell instance $254 r0 *1 353.205,273.51
X$254 4 7 M3_M2_CDNS_406619561346
* cell instance $255 r0 *1 353.205,265.61
X$255 4 7 M3_M2_CDNS_406619561346
* cell instance $256 r0 *1 353.205,337.58
X$256 4 7 M3_M2_CDNS_406619561346
* cell instance $257 r0 *1 353.205,297.6
X$257 4 7 M3_M2_CDNS_406619561346
* cell instance $258 r0 *1 353.205,209.485
X$258 4 7 M3_M2_CDNS_406619561346
.ENDS POWER_RAIL_COR

* cell GF_NI_ASIG_5P0_BASE
* pin
* pin
* pin
* pin
* pin
* pin
* pin
* pin
* pin
* pin
* pin
* pin
* pin
* pin
* pin
* pin
* pin
* pin
* pin
.SUBCKT GF_NI_ASIG_5P0_BASE 1 2 3 7 18 19 26 29 32 33 34 35 36 37 38 39 40 41 42
* cell instance $1 r0 *1 3.42,53.17
X$1 1 M1_PSUB_CDNS_40661956134499
* cell instance $2 r0 *1 0.42,185.985
X$2 1 19 M2_M1_CDNS_40661956134115
* cell instance $3 r0 *1 0.42,185.985
X$3 1 19 M3_M2_CDNS_40661956134114
* cell instance $4 r0 *1 0.42,257.985
X$4 1 18 M2_M1_CDNS_40661956134115
* cell instance $5 r0 *1 0.42,257.985
X$5 1 18 M3_M2_CDNS_40661956134114
* cell instance $6 m90 *1 71.9,53.17
X$6 2 M1_PSUB_CDNS_40661956134499
* cell instance $7 r0 *1 74.9,257.985
X$7 2 32 M3_M2_CDNS_40661956134114
* cell instance $8 r0 *1 74.9,257.985
X$8 2 32 M2_M1_CDNS_40661956134115
* cell instance $9 r0 *1 74.9,185.985
X$9 2 33 M3_M2_CDNS_40661956134114
* cell instance $10 r0 *1 74.9,185.985
X$10 2 33 M2_M1_CDNS_40661956134115
* cell instance $11 r0 *1 15.805,90.98
X$11 3 5 M1_PSUB_CDNS_40661956134484
* cell instance $12 r0 *1 59.515,90.98
X$12 3 5 M1_PSUB_CDNS_40661956134484
* cell instance $13 r0 *1 2.89,106.675
X$13 3 20 M2_M1_CDNS_40661956134493
* cell instance $14 r0 *1 2.11,194.78
X$14 3 21 M1_PSUB_CDNS_40661956134482
* cell instance $15 r0 *1 37.66,105.95
X$15 3 21 M1_PSUB_CDNS_40661956134198
* cell instance $16 r0 *1 4.39,108.32
X$16 3 7 nmoscap_6p0_CDNS_406619561348
* cell instance $17 r0 *1 8.25,106.675
X$17 3 23 M2_M1_CDNS_40661956134207
* cell instance $18 r0 *1 13.93,106.675
X$18 3 4 M2_M1_CDNS_40661956134207
* cell instance $19 r0 *1 21.57,108.32
X$19 3 7 nmoscap_6p0_CDNS_406619561348
* cell instance $20 r0 *1 25.29,106.675
X$20 3 8 M2_M1_CDNS_40661956134207
* cell instance $21 r0 *1 36.445,106.675
X$21 3 10 M2_M1_CDNS_40661956134489
* cell instance $22 r0 *1 38.75,108.32
X$22 3 7 nmoscap_6p0_CDNS_406619561348
* cell instance $23 r0 *1 38.875,106.675
X$23 3 11 M2_M1_CDNS_40661956134489
* cell instance $24 r0 *1 50.03,106.675
X$24 3 13 M2_M1_CDNS_40661956134207
* cell instance $25 r0 *1 55.93,108.32
X$25 3 7 nmoscap_6p0_CDNS_406619561348
* cell instance $26 r0 *1 61.39,106.675
X$26 3 15 M2_M1_CDNS_40661956134207
* cell instance $27 r0 *1 67.07,106.675
X$27 3 17 M2_M1_CDNS_40661956134207
* cell instance $28 m90 *1 72.43,106.675
X$28 3 31 M2_M1_CDNS_40661956134493
* cell instance $29 r0 *1 73.21,194.78
X$29 3 21 M1_PSUB_CDNS_40661956134482
* cell instance $30 r0 *1 2.89,125.69
X$30 3 20 M2_M1_CDNS_40661956134497
* cell instance $31 r0 *1 37.07,115.82
X$31 3 10 M2_M1_CDNS_40661956134258
* cell instance $32 m90 *1 38.25,115.82
X$32 3 11 M2_M1_CDNS_40661956134258
* cell instance $33 m90 *1 72.43,125.69
X$33 3 31 M2_M1_CDNS_40661956134497
* cell instance $34 r0 *1 37.66,125.69
X$34 3 48 M1_PSUB_CDNS_40661956134198
* cell instance $35 r0 *1 4.39,128.06
X$35 3 7 nmoscap_6p0_CDNS_406619561348
* cell instance $36 r0 *1 8.25,125.69
X$36 3 23 M2_M1_CDNS_40661956134496
* cell instance $37 r0 *1 13.93,125.69
X$37 3 4 M2_M1_CDNS_40661956134496
* cell instance $38 r0 *1 21.57,128.06
X$38 3 7 nmoscap_6p0_CDNS_406619561348
* cell instance $39 r0 *1 25.29,125.69
X$39 3 8 M2_M1_CDNS_40661956134496
* cell instance $40 r0 *1 36.445,125.69
X$40 3 10 M2_M1_CDNS_40661956134462
* cell instance $41 r0 *1 37.07,135.56
X$41 3 10 M2_M1_CDNS_40661956134258
* cell instance $42 r0 *1 36.445,137.985
X$42 3 10 M3_M2_CDNS_40661956134490
* cell instance $43 r0 *1 38.75,128.06
X$43 3 7 nmoscap_6p0_CDNS_406619561348
* cell instance $44 m90 *1 38.25,135.56
X$44 3 11 M2_M1_CDNS_40661956134258
* cell instance $45 m90 *1 38.875,137.985
X$45 3 11 M3_M2_CDNS_40661956134490
* cell instance $46 r0 *1 38.875,125.69
X$46 3 11 M2_M1_CDNS_40661956134462
* cell instance $47 r0 *1 50.03,125.69
X$47 3 13 M2_M1_CDNS_40661956134496
* cell instance $48 r0 *1 55.93,128.06
X$48 3 7 nmoscap_6p0_CDNS_406619561348
* cell instance $49 r0 *1 61.39,125.69
X$49 3 15 M2_M1_CDNS_40661956134496
* cell instance $50 r0 *1 67.07,125.69
X$50 3 17 M2_M1_CDNS_40661956134496
* cell instance $51 r0 *1 2.89,145.43
X$51 3 20 M2_M1_CDNS_40661956134497
* cell instance $52 r0 *1 37.66,145.43
X$52 3 49 M1_PSUB_CDNS_40661956134198
* cell instance $53 r0 *1 4.39,147.8
X$53 3 7 nmoscap_6p0_CDNS_406619561348
* cell instance $54 r0 *1 8.25,145.43
X$54 3 23 M2_M1_CDNS_40661956134496
* cell instance $55 r0 *1 13.93,145.43
X$55 3 4 M2_M1_CDNS_40661956134496
* cell instance $56 r0 *1 21.57,147.8
X$56 3 7 nmoscap_6p0_CDNS_406619561348
* cell instance $57 r0 *1 25.29,145.43
X$57 3 8 M2_M1_CDNS_40661956134496
* cell instance $58 r0 *1 36.445,145.43
X$58 3 10 M2_M1_CDNS_40661956134462
* cell instance $59 r0 *1 38.75,147.8
X$59 3 7 nmoscap_6p0_CDNS_406619561348
* cell instance $60 r0 *1 38.875,145.43
X$60 3 11 M2_M1_CDNS_40661956134462
* cell instance $61 r0 *1 50.03,145.43
X$61 3 13 M2_M1_CDNS_40661956134496
* cell instance $62 r0 *1 55.93,147.8
X$62 3 7 nmoscap_6p0_CDNS_406619561348
* cell instance $63 r0 *1 61.39,145.43
X$63 3 15 M2_M1_CDNS_40661956134496
* cell instance $64 r0 *1 67.07,145.43
X$64 3 17 M2_M1_CDNS_40661956134496
* cell instance $65 m90 *1 72.43,145.43
X$65 3 31 M2_M1_CDNS_40661956134497
* cell instance $66 r0 *1 37.07,155.3
X$66 3 10 M2_M1_CDNS_40661956134258
* cell instance $67 m90 *1 38.25,155.3
X$67 3 11 M2_M1_CDNS_40661956134258
* cell instance $68 r0 *1 2.89,165.17
X$68 3 20 M2_M1_CDNS_40661956134497
* cell instance $69 r0 *1 37.66,165.17
X$69 3 51 M1_PSUB_CDNS_40661956134198
* cell instance $70 r0 *1 4.39,167.54
X$70 3 7 nmoscap_6p0_CDNS_406619561348
* cell instance $71 r0 *1 8.25,165.17
X$71 3 23 M2_M1_CDNS_40661956134496
* cell instance $72 r0 *1 13.93,165.17
X$72 3 4 M2_M1_CDNS_40661956134496
* cell instance $73 r0 *1 21.57,167.54
X$73 3 7 nmoscap_6p0_CDNS_406619561348
* cell instance $74 r0 *1 25.29,165.17
X$74 3 8 M2_M1_CDNS_40661956134496
* cell instance $75 r0 *1 36.445,165.17
X$75 3 10 M2_M1_CDNS_40661956134462
* cell instance $76 r0 *1 38.75,167.54
X$76 3 7 nmoscap_6p0_CDNS_406619561348
* cell instance $77 r0 *1 38.875,165.17
X$77 3 11 M2_M1_CDNS_40661956134462
* cell instance $78 r0 *1 50.03,165.17
X$78 3 13 M2_M1_CDNS_40661956134496
* cell instance $79 r0 *1 55.93,167.54
X$79 3 7 nmoscap_6p0_CDNS_406619561348
* cell instance $80 r0 *1 61.39,165.17
X$80 3 15 M2_M1_CDNS_40661956134496
* cell instance $81 r0 *1 67.07,165.17
X$81 3 17 M2_M1_CDNS_40661956134496
* cell instance $82 m90 *1 72.43,165.17
X$82 3 31 M2_M1_CDNS_40661956134497
* cell instance $83 r0 *1 37.07,175.04
X$83 3 10 M2_M1_CDNS_40661956134258
* cell instance $84 r0 *1 36.445,173.985
X$84 3 10 M3_M2_CDNS_40661956134491
* cell instance $85 m90 *1 38.25,175.04
X$85 3 11 M2_M1_CDNS_40661956134258
* cell instance $86 m90 *1 38.875,173.985
X$86 3 11 M3_M2_CDNS_40661956134491
* cell instance $87 r0 *1 2.89,184.91
X$87 3 20 M2_M1_CDNS_40661956134497
* cell instance $88 r0 *1 37.66,184.91
X$88 3 50 M1_PSUB_CDNS_40661956134198
* cell instance $89 r0 *1 4.39,187.28
X$89 3 7 nmoscap_6p0_CDNS_406619561348
* cell instance $90 r0 *1 8.25,184.91
X$90 3 23 M2_M1_CDNS_40661956134496
* cell instance $91 r0 *1 13.93,184.91
X$91 3 4 M2_M1_CDNS_40661956134496
* cell instance $92 r0 *1 21.57,187.28
X$92 3 7 nmoscap_6p0_CDNS_406619561348
* cell instance $93 r0 *1 25.29,184.91
X$93 3 8 M2_M1_CDNS_40661956134496
* cell instance $94 r0 *1 36.445,184.91
X$94 3 10 M2_M1_CDNS_40661956134462
* cell instance $95 r0 *1 37.07,194.78
X$95 3 10 M2_M1_CDNS_40661956134258
* cell instance $96 r0 *1 38.75,187.28
X$96 3 7 nmoscap_6p0_CDNS_406619561348
* cell instance $97 m90 *1 38.25,194.78
X$97 3 11 M2_M1_CDNS_40661956134258
* cell instance $98 r0 *1 38.875,184.91
X$98 3 11 M2_M1_CDNS_40661956134462
* cell instance $99 r0 *1 50.03,184.91
X$99 3 13 M2_M1_CDNS_40661956134496
* cell instance $100 r0 *1 55.93,187.28
X$100 3 7 nmoscap_6p0_CDNS_406619561348
* cell instance $101 r0 *1 61.39,184.91
X$101 3 15 M2_M1_CDNS_40661956134496
* cell instance $102 r0 *1 67.84,184.91
X$102 3 17 M2_M1_CDNS_40661956134498
* cell instance $103 m90 *1 72.43,184.91
X$103 3 31 M2_M1_CDNS_40661956134497
* cell instance $104 r0 *1 2.89,204.65
X$104 3 20 M2_M1_CDNS_40661956134497
* cell instance $105 r0 *1 37.66,204.65
X$105 3 47 M1_PSUB_CDNS_40661956134198
* cell instance $106 r0 *1 4.39,207.02
X$106 3 7 nmoscap_6p0_CDNS_406619561348
* cell instance $107 r0 *1 8.25,204.65
X$107 3 23 M2_M1_CDNS_40661956134496
* cell instance $108 r0 *1 13.93,204.65
X$108 3 4 M2_M1_CDNS_40661956134496
* cell instance $109 r0 *1 21.57,207.02
X$109 3 7 nmoscap_6p0_CDNS_406619561348
* cell instance $110 r0 *1 25.29,204.65
X$110 3 8 M2_M1_CDNS_40661956134496
* cell instance $111 r0 *1 36.445,204.65
X$111 3 10 M2_M1_CDNS_40661956134462
* cell instance $112 r0 *1 38.75,207.02
X$112 3 7 nmoscap_6p0_CDNS_406619561348
* cell instance $113 r0 *1 38.875,204.65
X$113 3 11 M2_M1_CDNS_40661956134462
* cell instance $114 r0 *1 50.03,204.65
X$114 3 13 M2_M1_CDNS_40661956134496
* cell instance $115 r0 *1 55.93,207.02
X$115 3 7 nmoscap_6p0_CDNS_406619561348
* cell instance $116 r0 *1 61.39,204.65
X$116 3 15 M2_M1_CDNS_40661956134496
* cell instance $117 r0 *1 67.84,204.65
X$117 3 17 M2_M1_CDNS_40661956134498
* cell instance $118 m90 *1 72.43,204.65
X$118 3 31 M2_M1_CDNS_40661956134497
* cell instance $119 r0 *1 37.07,214.52
X$119 3 10 M2_M1_CDNS_40661956134258
* cell instance $120 m90 *1 38.25,214.52
X$120 3 11 M2_M1_CDNS_40661956134258
* cell instance $121 r0 *1 2.89,224.39
X$121 3 20 M2_M1_CDNS_40661956134497
* cell instance $122 r0 *1 2.57,225.985
X$122 3 20 M3_M2_CDNS_40661956134225
* cell instance $123 r0 *1 37.66,224.39
X$123 3 45 M1_PSUB_CDNS_40661956134198
* cell instance $124 r0 *1 4.39,226.76
X$124 3 7 nmoscap_6p0_CDNS_406619561348
* cell instance $125 r0 *1 8.25,225.985
X$125 3 23 M3_M2_CDNS_40661956134225
* cell instance $126 r0 *1 8.25,224.39
X$126 3 23 M2_M1_CDNS_40661956134496
* cell instance $127 r0 *1 13.93,224.39
X$127 3 4 M2_M1_CDNS_40661956134496
* cell instance $128 r0 *1 13.93,225.985
X$128 3 4 M3_M2_CDNS_40661956134225
* cell instance $129 r0 *1 21.57,226.76
X$129 3 7 nmoscap_6p0_CDNS_406619561348
* cell instance $130 r0 *1 25.29,225.985
X$130 3 8 M3_M2_CDNS_40661956134225
* cell instance $131 r0 *1 25.29,224.39
X$131 3 8 M2_M1_CDNS_40661956134496
* cell instance $132 r0 *1 36.445,225.985
X$132 3 10 M3_M2_CDNS_40661956134490
* cell instance $133 r0 *1 36.445,224.39
X$133 3 10 M2_M1_CDNS_40661956134462
* cell instance $134 r0 *1 37.07,234.26
X$134 3 10 M2_M1_CDNS_40661956134258
* cell instance $135 r0 *1 38.75,226.76
X$135 3 7 nmoscap_6p0_CDNS_406619561348
* cell instance $136 m90 *1 38.25,234.26
X$136 3 11 M2_M1_CDNS_40661956134258
* cell instance $137 m90 *1 38.875,225.985
X$137 3 11 M3_M2_CDNS_40661956134490
* cell instance $138 r0 *1 38.875,224.39
X$138 3 11 M2_M1_CDNS_40661956134462
* cell instance $139 r0 *1 50.03,224.39
X$139 3 13 M2_M1_CDNS_40661956134496
* cell instance $140 m90 *1 50.03,225.985
X$140 3 13 M3_M2_CDNS_40661956134225
* cell instance $141 r0 *1 55.93,226.76
X$141 3 7 nmoscap_6p0_CDNS_406619561348
* cell instance $142 m90 *1 61.39,225.985
X$142 3 15 M3_M2_CDNS_40661956134225
* cell instance $143 r0 *1 61.39,224.39
X$143 3 15 M2_M1_CDNS_40661956134496
* cell instance $144 r0 *1 67.84,224.39
X$144 3 17 M2_M1_CDNS_40661956134498
* cell instance $145 m90 *1 67.84,225.985
X$145 3 17 M3_M2_CDNS_40661956134223
* cell instance $146 m90 *1 72.43,224.39
X$146 3 31 M2_M1_CDNS_40661956134497
* cell instance $147 m90 *1 72.75,225.985
X$147 3 31 M3_M2_CDNS_40661956134225
* cell instance $148 r0 *1 2.89,244.13
X$148 3 20 M2_M1_CDNS_40661956134497
* cell instance $149 r0 *1 2.57,241.985
X$149 3 20 M3_M2_CDNS_40661956134225
* cell instance $150 r0 *1 37.66,244.13
X$150 3 44 M1_PSUB_CDNS_40661956134198
* cell instance $151 r0 *1 4.39,246.5
X$151 3 7 nmoscap_6p0_CDNS_406619561348
* cell instance $152 r0 *1 8.25,244.13
X$152 3 23 M2_M1_CDNS_40661956134496
* cell instance $153 r0 *1 8.25,241.985
X$153 3 23 M3_M2_CDNS_40661956134225
* cell instance $154 r0 *1 13.93,244.13
X$154 3 4 M2_M1_CDNS_40661956134496
* cell instance $155 r0 *1 13.93,241.985
X$155 3 4 M3_M2_CDNS_40661956134225
* cell instance $156 r0 *1 21.57,246.5
X$156 3 7 nmoscap_6p0_CDNS_406619561348
* cell instance $157 r0 *1 25.29,244.13
X$157 3 8 M2_M1_CDNS_40661956134496
* cell instance $158 r0 *1 25.29,241.985
X$158 3 8 M3_M2_CDNS_40661956134225
* cell instance $159 r0 *1 36.445,244.13
X$159 3 10 M2_M1_CDNS_40661956134462
* cell instance $160 r0 *1 36.445,241.985
X$160 3 10 M3_M2_CDNS_40661956134490
* cell instance $161 r0 *1 38.75,246.5
X$161 3 7 nmoscap_6p0_CDNS_406619561348
* cell instance $162 m90 *1 38.875,241.985
X$162 3 11 M3_M2_CDNS_40661956134490
* cell instance $163 r0 *1 38.875,244.13
X$163 3 11 M2_M1_CDNS_40661956134462
* cell instance $164 r0 *1 50.03,244.13
X$164 3 13 M2_M1_CDNS_40661956134496
* cell instance $165 m90 *1 50.03,241.985
X$165 3 13 M3_M2_CDNS_40661956134225
* cell instance $166 r0 *1 55.93,246.5
X$166 3 7 nmoscap_6p0_CDNS_406619561348
* cell instance $167 r0 *1 61.39,244.13
X$167 3 15 M2_M1_CDNS_40661956134496
* cell instance $168 m90 *1 61.39,241.985
X$168 3 15 M3_M2_CDNS_40661956134225
* cell instance $169 r0 *1 67.84,244.13
X$169 3 17 M2_M1_CDNS_40661956134498
* cell instance $170 m90 *1 67.84,241.985
X$170 3 17 M3_M2_CDNS_40661956134223
* cell instance $171 m90 *1 72.43,244.13
X$171 3 31 M2_M1_CDNS_40661956134497
* cell instance $172 m90 *1 72.75,241.985
X$172 3 31 M3_M2_CDNS_40661956134225
* cell instance $173 r0 *1 2.89,263.87
X$173 3 20 M2_M1_CDNS_40661956134497
* cell instance $174 r0 *1 2.57,265.985
X$174 3 20 M3_M2_CDNS_40661956134225
* cell instance $175 r0 *1 37.07,254
X$175 3 10 M2_M1_CDNS_40661956134258
* cell instance $176 m90 *1 38.25,254
X$176 3 11 M2_M1_CDNS_40661956134258
* cell instance $177 m90 *1 72.43,263.87
X$177 3 31 M2_M1_CDNS_40661956134497
* cell instance $178 m90 *1 72.75,265.985
X$178 3 31 M3_M2_CDNS_40661956134225
* cell instance $179 r0 *1 37.66,263.87
X$179 3 46 M1_PSUB_CDNS_40661956134198
* cell instance $180 r0 *1 4.39,266.24
X$180 3 7 nmoscap_6p0_CDNS_406619561348
* cell instance $181 r0 *1 8.25,263.87
X$181 3 23 M2_M1_CDNS_40661956134496
* cell instance $182 r0 *1 8.25,265.985
X$182 3 23 M3_M2_CDNS_40661956134225
* cell instance $183 r0 *1 13.93,265.985
X$183 3 4 M3_M2_CDNS_40661956134225
* cell instance $184 r0 *1 13.93,263.87
X$184 3 4 M2_M1_CDNS_40661956134496
* cell instance $185 r0 *1 21.57,266.24
X$185 3 7 nmoscap_6p0_CDNS_406619561348
* cell instance $186 r0 *1 25.29,265.985
X$186 3 8 M3_M2_CDNS_40661956134225
* cell instance $187 r0 *1 25.29,263.87
X$187 3 8 M2_M1_CDNS_40661956134496
* cell instance $188 r0 *1 36.445,265.985
X$188 3 10 M3_M2_CDNS_40661956134490
* cell instance $189 r0 *1 36.445,263.87
X$189 3 10 M2_M1_CDNS_40661956134462
* cell instance $190 r0 *1 37.07,273.74
X$190 3 10 M2_M1_CDNS_40661956134258
* cell instance $191 r0 *1 36.445,281.68
X$191 3 10 M3_M2_CDNS_4066195613427
* cell instance $192 r0 *1 38.75,266.24
X$192 3 7 nmoscap_6p0_CDNS_406619561348
* cell instance $193 m90 *1 38.25,273.74
X$193 3 11 M2_M1_CDNS_40661956134258
* cell instance $194 m90 *1 38.875,281.68
X$194 3 11 M3_M2_CDNS_4066195613427
* cell instance $195 m90 *1 38.875,265.985
X$195 3 11 M3_M2_CDNS_40661956134490
* cell instance $196 r0 *1 38.875,263.87
X$196 3 11 M2_M1_CDNS_40661956134462
* cell instance $197 r0 *1 50.03,263.87
X$197 3 13 M2_M1_CDNS_40661956134496
* cell instance $198 m90 *1 50.03,265.985
X$198 3 13 M3_M2_CDNS_40661956134225
* cell instance $199 r0 *1 55.93,266.24
X$199 3 7 nmoscap_6p0_CDNS_406619561348
* cell instance $200 r0 *1 61.39,263.87
X$200 3 15 M2_M1_CDNS_40661956134496
* cell instance $201 m90 *1 61.39,265.985
X$201 3 15 M3_M2_CDNS_40661956134225
* cell instance $202 m90 *1 67.07,265.985
X$202 3 17 M3_M2_CDNS_40661956134225
* cell instance $203 r0 *1 67.07,263.87
X$203 3 17 M2_M1_CDNS_40661956134496
* cell instance $204 r0 *1 2.89,282.885
X$204 3 20 M2_M1_CDNS_40661956134493
* cell instance $205 r0 *1 2.57,281.68
X$205 3 20 M3_M2_CDNS_40661956134224
* cell instance $206 r0 *1 37.66,283.61
X$206 3 21 M1_PSUB_CDNS_40661956134198
* cell instance $207 r0 *1 8.25,282.885
X$207 3 23 M2_M1_CDNS_40661956134207
* cell instance $208 r0 *1 8.25,281.68
X$208 3 23 M3_M2_CDNS_40661956134224
* cell instance $209 r0 *1 13.93,282.885
X$209 3 4 M2_M1_CDNS_40661956134207
* cell instance $210 r0 *1 13.93,281.68
X$210 3 4 M3_M2_CDNS_40661956134224
* cell instance $211 r0 *1 25.29,282.885
X$211 3 8 M2_M1_CDNS_40661956134207
* cell instance $212 r0 *1 25.29,281.68
X$212 3 8 M3_M2_CDNS_40661956134224
* cell instance $213 r0 *1 36.445,282.885
X$213 3 10 M2_M1_CDNS_40661956134489
* cell instance $214 r0 *1 38.875,282.885
X$214 3 11 M2_M1_CDNS_40661956134489
* cell instance $215 r0 *1 50.03,282.885
X$215 3 13 M2_M1_CDNS_40661956134207
* cell instance $216 m90 *1 50.03,281.68
X$216 3 13 M3_M2_CDNS_40661956134224
* cell instance $217 r0 *1 61.39,282.885
X$217 3 15 M2_M1_CDNS_40661956134207
* cell instance $218 m90 *1 61.39,281.68
X$218 3 15 M3_M2_CDNS_40661956134224
* cell instance $219 r0 *1 67.07,282.885
X$219 3 17 M2_M1_CDNS_40661956134207
* cell instance $220 m90 *1 67.07,281.68
X$220 3 17 M3_M2_CDNS_40661956134224
* cell instance $221 m90 *1 72.43,282.885
X$221 3 31 M2_M1_CDNS_40661956134493
* cell instance $222 m90 *1 72.75,281.68
X$222 3 31 M3_M2_CDNS_40661956134224
* cell instance $223 r0 *1 58.745,84.44
X$223 3 5 M1_PSUB_CDNS_40661956134199
* cell instance $224 r0 *1 58.745,97.52
X$224 3 5 M1_PSUB_CDNS_40661956134199
* cell instance $225 r0 *1 58.745,93.16
X$225 3 5 M1_PSUB_CDNS_40661956134199
* cell instance $226 r0 *1 58.745,88.8
X$226 3 5 M1_PSUB_CDNS_40661956134199
* cell instance $227 r0 *1 16.575,93.16
X$227 3 5 M1_PSUB_CDNS_40661956134199
* cell instance $228 r0 *1 16.575,88.8
X$228 3 5 M1_PSUB_CDNS_40661956134199
* cell instance $229 r0 *1 16.575,97.52
X$229 3 5 M1_PSUB_CDNS_40661956134199
* cell instance $230 r0 *1 16.575,84.44
X$230 3 5 M1_PSUB_CDNS_40661956134199
* cell instance $231 m90 *1 50.03,137.985
X$231 3 13 M3_M2_CDNS_40661956134225
* cell instance $232 m90 *1 61.39,137.985
X$232 3 15 M3_M2_CDNS_40661956134225
* cell instance $233 m90 *1 72.75,65.985
X$233 3 31 M3_M2_CDNS_40661956134225
* cell instance $234 m90 *1 72.75,137.985
X$234 3 31 M3_M2_CDNS_40661956134225
* cell instance $235 m90 *1 67.07,137.985
X$235 3 17 M3_M2_CDNS_40661956134225
* cell instance $236 r0 *1 25.29,137.985
X$236 3 8 M3_M2_CDNS_40661956134225
* cell instance $237 r0 *1 13.93,137.985
X$237 3 4 M3_M2_CDNS_40661956134225
* cell instance $238 r0 *1 8.25,137.985
X$238 3 23 M3_M2_CDNS_40661956134225
* cell instance $239 r0 *1 2.57,137.985
X$239 3 20 M3_M2_CDNS_40661956134225
* cell instance $240 r0 *1 2.57,65.985
X$240 3 20 M3_M2_CDNS_40661956134225
* cell instance $241 m90 *1 72.75,29.985
X$241 3 31 M3_M2_CDNS_40661956134227
* cell instance $242 m90 *1 50.03,173.985
X$242 3 13 M3_M2_CDNS_40661956134227
* cell instance $243 m90 *1 61.39,173.985
X$243 3 15 M3_M2_CDNS_40661956134227
* cell instance $244 m90 *1 67.07,173.985
X$244 3 17 M3_M2_CDNS_40661956134227
* cell instance $245 m90 *1 72.75,173.985
X$245 3 31 M3_M2_CDNS_40661956134227
* cell instance $246 m90 *1 72.75,13.985
X$246 3 31 M3_M2_CDNS_40661956134227
* cell instance $247 m90 *1 72.75,45.985
X$247 3 31 M3_M2_CDNS_40661956134227
* cell instance $248 r0 *1 25.29,173.985
X$248 3 8 M3_M2_CDNS_40661956134227
* cell instance $249 r0 *1 8.25,173.985
X$249 3 23 M3_M2_CDNS_40661956134227
* cell instance $250 r0 *1 2.57,173.985
X$250 3 20 M3_M2_CDNS_40661956134227
* cell instance $251 r0 *1 13.93,173.985
X$251 3 4 M3_M2_CDNS_40661956134227
* cell instance $252 r0 *1 8.25,13.985
X$252 3 23 M3_M2_CDNS_40661956134227
* cell instance $253 r0 *1 7.005,4.285
X$253 7 3 4 30 22 17 23 15 41 6 8 40 11 39 9 38 10 37 12 36 13 35 14 34 42
+ comp018green_esd_hbm
* cell instance $254 r0 *1 13.93,13.985
X$254 3 4 M3_M2_CDNS_40661956134227
* cell instance $255 r0 *1 25.29,13.985
X$255 3 8 M3_M2_CDNS_40661956134227
* cell instance $256 r0 *1 36.445,13.985
X$256 3 10 M3_M2_CDNS_40661956134491
* cell instance $257 m90 *1 38.875,13.985
X$257 3 11 M3_M2_CDNS_40661956134491
* cell instance $258 m90 *1 50.03,13.985
X$258 3 13 M3_M2_CDNS_40661956134227
* cell instance $259 m90 *1 61.39,13.985
X$259 3 15 M3_M2_CDNS_40661956134227
* cell instance $260 m90 *1 67.07,13.985
X$260 3 17 M3_M2_CDNS_40661956134227
* cell instance $261 r0 *1 8.25,45.985
X$261 3 23 M3_M2_CDNS_40661956134227
* cell instance $262 r0 *1 8.25,29.985
X$262 3 23 M3_M2_CDNS_40661956134227
* cell instance $263 r0 *1 13.93,45.985
X$263 3 4 M3_M2_CDNS_40661956134227
* cell instance $264 r0 *1 13.93,29.985
X$264 3 4 M3_M2_CDNS_40661956134227
* cell instance $265 r0 *1 25.29,45.985
X$265 3 8 M3_M2_CDNS_40661956134227
* cell instance $266 r0 *1 25.29,29.985
X$266 3 8 M3_M2_CDNS_40661956134227
* cell instance $267 r0 *1 36.445,29.985
X$267 3 10 M3_M2_CDNS_40661956134491
* cell instance $268 r0 *1 36.445,45.985
X$268 3 10 M3_M2_CDNS_40661956134491
* cell instance $269 m90 *1 38.875,45.985
X$269 3 11 M3_M2_CDNS_40661956134491
* cell instance $270 m90 *1 38.875,29.985
X$270 3 11 M3_M2_CDNS_40661956134491
* cell instance $271 m90 *1 50.03,45.985
X$271 3 13 M3_M2_CDNS_40661956134227
* cell instance $272 m90 *1 50.03,29.985
X$272 3 13 M3_M2_CDNS_40661956134227
* cell instance $273 m90 *1 61.39,29.985
X$273 3 15 M3_M2_CDNS_40661956134227
* cell instance $274 m90 *1 61.39,45.985
X$274 3 15 M3_M2_CDNS_40661956134227
* cell instance $275 m90 *1 67.07,29.985
X$275 3 17 M3_M2_CDNS_40661956134227
* cell instance $276 m90 *1 67.07,45.985
X$276 3 17 M3_M2_CDNS_40661956134227
* cell instance $277 r0 *1 8.25,65.985
X$277 3 23 M3_M2_CDNS_40661956134225
* cell instance $278 r0 *1 13.93,65.985
X$278 3 4 M3_M2_CDNS_40661956134225
* cell instance $279 r0 *1 25.29,65.985
X$279 3 8 M3_M2_CDNS_40661956134225
* cell instance $280 r0 *1 36.445,65.985
X$280 3 10 M3_M2_CDNS_40661956134490
* cell instance $281 m90 *1 38.875,65.985
X$281 3 11 M3_M2_CDNS_40661956134490
* cell instance $282 m90 *1 50.03,65.985
X$282 3 13 M3_M2_CDNS_40661956134225
* cell instance $283 m90 *1 61.39,65.985
X$283 3 15 M3_M2_CDNS_40661956134225
* cell instance $284 m90 *1 67.07,65.985
X$284 3 17 M3_M2_CDNS_40661956134225
* cell instance $285 r0 *1 2.57,13.985
X$285 3 20 M3_M2_CDNS_40661956134227
* cell instance $286 r0 *1 2.57,29.985
X$286 3 20 M3_M2_CDNS_40661956134227
* cell instance $287 r0 *1 2.57,45.985
X$287 3 20 M3_M2_CDNS_40661956134227
* cell instance $288 r0 *1 25.29,99.355
X$288 3 8 M2_M1_CDNS_40661956134250
* cell instance $289 r0 *1 37.66,99.74
X$289 3 5 M1_PSUB_CDNS_40661956134486
* cell instance $290 r0 *1 37.66,98.97
X$290 3 5 M1_PSUB_CDNS_40661956134200
* cell instance $291 r0 *1 36.445,99.355
X$291 3 10 M2_M1_CDNS_40661956134488
* cell instance $292 r0 *1 38.875,99.355
X$292 3 11 M2_M1_CDNS_40661956134488
* cell instance $293 r0 *1 50.03,99.355
X$293 3 13 M2_M1_CDNS_40661956134250
* cell instance $294 r0 *1 25.29,82.605
X$294 3 8 M2_M1_CDNS_40661956134250
* cell instance $295 r0 *1 37.66,82.22
X$295 3 5 M1_PSUB_CDNS_40661956134486
* cell instance $296 r0 *1 37.66,82.99
X$296 3 5 M1_PSUB_CDNS_40661956134200
* cell instance $297 r0 *1 36.445,82.605
X$297 3 10 M2_M1_CDNS_40661956134488
* cell instance $298 r0 *1 38.875,82.605
X$298 3 11 M2_M1_CDNS_40661956134488
* cell instance $299 r0 *1 50.03,82.605
X$299 3 13 M2_M1_CDNS_40661956134250
* cell instance $300 r0 *1 25.29,95.34
X$300 3 8 M2_M1_CDNS_40661956134207
* cell instance $301 r0 *1 37.66,95.34
X$301 3 5 M1_PSUB_CDNS_40661956134485
* cell instance $302 r0 *1 37.66,94.57
X$302 3 5 M1_PSUB_CDNS_40661956134200
* cell instance $303 r0 *1 37.66,96.11
X$303 3 5 M1_PSUB_CDNS_40661956134200
* cell instance $304 r0 *1 36.445,95.34
X$304 3 10 M2_M1_CDNS_40661956134489
* cell instance $305 r0 *1 38.875,95.34
X$305 3 11 M2_M1_CDNS_40661956134489
* cell instance $306 r0 *1 50.03,95.34
X$306 3 13 M2_M1_CDNS_40661956134207
* cell instance $307 r0 *1 25.29,86.62
X$307 3 8 M2_M1_CDNS_40661956134207
* cell instance $308 r0 *1 37.66,85.85
X$308 3 5 M1_PSUB_CDNS_40661956134200
* cell instance $309 r0 *1 36.445,86.62
X$309 3 10 M2_M1_CDNS_40661956134489
* cell instance $310 r0 *1 38.875,86.62
X$310 3 11 M2_M1_CDNS_40661956134489
* cell instance $311 r0 *1 50.03,86.62
X$311 3 13 M2_M1_CDNS_40661956134207
* cell instance $312 r0 *1 37.66,86.62
X$312 3 5 M1_PSUB_CDNS_40661956134485
* cell instance $313 r0 *1 37.66,87.39
X$313 3 5 M1_PSUB_CDNS_40661956134200
* cell instance $314 r0 *1 25.29,90.98
X$314 3 8 M2_M1_CDNS_40661956134207
* cell instance $315 r0 *1 37.66,90.98
X$315 3 5 M1_PSUB_CDNS_40661956134485
* cell instance $316 r0 *1 37.66,90.21
X$316 3 5 M1_PSUB_CDNS_40661956134200
* cell instance $317 r0 *1 37.66,91.75
X$317 3 5 M1_PSUB_CDNS_40661956134200
* cell instance $318 r0 *1 36.445,90.98
X$318 3 10 M2_M1_CDNS_40661956134489
* cell instance $319 r0 *1 38.875,90.98
X$319 3 11 M2_M1_CDNS_40661956134489
* cell instance $320 r0 *1 50.03,90.98
X$320 3 13 M2_M1_CDNS_40661956134207
* cell instance $321 r0 *1 18.775,254
X$321 7 6 M2_M1_CDNS_40661956134495
* cell instance $322 r0 *1 18.775,175.04
X$322 7 6 M2_M1_CDNS_40661956134495
* cell instance $323 r0 *1 18.775,194.78
X$323 7 6 M2_M1_CDNS_40661956134495
* cell instance $324 r0 *1 19.61,201.985
X$324 7 6 M3_M2_CDNS_40661956134225
* cell instance $325 r0 *1 18.775,273.74
X$325 7 6 M2_M1_CDNS_40661956134495
* cell instance $326 r0 *1 19.61,273.985
X$326 7 6 M3_M2_CDNS_40661956134225
* cell instance $327 r0 *1 18.775,234.26
X$327 7 6 M2_M1_CDNS_40661956134495
* cell instance $328 r0 *1 19.61,233.985
X$328 7 6 M3_M2_CDNS_40661956134225
* cell instance $329 r0 *1 18.775,214.52
X$329 7 6 M2_M1_CDNS_40661956134495
* cell instance $330 r0 *1 19.61,209.985
X$330 7 6 M3_M2_CDNS_40661956134225
* cell instance $331 r0 *1 19.61,217.985
X$331 7 6 M3_M2_CDNS_40661956134225
* cell instance $332 r0 *1 19.61,57.985
X$332 7 6 M3_M2_CDNS_40661956134225
* cell instance $333 r0 *1 19.61,77.985
X$333 7 6 M3_M2_CDNS_40661956134227
* cell instance $334 r0 *1 19.61,79.745
X$334 7 6 M2_M1_CDNS_40661956134207
* cell instance $335 r0 *1 19.61,84.44
X$335 7 6 M2_M1_CDNS_40661956134250
* cell instance $336 r0 *1 19.61,109.985
X$336 7 6 M3_M2_CDNS_40661956134227
* cell instance $337 r0 *1 19.61,102.215
X$337 7 6 M2_M1_CDNS_40661956134207
* cell instance $338 r0 *1 18.775,115.82
X$338 7 6 M2_M1_CDNS_40661956134495
* cell instance $339 r0 *1 19.61,125.985
X$339 7 6 M3_M2_CDNS_40661956134227
* cell instance $340 r0 *1 18.775,135.56
X$340 7 6 M2_M1_CDNS_40661956134495
* cell instance $341 r0 *1 19.61,145.985
X$341 7 6 M3_M2_CDNS_40661956134225
* cell instance $342 r0 *1 18.775,155.3
X$342 7 6 M2_M1_CDNS_40661956134495
* cell instance $343 r0 *1 19.61,157.985
X$343 7 6 M3_M2_CDNS_40661956134227
* cell instance $344 r0 *1 19.61,93.985
X$344 7 6 M3_M2_CDNS_40661956134227
* cell instance $345 r0 *1 19.61,88.8
X$345 7 6 M2_M1_CDNS_40661956134250
* cell instance $346 r0 *1 19.61,93.16
X$346 7 6 M2_M1_CDNS_40661956134250
* cell instance $347 r0 *1 19.61,97.52
X$347 7 6 M2_M1_CDNS_40661956134250
* cell instance $348 r0 *1 13.39,90.98
X$348 7 16 7 43 M1_NWELL_CDNS_40661956134483
* cell instance $349 r0 *1 61.93,90.98
X$349 7 16 7 43 M1_NWELL_CDNS_40661956134483
* cell instance $350 r0 *1 6.18,234.26
X$350 7 24 M2_M1_CDNS_40661956134492
* cell instance $351 r0 *1 6.18,233.985
X$351 7 24 M3_M2_CDNS_40661956134223
* cell instance $352 r0 *1 6.18,254
X$352 7 24 M2_M1_CDNS_40661956134492
* cell instance $353 r0 *1 6.18,214.52
X$353 7 24 M2_M1_CDNS_40661956134492
* cell instance $354 r0 *1 6.18,209.985
X$354 7 24 M3_M2_CDNS_40661956134223
* cell instance $355 r0 *1 6.18,217.985
X$355 7 24 M3_M2_CDNS_40661956134223
* cell instance $356 m90 *1 43.515,234.26
X$356 7 12 M2_M1_CDNS_40661956134495
* cell instance $357 m90 *1 44.35,233.985
X$357 7 12 M3_M2_CDNS_40661956134225
* cell instance $358 m90 *1 43.515,175.04
X$358 7 12 M2_M1_CDNS_40661956134495
* cell instance $359 m90 *1 56.545,194.78
X$359 7 14 M2_M1_CDNS_40661956134495
* cell instance $360 m90 *1 69.68,194.78
X$360 7 27 M2_M1_CDNS_40661956134494
* cell instance $361 m90 *1 55.71,201.985
X$361 7 14 M3_M2_CDNS_40661956134225
* cell instance $362 m90 *1 69.91,201.985
X$362 7 27 M3_M2_CDNS_40661956134225
* cell instance $363 m90 *1 43.515,254
X$363 7 12 M2_M1_CDNS_40661956134495
* cell instance $364 m90 *1 43.515,273.74
X$364 7 12 M2_M1_CDNS_40661956134495
* cell instance $365 m90 *1 44.35,273.985
X$365 7 12 M3_M2_CDNS_40661956134225
* cell instance $366 m90 *1 43.515,194.78
X$366 7 12 M2_M1_CDNS_40661956134495
* cell instance $367 m90 *1 44.35,201.985
X$367 7 12 M3_M2_CDNS_40661956134225
* cell instance $368 m90 *1 56.545,273.74
X$368 7 14 M2_M1_CDNS_40661956134495
* cell instance $369 m90 *1 55.71,273.985
X$369 7 14 M3_M2_CDNS_40661956134225
* cell instance $370 m90 *1 69.68,273.74
X$370 7 27 M2_M1_CDNS_40661956134494
* cell instance $371 m90 *1 69.91,273.985
X$371 7 27 M3_M2_CDNS_40661956134225
* cell instance $372 m90 *1 56.545,214.52
X$372 7 14 M2_M1_CDNS_40661956134495
* cell instance $373 m90 *1 55.71,209.985
X$373 7 14 M3_M2_CDNS_40661956134225
* cell instance $374 m90 *1 69.68,214.52
X$374 7 27 M2_M1_CDNS_40661956134494
* cell instance $375 m90 *1 69.91,209.985
X$375 7 27 M3_M2_CDNS_40661956134225
* cell instance $376 m90 *1 55.71,217.985
X$376 7 14 M3_M2_CDNS_40661956134225
* cell instance $377 m90 *1 69.91,217.985
X$377 7 27 M3_M2_CDNS_40661956134225
* cell instance $378 m90 *1 43.515,214.52
X$378 7 12 M2_M1_CDNS_40661956134495
* cell instance $379 m90 *1 44.35,209.985
X$379 7 12 M3_M2_CDNS_40661956134225
* cell instance $380 m90 *1 44.35,217.985
X$380 7 12 M3_M2_CDNS_40661956134225
* cell instance $381 m90 *1 56.545,254
X$381 7 14 M2_M1_CDNS_40661956134495
* cell instance $382 m90 *1 69.68,254
X$382 7 27 M2_M1_CDNS_40661956134494
* cell instance $383 m90 *1 56.545,234.26
X$383 7 14 M2_M1_CDNS_40661956134495
* cell instance $384 m90 *1 55.71,233.985
X$384 7 14 M3_M2_CDNS_40661956134225
* cell instance $385 m90 *1 69.68,234.26
X$385 7 27 M2_M1_CDNS_40661956134494
* cell instance $386 m90 *1 69.91,233.985
X$386 7 27 M3_M2_CDNS_40661956134225
* cell instance $387 r0 *1 31.805,273.74
X$387 7 9 M2_M1_CDNS_40661956134495
* cell instance $388 r0 *1 30.97,273.985
X$388 7 9 M3_M2_CDNS_40661956134225
* cell instance $389 r0 *1 31.805,254
X$389 7 9 M2_M1_CDNS_40661956134495
* cell instance $390 r0 *1 31.805,234.26
X$390 7 9 M2_M1_CDNS_40661956134495
* cell instance $391 r0 *1 30.97,233.985
X$391 7 9 M3_M2_CDNS_40661956134225
* cell instance $392 r0 *1 31.805,214.52
X$392 7 9 M2_M1_CDNS_40661956134495
* cell instance $393 r0 *1 30.97,209.985
X$393 7 9 M3_M2_CDNS_40661956134225
* cell instance $394 r0 *1 30.97,217.985
X$394 7 9 M3_M2_CDNS_40661956134225
* cell instance $395 r0 *1 31.805,175.04
X$395 7 9 M2_M1_CDNS_40661956134495
* cell instance $396 r0 *1 31.805,194.78
X$396 7 9 M2_M1_CDNS_40661956134495
* cell instance $397 r0 *1 30.97,201.985
X$397 7 9 M3_M2_CDNS_40661956134225
* cell instance $398 m90 *1 69.68,175.04
X$398 7 27 M2_M1_CDNS_40661956134494
* cell instance $399 m90 *1 56.545,175.04
X$399 7 14 M2_M1_CDNS_40661956134495
* cell instance $400 r0 *1 5.64,175.04
X$400 7 24 M2_M1_CDNS_40661956134494
* cell instance $401 r0 *1 5.64,273.74
X$401 7 24 M2_M1_CDNS_40661956134494
* cell instance $402 r0 *1 5.41,273.985
X$402 7 24 M3_M2_CDNS_40661956134225
* cell instance $403 r0 *1 37.66,79.73
X$403 7 7 43 16 M1_NWELL_CDNS_40661956134487
* cell instance $404 r0 *1 37.66,102.23
X$404 7 7 43 16 M1_NWELL_CDNS_40661956134487
* cell instance $405 r0 *1 6.18,194.78
X$405 7 24 M2_M1_CDNS_40661956134492
* cell instance $406 r0 *1 6.18,201.985
X$406 7 24 M3_M2_CDNS_40661956134223
* cell instance $407 m90 *1 64.23,145.985
X$407 7 30 M3_M2_CDNS_40661956134225
* cell instance $408 m90 *1 64.23,273.985
X$408 7 30 M3_M2_CDNS_40661956134225
* cell instance $409 m90 *1 64.23,217.985
X$409 7 30 M3_M2_CDNS_40661956134225
* cell instance $410 m90 *1 64.23,201.985
X$410 7 30 M3_M2_CDNS_40661956134225
* cell instance $411 m90 *1 69.91,57.985
X$411 7 27 M3_M2_CDNS_40661956134225
* cell instance $412 m90 *1 64.23,209.985
X$412 7 30 M3_M2_CDNS_40661956134225
* cell instance $413 m90 *1 64.23,233.985
X$413 7 30 M3_M2_CDNS_40661956134225
* cell instance $414 r0 *1 11.09,145.985
X$414 7 22 M3_M2_CDNS_40661956134225
* cell instance $415 r0 *1 11.09,201.985
X$415 7 22 M3_M2_CDNS_40661956134225
* cell instance $416 r0 *1 11.09,209.985
X$416 7 22 M3_M2_CDNS_40661956134225
* cell instance $417 r0 *1 11.09,233.985
X$417 7 22 M3_M2_CDNS_40661956134225
* cell instance $418 r0 *1 11.09,273.985
X$418 7 22 M3_M2_CDNS_40661956134225
* cell instance $419 r0 *1 11.09,217.985
X$419 7 22 M3_M2_CDNS_40661956134225
* cell instance $420 r0 *1 11.09,57.985
X$420 7 22 M3_M2_CDNS_40661956134225
* cell instance $421 r0 *1 30.97,57.985
X$421 7 9 M3_M2_CDNS_40661956134225
* cell instance $422 m90 *1 44.35,57.985
X$422 7 12 M3_M2_CDNS_40661956134225
* cell instance $423 m90 *1 55.71,57.985
X$423 7 14 M3_M2_CDNS_40661956134225
* cell instance $424 m90 *1 64.23,57.985
X$424 7 30 M3_M2_CDNS_40661956134225
* cell instance $425 r0 *1 11.09,77.985
X$425 7 22 M3_M2_CDNS_40661956134227
* cell instance $426 r0 *1 30.97,79.745
X$426 7 9 M2_M1_CDNS_40661956134207
* cell instance $427 r0 *1 30.97,77.985
X$427 7 9 M3_M2_CDNS_40661956134227
* cell instance $428 r0 *1 44.35,79.745
X$428 7 12 M2_M1_CDNS_40661956134207
* cell instance $429 m90 *1 44.35,77.985
X$429 7 12 M3_M2_CDNS_40661956134227
* cell instance $430 r0 *1 55.71,79.745
X$430 7 14 M2_M1_CDNS_40661956134207
* cell instance $431 m90 *1 55.71,77.985
X$431 7 14 M3_M2_CDNS_40661956134227
* cell instance $432 m90 *1 64.23,77.985
X$432 7 30 M3_M2_CDNS_40661956134227
* cell instance $433 r0 *1 17.66,83.94
X$433 7 np_6p0_CDNS_406619561349
* cell instance $434 r0 *1 30.97,84.44
X$434 7 9 M2_M1_CDNS_40661956134250
* cell instance $435 r0 *1 44.35,84.44
X$435 7 12 M2_M1_CDNS_40661956134250
* cell instance $436 r0 *1 55.71,84.44
X$436 7 14 M2_M1_CDNS_40661956134250
* cell instance $437 r0 *1 5.41,57.985
X$437 7 24 M3_M2_CDNS_40661956134225
* cell instance $438 m90 *1 69.91,93.985
X$438 7 27 M3_M2_CDNS_40661956134227
* cell instance $439 m90 *1 64.23,109.985
X$439 7 30 M3_M2_CDNS_40661956134227
* cell instance $440 m90 *1 64.23,157.985
X$440 7 30 M3_M2_CDNS_40661956134227
* cell instance $441 m90 *1 64.23,93.985
X$441 7 30 M3_M2_CDNS_40661956134227
* cell instance $442 m90 *1 64.23,125.985
X$442 7 30 M3_M2_CDNS_40661956134227
* cell instance $443 m90 *1 69.91,77.985
X$443 7 27 M3_M2_CDNS_40661956134227
* cell instance $444 r0 *1 5.41,77.985
X$444 7 24 M3_M2_CDNS_40661956134227
* cell instance $445 r0 *1 11.09,125.985
X$445 7 22 M3_M2_CDNS_40661956134227
* cell instance $446 r0 *1 11.09,157.985
X$446 7 22 M3_M2_CDNS_40661956134227
* cell instance $447 r0 *1 11.09,109.985
X$447 7 22 M3_M2_CDNS_40661956134227
* cell instance $448 r0 *1 5.41,93.985
X$448 7 24 M3_M2_CDNS_40661956134227
* cell instance $449 r0 *1 11.09,93.985
X$449 7 22 M3_M2_CDNS_40661956134227
* cell instance $450 r0 *1 17.66,88.3
X$450 7 np_6p0_CDNS_406619561349
* cell instance $451 r0 *1 30.97,88.8
X$451 7 9 M2_M1_CDNS_40661956134250
* cell instance $452 r0 *1 30.97,93.985
X$452 7 9 M3_M2_CDNS_40661956134227
* cell instance $453 r0 *1 44.35,88.8
X$453 7 12 M2_M1_CDNS_40661956134250
* cell instance $454 m90 *1 44.35,93.985
X$454 7 12 M3_M2_CDNS_40661956134227
* cell instance $455 r0 *1 55.71,88.8
X$455 7 14 M2_M1_CDNS_40661956134250
* cell instance $456 m90 *1 55.71,93.985
X$456 7 14 M3_M2_CDNS_40661956134227
* cell instance $457 r0 *1 17.66,92.66
X$457 7 np_6p0_CDNS_406619561349
* cell instance $458 r0 *1 30.97,93.16
X$458 7 9 M2_M1_CDNS_40661956134250
* cell instance $459 r0 *1 44.35,93.16
X$459 7 12 M2_M1_CDNS_40661956134250
* cell instance $460 r0 *1 55.71,93.16
X$460 7 14 M2_M1_CDNS_40661956134250
* cell instance $461 r0 *1 17.66,97.02
X$461 7 np_6p0_CDNS_406619561349
* cell instance $462 r0 *1 30.97,97.52
X$462 7 9 M2_M1_CDNS_40661956134250
* cell instance $463 r0 *1 44.35,97.52
X$463 7 12 M2_M1_CDNS_40661956134250
* cell instance $464 r0 *1 55.71,97.52
X$464 7 14 M2_M1_CDNS_40661956134250
* cell instance $465 r0 *1 30.97,102.215
X$465 7 9 M2_M1_CDNS_40661956134207
* cell instance $466 r0 *1 30.97,109.985
X$466 7 9 M3_M2_CDNS_40661956134227
* cell instance $467 r0 *1 44.35,102.215
X$467 7 12 M2_M1_CDNS_40661956134207
* cell instance $468 m90 *1 44.35,109.985
X$468 7 12 M3_M2_CDNS_40661956134227
* cell instance $469 r0 *1 55.71,102.215
X$469 7 14 M2_M1_CDNS_40661956134207
* cell instance $470 m90 *1 55.71,109.985
X$470 7 14 M3_M2_CDNS_40661956134227
* cell instance $471 r0 *1 5.64,115.82
X$471 7 24 M2_M1_CDNS_40661956134494
* cell instance $472 r0 *1 5.41,125.985
X$472 7 24 M3_M2_CDNS_40661956134227
* cell instance $473 r0 *1 5.41,109.985
X$473 7 24 M3_M2_CDNS_40661956134227
* cell instance $474 r0 *1 31.805,115.82
X$474 7 9 M2_M1_CDNS_40661956134495
* cell instance $475 r0 *1 30.97,125.985
X$475 7 9 M3_M2_CDNS_40661956134227
* cell instance $476 m90 *1 43.515,115.82
X$476 7 12 M2_M1_CDNS_40661956134495
* cell instance $477 m90 *1 44.35,125.985
X$477 7 12 M3_M2_CDNS_40661956134227
* cell instance $478 m90 *1 56.545,115.82
X$478 7 14 M2_M1_CDNS_40661956134495
* cell instance $479 m90 *1 55.71,125.985
X$479 7 14 M3_M2_CDNS_40661956134227
* cell instance $480 m90 *1 69.68,115.82
X$480 7 27 M2_M1_CDNS_40661956134494
* cell instance $481 m90 *1 69.91,109.985
X$481 7 27 M3_M2_CDNS_40661956134227
* cell instance $482 m90 *1 69.91,125.985
X$482 7 27 M3_M2_CDNS_40661956134227
* cell instance $483 r0 *1 5.64,135.56
X$483 7 24 M2_M1_CDNS_40661956134494
* cell instance $484 r0 *1 31.805,135.56
X$484 7 9 M2_M1_CDNS_40661956134495
* cell instance $485 m90 *1 43.515,135.56
X$485 7 12 M2_M1_CDNS_40661956134495
* cell instance $486 m90 *1 56.545,135.56
X$486 7 14 M2_M1_CDNS_40661956134495
* cell instance $487 m90 *1 69.68,135.56
X$487 7 27 M2_M1_CDNS_40661956134494
* cell instance $488 r0 *1 5.64,155.3
X$488 7 24 M2_M1_CDNS_40661956134494
* cell instance $489 r0 *1 5.41,145.985
X$489 7 24 M3_M2_CDNS_40661956134225
* cell instance $490 r0 *1 30.97,145.985
X$490 7 9 M3_M2_CDNS_40661956134225
* cell instance $491 m90 *1 44.35,145.985
X$491 7 12 M3_M2_CDNS_40661956134225
* cell instance $492 m90 *1 55.71,145.985
X$492 7 14 M3_M2_CDNS_40661956134225
* cell instance $493 m90 *1 69.91,145.985
X$493 7 27 M3_M2_CDNS_40661956134225
* cell instance $494 m90 *1 69.68,155.3
X$494 7 27 M2_M1_CDNS_40661956134494
* cell instance $495 r0 *1 5.41,157.985
X$495 7 24 M3_M2_CDNS_40661956134227
* cell instance $496 r0 *1 31.805,155.3
X$496 7 9 M2_M1_CDNS_40661956134495
* cell instance $497 r0 *1 30.97,157.985
X$497 7 9 M3_M2_CDNS_40661956134227
* cell instance $498 m90 *1 43.515,155.3
X$498 7 12 M2_M1_CDNS_40661956134495
* cell instance $499 m90 *1 44.35,157.985
X$499 7 12 M3_M2_CDNS_40661956134227
* cell instance $500 m90 *1 56.545,155.3
X$500 7 14 M2_M1_CDNS_40661956134495
* cell instance $501 m90 *1 55.71,157.985
X$501 7 14 M3_M2_CDNS_40661956134227
* cell instance $502 m90 *1 69.91,157.985
X$502 7 27 M3_M2_CDNS_40661956134227
* cell instance $503 r0 *1 4.64,193.985
X$503 26 25 M3_M2_CDNS_40661956134223
* cell instance $504 r0 *1 4.64,249.985
X$504 26 25 M3_M2_CDNS_40661956134223
* cell instance $505 m90 *1 66.3,257.985
X$505 29 28 M3_M2_CDNS_40661956134223
* cell instance $506 m90 *1 66.3,185.985
X$506 29 28 M3_M2_CDNS_40661956134223
.ENDS GF_NI_ASIG_5P0_BASE

* cell 3LM_METAL_RAIL_PAD_60
* pin
* pin
* pin
* pin
* pin
* pin
* pin
* pin
.SUBCKT 3LM_METAL_RAIL_PAD_60 1 2 3 4 5 6 7 8
* cell instance $1 r0 *1 0,0
X$1 1 8 4 7 6 5 3LM_METAL_RAIL
* cell instance $2 r0 *1 5.5,0
X$2 3 2 Bondpad_3LM
.ENDS 3LM_METAL_RAIL_PAD_60

* cell M2_M1_CDNS_40661956134168
* pin
* pin
.SUBCKT M2_M1_CDNS_40661956134168 1 2
.ENDS M2_M1_CDNS_40661956134168

* cell M2_M1_CDNS_40661956134169
* pin
* pin
.SUBCKT M2_M1_CDNS_40661956134169 1 2
.ENDS M2_M1_CDNS_40661956134169

* cell M3_M2_CDNS_40661956134170
* pin
* pin
.SUBCKT M3_M2_CDNS_40661956134170 1 2
.ENDS M3_M2_CDNS_40661956134170

* cell M3_M2_CDNS_40661956134171
* pin
* pin
.SUBCKT M3_M2_CDNS_40661956134171 1 2
.ENDS M3_M2_CDNS_40661956134171

* cell M1_PSUB_CDNS_40661956134167
* pin
* pin
.SUBCKT M1_PSUB_CDNS_40661956134167 1 2
.ENDS M1_PSUB_CDNS_40661956134167

* cell POLY_SUB_FILL
* pin
* pin
* pin
.SUBCKT POLY_SUB_FILL 1 2 5
* cell instance $1 r0 *1 6.58,5.225
X$1 1 5 M2_M1_CDNS_40661956134178
* cell instance $2 m0 *1 6.58,1.765
X$2 1 5 M2_M1_CDNS_40661956134178
* cell instance $3 r0 *1 6.58,3.205
X$3 1 5 M2_M1_CDNS_40661956134178
* cell instance $4 r0 *1 6.58,-0.255
X$4 1 5 M2_M1_CDNS_40661956134178
* device instance $1 r0 *1 6.575,4.215 nmoscap_6p0
C$1 1 2 5.175e-15 nmoscap_6p0 A=2.25P P=6U
* device instance $2 r0 *1 6.575,0.755 nmoscap_6p0
C$2 1 2 5.175e-15 nmoscap_6p0 A=2.25P P=6U
.ENDS POLY_SUB_FILL

* cell M2_M1_CDNS_40661956134173
* pin
* pin
.SUBCKT M2_M1_CDNS_40661956134173 1 2
.ENDS M2_M1_CDNS_40661956134173

* cell M3_M2_CDNS_40661956134177
* pin
* pin
.SUBCKT M3_M2_CDNS_40661956134177 1 2
.ENDS M3_M2_CDNS_40661956134177

* cell M1_PSUB_CDNS_40661956134174
* pin
* pin
.SUBCKT M1_PSUB_CDNS_40661956134174 1 2
.ENDS M1_PSUB_CDNS_40661956134174

* cell M3_M2_CDNS_40661956134181
* pin
* pin
.SUBCKT M3_M2_CDNS_40661956134181 1 2
.ENDS M3_M2_CDNS_40661956134181

* cell M2_M1_CDNS_40661956134179
* pin
* pin
.SUBCKT M2_M1_CDNS_40661956134179 1 2
.ENDS M2_M1_CDNS_40661956134179

* cell POLY_SUB_FILL_1
* pin
* pin
* pin
.SUBCKT POLY_SUB_FILL_1 1 2 3
* device instance $1 r0 *1 6.425,4.615 nmoscap_6p0
C$1 2 1 9.66e-14 nmoscap_6p0 A=42P P=26U
* device instance $2 r0 *1 6.425,12.175 nmoscap_6p0
C$2 2 1 9.66e-14 nmoscap_6p0 A=42P P=26U
.ENDS POLY_SUB_FILL_1

* cell M3_M2_CDNS_40661956134172
* pin
* pin
.SUBCKT M3_M2_CDNS_40661956134172 1 2
.ENDS M3_M2_CDNS_40661956134172

* cell M3_M2_CDNS_40661956134175
* pin
* pin
.SUBCKT M3_M2_CDNS_40661956134175 1 2
.ENDS M3_M2_CDNS_40661956134175

* cell M1_PSUB_CDNS_40661956134182
* pin
* pin
.SUBCKT M1_PSUB_CDNS_40661956134182 1 2
.ENDS M1_PSUB_CDNS_40661956134182

* cell M2_M1_CDNS_40661956134208
* pin
* pin
.SUBCKT M2_M1_CDNS_40661956134208 1 2
.ENDS M2_M1_CDNS_40661956134208

* cell M2_M1_CDNS_40661956134209
* pin
* pin
.SUBCKT M2_M1_CDNS_40661956134209 1 2
.ENDS M2_M1_CDNS_40661956134209

* cell M2_M1_CDNS_40661956134210
* pin
* pin
.SUBCKT M2_M1_CDNS_40661956134210 1 2
.ENDS M2_M1_CDNS_40661956134210

* cell M2_M1_CDNS_40661956134211
* pin
* pin
.SUBCKT M2_M1_CDNS_40661956134211 1 2
.ENDS M2_M1_CDNS_40661956134211

* cell M2_M1_CDNS_40661956134212
* pin
* pin
.SUBCKT M2_M1_CDNS_40661956134212 1 2
.ENDS M2_M1_CDNS_40661956134212

* cell M2_M1_CDNS_40661956134213
* pin
* pin
.SUBCKT M2_M1_CDNS_40661956134213 1 2
.ENDS M2_M1_CDNS_40661956134213

* cell M2_M1_CDNS_40661956134214
* pin
* pin
.SUBCKT M2_M1_CDNS_40661956134214 1 2
.ENDS M2_M1_CDNS_40661956134214

* cell M2_M1_CDNS_40661956134216
* pin
* pin
.SUBCKT M2_M1_CDNS_40661956134216 1 2
.ENDS M2_M1_CDNS_40661956134216

* cell M2_M1_CDNS_40661956134215
* pin
* pin
.SUBCKT M2_M1_CDNS_40661956134215 1 2
.ENDS M2_M1_CDNS_40661956134215

* cell M2_M1_CDNS_40661956134220
* pin
* pin
.SUBCKT M2_M1_CDNS_40661956134220 1 2
.ENDS M2_M1_CDNS_40661956134220

* cell comp018green_esd_clamp_v5p0_DVDD
* pin
* pin
* pin
* pin
* pin
* pin
* pin
* pin
* pin
* pin
* pin
* pin
* pin
* pin gf180mcu_gnd
.SUBCKT comp018green_esd_clamp_v5p0_DVDD 1 3 8 9 11 12 13 14 15 16 18 19 20 21
* net 21 gf180mcu_gnd
* cell instance $1 m90 *1 32.405,128.805
X$1 1 14 M2_M1_CDNS_40661956134232
* cell instance $2 r0 *1 0,0
X$2 6 3 1 8 25 9 18 16 15 14 13 12 11 24 19 20 21 nmos_clamp_20_50_4_DVDD
* cell instance $3 m90 *1 19.715,137.29
X$3 1 11 M2_M1_CDNS_40661956134237
* cell instance $4 r0 *1 25.66,137.31
X$4 1 4 M1_PSUB_CDNS_40661956134243
* cell instance $5 m90 *1 31.935,137.29
X$5 1 14 M2_M1_CDNS_40661956134245
* cell instance $6 m90 *1 45.095,137.29
X$6 1 16 M2_M1_CDNS_40661956134237
* cell instance $7 r0 *1 42.775,137.31
X$7 1 4 M1_PSUB_CDNS_40661956134244
* cell instance $8 m90 *1 45.095,128.805
X$8 1 16 M2_M1_CDNS_40661956134237
* cell instance $9 m90 *1 56.945,128.805
X$9 1 19 M2_M1_CDNS_40661956134237
* cell instance $10 m90 *1 19.715,128.805
X$10 1 11 M2_M1_CDNS_40661956134237
* cell instance $11 r0 *1 7.865,128.805
X$11 1 9 M2_M1_CDNS_40661956134237
* cell instance $12 r0 *1 20.645,130.03
X$12 1 5 2 21 nmos_6p0_CDNS_406619561347
* cell instance $13 m0 *1 11.49,132.61
X$13 1 4 M1_PSUB_CDNS_40661956134125
* cell instance $14 m0 *1 53.32,132.61
X$14 1 4 M1_PSUB_CDNS_40661956134125
* cell instance $15 r0 *1 33.275,130.03
X$15 23 1 6 1 6 1 6 1 7 7 7 7 7 7 nmos_6p0_CDNS_406619561346
* cell instance $16 r0 *1 25.955,130.03
X$16 23 1 7 1 7 1 7 1 5 5 5 5 5 5 nmos_6p0_CDNS_406619561346
* cell instance $17 m0 *1 -1.78,232.535
X$17 3 2 1 21 comp018green_esd_rc_v5p0
* cell instance $18 r0 *1 7.865,208.275
X$18 1 9 M2_M1_CDNS_40661956134235
* cell instance $19 r0 *1 7.865,178.31
X$19 1 9 M2_M1_CDNS_40661956134239
* cell instance $20 r0 *1 7.865,147.855
X$20 1 9 M2_M1_CDNS_40661956134235
* cell instance $21 r0 *1 19.715,178.31
X$21 1 11 M2_M1_CDNS_40661956134239
* cell instance $22 r0 *1 19.715,147.855
X$22 1 11 M2_M1_CDNS_40661956134235
* cell instance $23 r0 *1 19.715,208.275
X$23 1 11 M2_M1_CDNS_40661956134235
* cell instance $24 r0 *1 32.405,208.275
X$24 1 14 M2_M1_CDNS_40661956134231
* cell instance $25 r0 *1 32.405,147.855
X$25 1 14 M2_M1_CDNS_40661956134231
* cell instance $26 r0 *1 32.405,178.31
X$26 1 14 M2_M1_CDNS_40661956134241
* cell instance $27 r0 *1 45.095,147.855
X$27 1 16 M2_M1_CDNS_40661956134235
* cell instance $28 r0 *1 45.095,208.275
X$28 1 16 M2_M1_CDNS_40661956134235
* cell instance $29 r0 *1 45.095,178.31
X$29 1 16 M2_M1_CDNS_40661956134239
* cell instance $30 r0 *1 56.945,208.275
X$30 1 19 M2_M1_CDNS_40661956134235
* cell instance $31 r0 *1 56.945,178.31
X$31 1 19 M2_M1_CDNS_40661956134239
* cell instance $32 r0 *1 56.945,147.855
X$32 1 19 M2_M1_CDNS_40661956134235
* cell instance $33 r0 *1 20.71,135.54
X$33 2 M1_POLY2_CDNS_40661956134128
* cell instance $34 r0 *1 15.505,138.435
X$34 2 M1_POLY2_CDNS_40661956134127
* cell instance $35 r0 *1 13.325,139.585
X$35 22 5 3 5 3 3 2 2 2 2 17 3 pmos_6p0_CDNS_406619561344
* cell instance $36 r0 *1 18.205,139.585
X$36 22 7 3 3 7 5 5 5 17 3 pmos_6p0_CDNS_406619561343
* cell instance $37 r0 *1 22.725,139.585
X$37 3 6 3 6 3 6 3 6 3 6 3 6 3 6 3 6 3 6 3 6 3 6 3 6 3 7 7 7 7 7 7 7 7 7 7 7 7
+ 7 7 7 7 7 7 7 7 7 7 7 7 17 3 pmos_6p0_CDNS_406619561342
* cell instance $38 r0 *1 13.065,142.635
X$38 3 12 M2_M1_CDNS_40661956134242
* cell instance $39 r0 *1 11.49,142.235
X$39 3 10 17 3 M1_NWELL_CDNS_40661956134133
* cell instance $40 r0 *1 11.51,142.555
X$40 3 12 M2_M1_CDNS_40661956134240
* cell instance $41 r0 *1 32.405,145.825
X$41 3 10 17 3 M1_NWELL_CDNS_40661956134129
* cell instance $42 r0 *1 15.505,142.635
X$42 3 12 M2_M1_CDNS_40661956134242
* cell instance $43 r0 *1 17.945,142.635
X$43 3 12 M2_M1_CDNS_40661956134242
* cell instance $44 r0 *1 22.465,142.635
X$44 3 13 M2_M1_CDNS_40661956134242
* cell instance $45 r0 *1 24.905,142.635
X$45 3 13 M2_M1_CDNS_40661956134242
* cell instance $46 r0 *1 27.345,142.635
X$46 3 13 M2_M1_CDNS_40661956134242
* cell instance $47 r0 *1 29.785,142.635
X$47 3 13 M2_M1_CDNS_40661956134242
* cell instance $48 r0 *1 34.665,142.635
X$48 3 15 M2_M1_CDNS_40661956134242
* cell instance $49 r0 *1 37.105,142.635
X$49 3 15 M2_M1_CDNS_40661956134242
* cell instance $50 r0 *1 39.545,142.635
X$50 3 15 M2_M1_CDNS_40661956134242
* cell instance $51 r0 *1 41.985,142.635
X$51 3 15 M2_M1_CDNS_40661956134242
* cell instance $52 r0 *1 46.865,142.635
X$52 3 18 M2_M1_CDNS_40661956134242
* cell instance $53 r0 *1 49.305,142.635
X$53 3 18 M2_M1_CDNS_40661956134242
* cell instance $54 r0 *1 51.745,142.635
X$54 3 18 M2_M1_CDNS_40661956134242
* cell instance $55 r0 *1 53.3,142.635
X$55 3 18 M2_M1_CDNS_40661956134242
* cell instance $56 r0 *1 53.32,142.235
X$56 3 10 17 3 M1_NWELL_CDNS_40661956134133
* cell instance $57 r0 *1 -1.415,220.08
X$57 3 8 M2_M1_CDNS_40661956134236
* cell instance $58 r0 *1 2.47,229.44
X$58 3 8 M2_M1_CDNS_40661956134234
* cell instance $59 r0 *1 3.225,210.74
X$59 3 8 M2_M1_CDNS_40661956134233
* cell instance $60 r0 *1 13.79,210.74
X$60 3 12 M2_M1_CDNS_40661956134238
* cell instance $61 r0 *1 13.79,229.44
X$61 3 12 M2_M1_CDNS_40661956134238
* cell instance $62 r0 *1 25.64,210.74
X$62 3 13 M2_M1_CDNS_40661956134238
* cell instance $63 r0 *1 25.64,229.44
X$63 3 13 M2_M1_CDNS_40661956134238
* cell instance $64 r0 *1 39.17,210.74
X$64 3 15 M2_M1_CDNS_40661956134238
* cell instance $65 r0 *1 39.17,229.44
X$65 3 15 M2_M1_CDNS_40661956134238
* cell instance $66 r0 *1 51.02,229.44
X$66 3 18 M2_M1_CDNS_40661956134238
* cell instance $67 r0 *1 51.02,210.74
X$67 3 18 M2_M1_CDNS_40661956134238
* cell instance $68 r0 *1 62.405,210.74
X$68 3 20 M2_M1_CDNS_40661956134234
* cell instance $69 r0 *1 62.405,229.44
X$69 3 20 M2_M1_CDNS_40661956134234
* cell instance $70 r0 *1 66.225,220.08
X$70 3 20 M2_M1_CDNS_40661956134236
* cell instance $71 r0 *1 29.355,136.18
X$71 5 M1_POLY2_CDNS_40661956134131
* cell instance $72 r0 *1 19.775,138.435
X$72 5 M1_POLY2_CDNS_40661956134130
* cell instance $73 r0 *1 6.565,127.585
X$73 6 25 M2_M1_CDNS_40661956134126
* cell instance $74 r0 *1 58.245,127.585
X$74 6 24 M2_M1_CDNS_40661956134126
* cell instance $75 r0 *1 36.675,136.18
X$75 7 M1_POLY2_CDNS_40661956134131
* cell instance $76 r0 *1 37.105,138.435
X$76 7 M1_POLY2_CDNS_40661956134132
* device instance $1 r0 *1 13.675,142.085 pmos_6p0
M$1 5 2 3 3 pmos_6p0 L=0.7U W=5U AS=2.2P AD=1.3P PS=10.88U PD=5.52U
* device instance $2 r0 *1 14.895,142.085 pmos_6p0
M$2 3 2 5 3 pmos_6p0 L=0.7U W=5U AS=1.3P AD=1.3P PS=5.52U PD=5.52U
* device instance $3 r0 *1 16.115,142.085 pmos_6p0
M$3 5 2 3 3 pmos_6p0 L=0.7U W=5U AS=1.3P AD=1.3P PS=5.52U PD=5.52U
* device instance $4 r0 *1 17.335,142.085 pmos_6p0
M$4 3 2 5 3 pmos_6p0 L=0.7U W=5U AS=1.3P AD=1.3P PS=5.52U PD=5.52U
* device instance $5 r0 *1 18.555,142.085 pmos_6p0
M$5 7 5 3 3 pmos_6p0 L=0.7U W=5U AS=1.3P AD=1.3P PS=5.52U PD=5.52U
* device instance $6 r0 *1 19.775,142.085 pmos_6p0
M$6 3 5 7 3 pmos_6p0 L=0.7U W=5U AS=1.3P AD=1.3P PS=5.52U PD=5.52U
* device instance $7 r0 *1 20.995,142.085 pmos_6p0
M$7 7 5 3 3 pmos_6p0 L=0.7U W=5U AS=1.3P AD=2.2P PS=5.52U PD=10.88U
* device instance $8 r0 *1 23.075,142.085 pmos_6p0
M$8 6 7 3 3 pmos_6p0 L=0.7U W=5U AS=2.2P AD=1.3P PS=10.88U PD=5.52U
* device instance $9 r0 *1 24.295,142.085 pmos_6p0
M$9 3 7 6 3 pmos_6p0 L=0.7U W=5U AS=1.3P AD=1.3P PS=5.52U PD=5.52U
* device instance $10 r0 *1 25.515,142.085 pmos_6p0
M$10 6 7 3 3 pmos_6p0 L=0.7U W=5U AS=1.3P AD=1.3P PS=5.52U PD=5.52U
* device instance $11 r0 *1 26.735,142.085 pmos_6p0
M$11 3 7 6 3 pmos_6p0 L=0.7U W=5U AS=1.3P AD=1.3P PS=5.52U PD=5.52U
* device instance $12 r0 *1 27.955,142.085 pmos_6p0
M$12 6 7 3 3 pmos_6p0 L=0.7U W=5U AS=1.3P AD=1.3P PS=5.52U PD=5.52U
* device instance $13 r0 *1 29.175,142.085 pmos_6p0
M$13 3 7 6 3 pmos_6p0 L=0.7U W=5U AS=1.3P AD=1.3P PS=5.52U PD=5.52U
* device instance $14 r0 *1 30.395,142.085 pmos_6p0
M$14 6 7 3 3 pmos_6p0 L=0.7U W=5U AS=1.3P AD=1.3P PS=5.52U PD=5.52U
* device instance $15 r0 *1 31.615,142.085 pmos_6p0
M$15 3 7 6 3 pmos_6p0 L=0.7U W=5U AS=1.3P AD=1.3P PS=5.52U PD=5.52U
* device instance $16 r0 *1 32.835,142.085 pmos_6p0
M$16 6 7 3 3 pmos_6p0 L=0.7U W=5U AS=1.3P AD=1.3P PS=5.52U PD=5.52U
* device instance $17 r0 *1 34.055,142.085 pmos_6p0
M$17 3 7 6 3 pmos_6p0 L=0.7U W=5U AS=1.3P AD=1.3P PS=5.52U PD=5.52U
* device instance $18 r0 *1 35.275,142.085 pmos_6p0
M$18 6 7 3 3 pmos_6p0 L=0.7U W=5U AS=1.3P AD=1.3P PS=5.52U PD=5.52U
* device instance $19 r0 *1 36.495,142.085 pmos_6p0
M$19 3 7 6 3 pmos_6p0 L=0.7U W=5U AS=1.3P AD=1.3P PS=5.52U PD=5.52U
* device instance $20 r0 *1 37.715,142.085 pmos_6p0
M$20 6 7 3 3 pmos_6p0 L=0.7U W=5U AS=1.3P AD=1.3P PS=5.52U PD=5.52U
* device instance $21 r0 *1 38.935,142.085 pmos_6p0
M$21 3 7 6 3 pmos_6p0 L=0.7U W=5U AS=1.3P AD=1.3P PS=5.52U PD=5.52U
* device instance $22 r0 *1 40.155,142.085 pmos_6p0
M$22 6 7 3 3 pmos_6p0 L=0.7U W=5U AS=1.3P AD=1.3P PS=5.52U PD=5.52U
* device instance $23 r0 *1 41.375,142.085 pmos_6p0
M$23 3 7 6 3 pmos_6p0 L=0.7U W=5U AS=1.3P AD=1.3P PS=5.52U PD=5.52U
* device instance $24 r0 *1 42.595,142.085 pmos_6p0
M$24 6 7 3 3 pmos_6p0 L=0.7U W=5U AS=1.3P AD=1.3P PS=5.52U PD=5.52U
* device instance $25 r0 *1 43.815,142.085 pmos_6p0
M$25 3 7 6 3 pmos_6p0 L=0.7U W=5U AS=1.3P AD=1.3P PS=5.52U PD=5.52U
* device instance $26 r0 *1 45.035,142.085 pmos_6p0
M$26 6 7 3 3 pmos_6p0 L=0.7U W=5U AS=1.3P AD=1.3P PS=5.52U PD=5.52U
* device instance $27 r0 *1 46.255,142.085 pmos_6p0
M$27 3 7 6 3 pmos_6p0 L=0.7U W=5U AS=1.3P AD=1.3P PS=5.52U PD=5.52U
* device instance $28 r0 *1 47.475,142.085 pmos_6p0
M$28 6 7 3 3 pmos_6p0 L=0.7U W=5U AS=1.3P AD=1.3P PS=5.52U PD=5.52U
* device instance $29 r0 *1 48.695,142.085 pmos_6p0
M$29 3 7 6 3 pmos_6p0 L=0.7U W=5U AS=1.3P AD=1.3P PS=5.52U PD=5.52U
* device instance $30 r0 *1 49.915,142.085 pmos_6p0
M$30 6 7 3 3 pmos_6p0 L=0.7U W=5U AS=1.3P AD=1.3P PS=5.52U PD=5.52U
* device instance $31 r0 *1 51.135,142.085 pmos_6p0
M$31 3 7 6 3 pmos_6p0 L=0.7U W=5U AS=1.3P AD=2.2P PS=5.52U PD=10.88U
* device instance $32 r0 *1 26.305,132.53 nmos_6p0
M$32 7 5 1 21 nmos_6p0 L=0.7U W=5U AS=2.2P AD=1.3P PS=10.88U PD=5.52U
* device instance $33 r0 *1 27.525,132.53 nmos_6p0
M$33 1 5 7 21 nmos_6p0 L=0.7U W=5U AS=1.3P AD=1.3P PS=5.52U PD=5.52U
* device instance $34 r0 *1 28.745,132.53 nmos_6p0
M$34 7 5 1 21 nmos_6p0 L=0.7U W=5U AS=1.3P AD=1.3P PS=5.52U PD=5.52U
* device instance $35 r0 *1 29.965,132.53 nmos_6p0
M$35 1 5 7 21 nmos_6p0 L=0.7U W=5U AS=1.3P AD=1.3P PS=5.52U PD=5.52U
* device instance $36 r0 *1 31.185,132.53 nmos_6p0
M$36 7 5 1 21 nmos_6p0 L=0.7U W=5U AS=1.3P AD=1.3P PS=5.52U PD=5.52U
* device instance $37 r0 *1 32.405,132.53 nmos_6p0
M$37 1 5 7 21 nmos_6p0 L=0.7U W=5U AS=1.3P AD=1.3P PS=5.52U PD=5.52U
* device instance $38 r0 *1 33.625,132.53 nmos_6p0
M$38 6 7 1 21 nmos_6p0 L=0.7U W=5U AS=1.3P AD=1.3P PS=5.52U PD=5.52U
* device instance $39 r0 *1 34.845,132.53 nmos_6p0
M$39 1 7 6 21 nmos_6p0 L=0.7U W=5U AS=1.3P AD=1.3P PS=5.52U PD=5.52U
* device instance $40 r0 *1 36.065,132.53 nmos_6p0
M$40 6 7 1 21 nmos_6p0 L=0.7U W=5U AS=1.3P AD=1.3P PS=5.52U PD=5.52U
* device instance $41 r0 *1 37.285,132.53 nmos_6p0
M$41 1 7 6 21 nmos_6p0 L=0.7U W=5U AS=1.3P AD=1.3P PS=5.52U PD=5.52U
* device instance $42 r0 *1 38.505,132.53 nmos_6p0
M$42 6 7 1 21 nmos_6p0 L=0.7U W=5U AS=1.3P AD=1.3P PS=5.52U PD=5.52U
* device instance $43 r0 *1 39.725,132.53 nmos_6p0
M$43 1 7 6 21 nmos_6p0 L=0.7U W=5U AS=1.3P AD=2.2P PS=5.52U PD=10.88U
.ENDS comp018green_esd_clamp_v5p0_DVDD

* cell M3_M2_CDNS_40661956134219
* pin
* pin
.SUBCKT M3_M2_CDNS_40661956134219 1 2
.ENDS M3_M2_CDNS_40661956134219

* cell M2_M1_CDNS_40661956134261
* pin
* pin
.SUBCKT M2_M1_CDNS_40661956134261 1 2
.ENDS M2_M1_CDNS_40661956134261

* cell M2_M1_CDNS_40661956134263
* pin
* pin
.SUBCKT M2_M1_CDNS_40661956134263 1 2
.ENDS M2_M1_CDNS_40661956134263

* cell M2_M1_CDNS_40661956134264
* pin
* pin
.SUBCKT M2_M1_CDNS_40661956134264 1 2
.ENDS M2_M1_CDNS_40661956134264

* cell M3_M2_CDNS_40661956134226
* pin
* pin
.SUBCKT M3_M2_CDNS_40661956134226 1 2
.ENDS M3_M2_CDNS_40661956134226

* cell M2_M1_CDNS_40661956134251
* pin
* pin
.SUBCKT M2_M1_CDNS_40661956134251 1 2
.ENDS M2_M1_CDNS_40661956134251

* cell M2_M1_CDNS_40661956134252
* pin
* pin
.SUBCKT M2_M1_CDNS_40661956134252 1 2
.ENDS M2_M1_CDNS_40661956134252

* cell M2_M1_CDNS_40661956134253
* pin
* pin
.SUBCKT M2_M1_CDNS_40661956134253 1 2
.ENDS M2_M1_CDNS_40661956134253

* cell M2_M1_CDNS_40661956134254
* pin
* pin
.SUBCKT M2_M1_CDNS_40661956134254 1 2
.ENDS M2_M1_CDNS_40661956134254

* cell M2_M1_CDNS_40661956134256
* pin
* pin
.SUBCKT M2_M1_CDNS_40661956134256 1 2
.ENDS M2_M1_CDNS_40661956134256

* cell M1_PSUB_CDNS_40661956134197
* pin
* pin
.SUBCKT M1_PSUB_CDNS_40661956134197 1 2
.ENDS M1_PSUB_CDNS_40661956134197

* cell M3_M2_CDNS_40661956134262
* pin
* pin
.SUBCKT M3_M2_CDNS_40661956134262 1 2
.ENDS M3_M2_CDNS_40661956134262

* cell M3_M2_CDNS_40661956134260
* pin
* pin
.SUBCKT M3_M2_CDNS_40661956134260 1 2
.ENDS M3_M2_CDNS_40661956134260

* cell M3_M2_CDNS_40661956134259
* pin
* pin
.SUBCKT M3_M2_CDNS_40661956134259 1 2
.ENDS M3_M2_CDNS_40661956134259

* cell M3_M2_CDNS_40661956134257
* pin
* pin
.SUBCKT M3_M2_CDNS_40661956134257 1 2
.ENDS M3_M2_CDNS_40661956134257

* cell M1_PSUB_CDNS_40661956134230
* pin
.SUBCKT M1_PSUB_CDNS_40661956134230 1
.ENDS M1_PSUB_CDNS_40661956134230

* cell M1_PSUB_CDNS_40661956134203
* pin
* pin
.SUBCKT M1_PSUB_CDNS_40661956134203 1 2
.ENDS M1_PSUB_CDNS_40661956134203

* cell M1_NWELL_CDNS_40661956134204
* pin
* pin
* pin
* pin
.SUBCKT M1_NWELL_CDNS_40661956134204 1 2 3 4
.ENDS M1_NWELL_CDNS_40661956134204

* cell M3_M2_CDNS_40661956134221
* pin
* pin
.SUBCKT M3_M2_CDNS_40661956134221 1 2
.ENDS M3_M2_CDNS_40661956134221

* cell M3_M2_CDNS_40661956134222
* pin
* pin
.SUBCKT M3_M2_CDNS_40661956134222 1 2
.ENDS M3_M2_CDNS_40661956134222

* cell M1_PSUB_CDNS_40661956134201
* pin
* pin
.SUBCKT M1_PSUB_CDNS_40661956134201 1 2
.ENDS M1_PSUB_CDNS_40661956134201

* cell M1_PSUB_CDNS_40661956134202
* pin
* pin
.SUBCKT M1_PSUB_CDNS_40661956134202 1 2
.ENDS M1_PSUB_CDNS_40661956134202

* cell M1_NWELL_CDNS_40661956134205
* pin
* pin
* pin
* pin
.SUBCKT M1_NWELL_CDNS_40661956134205 1 2 3 4
.ENDS M1_NWELL_CDNS_40661956134205

* cell M1_PSUB_CDNS_40661956134228
* pin
.SUBCKT M1_PSUB_CDNS_40661956134228 1
.ENDS M1_PSUB_CDNS_40661956134228

* cell M1_PSUB_CDNS_40661956134229
* pin
.SUBCKT M1_PSUB_CDNS_40661956134229 1
.ENDS M1_PSUB_CDNS_40661956134229

* cell comp018green_esd_clamp_v5p0_DVSS
* pin
* pin
* pin
* pin
* pin
* pin
* pin
* pin
* pin
* pin
* pin
* pin
* pin
* pin gf180mcu_gnd
.SUBCKT comp018green_esd_clamp_v5p0_DVSS 1 4 8 9 11 12 13 14 15 16 17 19 20 21
* net 21 gf180mcu_gnd
* cell instance $1 r0 *1 0,0
X$1 6 4 1 8 24 9 17 16 15 14 13 12 11 25 19 20 21 nmos_clamp_20_50_4_DVSS
* cell instance $2 r0 *1 14.89,128.765
X$2 1 12 M2_M1_CDNS_40661956134265
* cell instance $3 m90 *1 49.92,128.765
X$3 1 17 M2_M1_CDNS_40661956134265
* cell instance $4 r0 *1 25.64,137.29
X$4 1 13 M2_M1_CDNS_40661956134238
* cell instance $5 r0 *1 25.67,137.31
X$5 1 3 M1_PSUB_CDNS_40661956134243
* cell instance $6 r0 *1 25.64,128.765
X$6 1 13 M2_M1_CDNS_40661956134238
* cell instance $7 r0 *1 42.025,128.765
X$7 1 15 M2_M1_CDNS_40661956134233
* cell instance $8 m90 *1 53.3,132.785
X$8 1 17 M2_M1_CDNS_40661956134242
* cell instance $9 m0 *1 53.32,132.61
X$9 1 3 M1_PSUB_CDNS_40661956134125
* cell instance $10 r0 *1 11.51,132.785
X$10 1 12 M2_M1_CDNS_40661956134242
* cell instance $11 m0 *1 11.49,132.61
X$11 1 3 M1_PSUB_CDNS_40661956134125
* cell instance $12 r0 *1 42.785,137.31
X$12 1 3 M1_PSUB_CDNS_40661956134244
* cell instance $13 r0 *1 39.17,137.29
X$13 1 15 M2_M1_CDNS_40661956134238
* cell instance $14 r0 *1 48.65,137.29
X$14 1 17 M2_M1_CDNS_40661956134267
* cell instance $15 r0 *1 37.89,128.765
X$15 1 15 M2_M1_CDNS_40661956134245
* cell instance $16 r0 *1 35.445,128.765
X$16 1 15 M2_M1_CDNS_40661956134245
* cell instance $17 r0 *1 20.645,130.03
X$17 1 5 2 21 nmos_6p0_CDNS_406619561347
* cell instance $18 r0 *1 33.275,130.03
X$18 23 1 6 1 6 1 6 1 7 7 7 7 7 7 nmos_6p0_CDNS_406619561346
* cell instance $19 r0 *1 25.955,130.03
X$19 23 1 7 1 7 1 7 1 5 5 5 5 5 5 nmos_6p0_CDNS_406619561346
* cell instance $20 r0 *1 13.79,208.275
X$20 1 12 M2_M1_CDNS_40661956134255
* cell instance $21 m0 *1 -1.78,232.535
X$21 4 2 1 21 comp018green_esd_rc_v5p0
* cell instance $22 r0 *1 13.79,147.855
X$22 1 12 M2_M1_CDNS_40661956134255
* cell instance $23 r0 *1 13.79,178.31
X$23 1 12 M2_M1_CDNS_40661956134266
* cell instance $24 r0 *1 25.64,208.275
X$24 1 13 M2_M1_CDNS_40661956134255
* cell instance $25 r0 *1 25.64,147.855
X$25 1 13 M2_M1_CDNS_40661956134255
* cell instance $26 r0 *1 25.64,178.31
X$26 1 13 M2_M1_CDNS_40661956134266
* cell instance $27 r0 *1 39.17,208.275
X$27 1 15 M2_M1_CDNS_40661956134255
* cell instance $28 r0 *1 39.17,147.855
X$28 1 15 M2_M1_CDNS_40661956134255
* cell instance $29 r0 *1 39.17,178.31
X$29 1 15 M2_M1_CDNS_40661956134266
* cell instance $30 r0 *1 51.02,147.855
X$30 1 17 M2_M1_CDNS_40661956134255
* cell instance $31 r0 *1 51.02,208.275
X$31 1 17 M2_M1_CDNS_40661956134255
* cell instance $32 r0 *1 51.02,178.31
X$32 1 17 M2_M1_CDNS_40661956134266
* cell instance $33 r0 *1 20.71,135.54
X$33 2 M1_POLY2_CDNS_40661956134128
* cell instance $34 r0 *1 15.505,138.435
X$34 2 M1_POLY2_CDNS_40661956134127
* cell instance $35 r0 *1 13.325,139.585
X$35 22 5 4 5 4 4 2 2 2 2 18 4 pmos_6p0_CDNS_406619561344
* cell instance $36 m90 *1 19.715,145.805
X$36 4 11 M2_M1_CDNS_40661956134237
* cell instance $37 r0 *1 32.405,145.825
X$37 4 10 18 4 M1_NWELL_CDNS_40661956134129
* cell instance $38 m90 *1 32.405,145.805
X$38 4 14 M2_M1_CDNS_40661956134232
* cell instance $39 m90 *1 45.095,145.805
X$39 4 16 M2_M1_CDNS_40661956134237
* cell instance $40 m90 *1 56.945,145.805
X$40 4 19 M2_M1_CDNS_40661956134237
* cell instance $41 r0 *1 7.865,145.805
X$41 4 9 M2_M1_CDNS_40661956134237
* cell instance $42 r0 *1 53.32,142.235
X$42 4 10 18 4 M1_NWELL_CDNS_40661956134133
* cell instance $43 r0 *1 11.49,142.235
X$43 4 10 18 4 M1_NWELL_CDNS_40661956134133
* cell instance $44 r0 *1 22.725,139.585
X$44 4 6 4 6 4 6 4 6 4 6 4 6 4 6 4 6 4 6 4 6 4 6 4 6 4 7 7 7 7 7 7 7 7 7 7 7 7
+ 7 7 7 7 7 7 7 7 7 7 7 7 18 4 pmos_6p0_CDNS_406619561342
* cell instance $45 r0 *1 18.205,139.585
X$45 22 7 4 4 7 5 5 5 18 4 pmos_6p0_CDNS_406619561343
* cell instance $46 r0 *1 7.865,210.74
X$46 4 9 M2_M1_CDNS_40661956134218
* cell instance $47 r0 *1 7.865,229.44
X$47 4 9 M2_M1_CDNS_40661956134218
* cell instance $48 r0 *1 19.715,210.74
X$48 4 11 M2_M1_CDNS_40661956134218
* cell instance $49 r0 *1 19.715,229.44
X$49 4 11 M2_M1_CDNS_40661956134218
* cell instance $50 r0 *1 32.405,210.74
X$50 4 14 M2_M1_CDNS_40661956134217
* cell instance $51 r0 *1 32.405,229.44
X$51 4 14 M2_M1_CDNS_40661956134217
* cell instance $52 r0 *1 45.095,210.74
X$52 4 16 M2_M1_CDNS_40661956134218
* cell instance $53 r0 *1 45.095,229.44
X$53 4 16 M2_M1_CDNS_40661956134218
* cell instance $54 r0 *1 56.945,210.74
X$54 4 19 M2_M1_CDNS_40661956134218
* cell instance $55 r0 *1 56.945,229.44
X$55 4 19 M2_M1_CDNS_40661956134218
* cell instance $56 r0 *1 29.355,136.18
X$56 5 M1_POLY2_CDNS_40661956134131
* cell instance $57 r0 *1 19.775,138.435
X$57 5 M1_POLY2_CDNS_40661956134130
* cell instance $58 r0 *1 6.565,127.585
X$58 6 24 M2_M1_CDNS_40661956134126
* cell instance $59 r0 *1 58.245,127.585
X$59 6 25 M2_M1_CDNS_40661956134126
* cell instance $60 r0 *1 36.675,136.18
X$60 7 M1_POLY2_CDNS_40661956134131
* cell instance $61 r0 *1 37.105,138.435
X$61 7 M1_POLY2_CDNS_40661956134132
* device instance $1 r0 *1 13.675,142.085 pmos_6p0
M$1 5 2 4 4 pmos_6p0 L=0.7U W=5U AS=2.2P AD=1.3P PS=10.88U PD=5.52U
* device instance $2 r0 *1 14.895,142.085 pmos_6p0
M$2 4 2 5 4 pmos_6p0 L=0.7U W=5U AS=1.3P AD=1.3P PS=5.52U PD=5.52U
* device instance $3 r0 *1 16.115,142.085 pmos_6p0
M$3 5 2 4 4 pmos_6p0 L=0.7U W=5U AS=1.3P AD=1.3P PS=5.52U PD=5.52U
* device instance $4 r0 *1 17.335,142.085 pmos_6p0
M$4 4 2 5 4 pmos_6p0 L=0.7U W=5U AS=1.3P AD=1.3P PS=5.52U PD=5.52U
* device instance $5 r0 *1 18.555,142.085 pmos_6p0
M$5 7 5 4 4 pmos_6p0 L=0.7U W=5U AS=1.3P AD=1.3P PS=5.52U PD=5.52U
* device instance $6 r0 *1 19.775,142.085 pmos_6p0
M$6 4 5 7 4 pmos_6p0 L=0.7U W=5U AS=1.3P AD=1.3P PS=5.52U PD=5.52U
* device instance $7 r0 *1 20.995,142.085 pmos_6p0
M$7 7 5 4 4 pmos_6p0 L=0.7U W=5U AS=1.3P AD=2.2P PS=5.52U PD=10.88U
* device instance $8 r0 *1 23.075,142.085 pmos_6p0
M$8 6 7 4 4 pmos_6p0 L=0.7U W=5U AS=2.2P AD=1.3P PS=10.88U PD=5.52U
* device instance $9 r0 *1 24.295,142.085 pmos_6p0
M$9 4 7 6 4 pmos_6p0 L=0.7U W=5U AS=1.3P AD=1.3P PS=5.52U PD=5.52U
* device instance $10 r0 *1 25.515,142.085 pmos_6p0
M$10 6 7 4 4 pmos_6p0 L=0.7U W=5U AS=1.3P AD=1.3P PS=5.52U PD=5.52U
* device instance $11 r0 *1 26.735,142.085 pmos_6p0
M$11 4 7 6 4 pmos_6p0 L=0.7U W=5U AS=1.3P AD=1.3P PS=5.52U PD=5.52U
* device instance $12 r0 *1 27.955,142.085 pmos_6p0
M$12 6 7 4 4 pmos_6p0 L=0.7U W=5U AS=1.3P AD=1.3P PS=5.52U PD=5.52U
* device instance $13 r0 *1 29.175,142.085 pmos_6p0
M$13 4 7 6 4 pmos_6p0 L=0.7U W=5U AS=1.3P AD=1.3P PS=5.52U PD=5.52U
* device instance $14 r0 *1 30.395,142.085 pmos_6p0
M$14 6 7 4 4 pmos_6p0 L=0.7U W=5U AS=1.3P AD=1.3P PS=5.52U PD=5.52U
* device instance $15 r0 *1 31.615,142.085 pmos_6p0
M$15 4 7 6 4 pmos_6p0 L=0.7U W=5U AS=1.3P AD=1.3P PS=5.52U PD=5.52U
* device instance $16 r0 *1 32.835,142.085 pmos_6p0
M$16 6 7 4 4 pmos_6p0 L=0.7U W=5U AS=1.3P AD=1.3P PS=5.52U PD=5.52U
* device instance $17 r0 *1 34.055,142.085 pmos_6p0
M$17 4 7 6 4 pmos_6p0 L=0.7U W=5U AS=1.3P AD=1.3P PS=5.52U PD=5.52U
* device instance $18 r0 *1 35.275,142.085 pmos_6p0
M$18 6 7 4 4 pmos_6p0 L=0.7U W=5U AS=1.3P AD=1.3P PS=5.52U PD=5.52U
* device instance $19 r0 *1 36.495,142.085 pmos_6p0
M$19 4 7 6 4 pmos_6p0 L=0.7U W=5U AS=1.3P AD=1.3P PS=5.52U PD=5.52U
* device instance $20 r0 *1 37.715,142.085 pmos_6p0
M$20 6 7 4 4 pmos_6p0 L=0.7U W=5U AS=1.3P AD=1.3P PS=5.52U PD=5.52U
* device instance $21 r0 *1 38.935,142.085 pmos_6p0
M$21 4 7 6 4 pmos_6p0 L=0.7U W=5U AS=1.3P AD=1.3P PS=5.52U PD=5.52U
* device instance $22 r0 *1 40.155,142.085 pmos_6p0
M$22 6 7 4 4 pmos_6p0 L=0.7U W=5U AS=1.3P AD=1.3P PS=5.52U PD=5.52U
* device instance $23 r0 *1 41.375,142.085 pmos_6p0
M$23 4 7 6 4 pmos_6p0 L=0.7U W=5U AS=1.3P AD=1.3P PS=5.52U PD=5.52U
* device instance $24 r0 *1 42.595,142.085 pmos_6p0
M$24 6 7 4 4 pmos_6p0 L=0.7U W=5U AS=1.3P AD=1.3P PS=5.52U PD=5.52U
* device instance $25 r0 *1 43.815,142.085 pmos_6p0
M$25 4 7 6 4 pmos_6p0 L=0.7U W=5U AS=1.3P AD=1.3P PS=5.52U PD=5.52U
* device instance $26 r0 *1 45.035,142.085 pmos_6p0
M$26 6 7 4 4 pmos_6p0 L=0.7U W=5U AS=1.3P AD=1.3P PS=5.52U PD=5.52U
* device instance $27 r0 *1 46.255,142.085 pmos_6p0
M$27 4 7 6 4 pmos_6p0 L=0.7U W=5U AS=1.3P AD=1.3P PS=5.52U PD=5.52U
* device instance $28 r0 *1 47.475,142.085 pmos_6p0
M$28 6 7 4 4 pmos_6p0 L=0.7U W=5U AS=1.3P AD=1.3P PS=5.52U PD=5.52U
* device instance $29 r0 *1 48.695,142.085 pmos_6p0
M$29 4 7 6 4 pmos_6p0 L=0.7U W=5U AS=1.3P AD=1.3P PS=5.52U PD=5.52U
* device instance $30 r0 *1 49.915,142.085 pmos_6p0
M$30 6 7 4 4 pmos_6p0 L=0.7U W=5U AS=1.3P AD=1.3P PS=5.52U PD=5.52U
* device instance $31 r0 *1 51.135,142.085 pmos_6p0
M$31 4 7 6 4 pmos_6p0 L=0.7U W=5U AS=1.3P AD=2.2P PS=5.52U PD=10.88U
* device instance $32 r0 *1 26.305,132.53 nmos_6p0
M$32 7 5 1 21 nmos_6p0 L=0.7U W=5U AS=2.2P AD=1.3P PS=10.88U PD=5.52U
* device instance $33 r0 *1 27.525,132.53 nmos_6p0
M$33 1 5 7 21 nmos_6p0 L=0.7U W=5U AS=1.3P AD=1.3P PS=5.52U PD=5.52U
* device instance $34 r0 *1 28.745,132.53 nmos_6p0
M$34 7 5 1 21 nmos_6p0 L=0.7U W=5U AS=1.3P AD=1.3P PS=5.52U PD=5.52U
* device instance $35 r0 *1 29.965,132.53 nmos_6p0
M$35 1 5 7 21 nmos_6p0 L=0.7U W=5U AS=1.3P AD=1.3P PS=5.52U PD=5.52U
* device instance $36 r0 *1 31.185,132.53 nmos_6p0
M$36 7 5 1 21 nmos_6p0 L=0.7U W=5U AS=1.3P AD=1.3P PS=5.52U PD=5.52U
* device instance $37 r0 *1 32.405,132.53 nmos_6p0
M$37 1 5 7 21 nmos_6p0 L=0.7U W=5U AS=1.3P AD=1.3P PS=5.52U PD=5.52U
* device instance $38 r0 *1 33.625,132.53 nmos_6p0
M$38 6 7 1 21 nmos_6p0 L=0.7U W=5U AS=1.3P AD=1.3P PS=5.52U PD=5.52U
* device instance $39 r0 *1 34.845,132.53 nmos_6p0
M$39 1 7 6 21 nmos_6p0 L=0.7U W=5U AS=1.3P AD=1.3P PS=5.52U PD=5.52U
* device instance $40 r0 *1 36.065,132.53 nmos_6p0
M$40 6 7 1 21 nmos_6p0 L=0.7U W=5U AS=1.3P AD=1.3P PS=5.52U PD=5.52U
* device instance $41 r0 *1 37.285,132.53 nmos_6p0
M$41 1 7 6 21 nmos_6p0 L=0.7U W=5U AS=1.3P AD=1.3P PS=5.52U PD=5.52U
* device instance $42 r0 *1 38.505,132.53 nmos_6p0
M$42 6 7 1 21 nmos_6p0 L=0.7U W=5U AS=1.3P AD=1.3P PS=5.52U PD=5.52U
* device instance $43 r0 *1 39.725,132.53 nmos_6p0
M$43 1 7 6 21 nmos_6p0 L=0.7U W=5U AS=1.3P AD=2.2P PS=5.52U PD=10.88U
.ENDS comp018green_esd_clamp_v5p0_DVSS

* cell M1_PSUB_CDNS_406619561348
* pin
* pin
.SUBCKT M1_PSUB_CDNS_406619561348 1 2
.ENDS M1_PSUB_CDNS_406619561348

* cell moscap_corner_1
* pin
* pin
* pin
* pin
.SUBCKT moscap_corner_1 1 2 3 4
* cell instance $1 r90 *1 38.74,61.09
X$1 2 1 M1_PSUB_CDNS_4066195613410
* cell instance $2 r90 *1 38.725,30.635
X$2 2 1 M1_PSUB_CDNS_4066195613410
* cell instance $3 r90 *1 38.765,0.67
X$3 2 1 M1_PSUB_CDNS_4066195613410
* cell instance $4 r0 *1 52.37,30.88
X$4 2 1 M1_PSUB_CDNS_406619561349
* cell instance $5 m0 *1 27.595,28.105
X$5 2 3 nmoscap_6p0_CDNS_406619561340
* cell instance $6 m0 *1 39.775,28.105
X$6 2 3 nmoscap_6p0_CDNS_406619561340
* cell instance $7 r0 *1 27.595,33.165
X$7 2 4 nmoscap_6p0_CDNS_406619561340
* cell instance $8 r0 *1 39.775,33.165
X$8 2 4 nmoscap_6p0_CDNS_406619561340
.ENDS moscap_corner_1

* cell moscap_corner
* pin
* pin VMINUS
* pin
* pin
.SUBCKT moscap_corner 1 2 3 4
* net 2 VMINUS
* cell instance $1 r90 *1 26.52,61.09
X$1 2 1 M1_PSUB_CDNS_4066195613411
* cell instance $2 r90 *1 26.52,30.635
X$2 2 1 M1_PSUB_CDNS_4066195613411
* cell instance $3 r90 *1 26.52,0.67
X$3 2 1 M1_PSUB_CDNS_4066195613411
* cell instance $4 r0 *1 52.37,30.88
X$4 2 1 M1_PSUB_CDNS_406619561349
* cell instance $5 m0 *1 3.235,28.105
X$5 2 3 nmoscap_6p0_CDNS_406619561340
* cell instance $6 m0 *1 15.415,28.105
X$6 2 3 nmoscap_6p0_CDNS_406619561340
* cell instance $7 m0 *1 27.595,28.105
X$7 2 3 nmoscap_6p0_CDNS_406619561340
* cell instance $8 m0 *1 39.775,28.105
X$8 2 3 nmoscap_6p0_CDNS_406619561340
* cell instance $9 r0 *1 3.235,33.165
X$9 2 4 nmoscap_6p0_CDNS_406619561340
* cell instance $10 r0 *1 15.415,33.165
X$10 2 4 nmoscap_6p0_CDNS_406619561340
* cell instance $11 r0 *1 27.595,33.165
X$11 2 4 nmoscap_6p0_CDNS_406619561340
* cell instance $12 r0 *1 39.775,33.165
X$12 2 4 nmoscap_6p0_CDNS_406619561340
.ENDS moscap_corner

* cell moscap_corner_2
* pin VMINUS
* pin
* pin
* pin
.SUBCKT moscap_corner_2 1 2 3 4
* net 1 VMINUS
* cell instance $1 r90 *1 39.14,0.67
X$1 1 2 M1_PSUB_CDNS_4066195613412
* cell instance $2 r0 *1 25.215,15.07
X$2 1 2 M1_PSUB_CDNS_4066195613413
* cell instance $3 r90 *1 26.52,61.09
X$3 1 2 M1_PSUB_CDNS_4066195613411
* cell instance $4 r90 *1 26.52,30.635
X$4 1 2 M1_PSUB_CDNS_4066195613411
* cell instance $5 r0 *1 52.37,30.88
X$5 1 2 M1_PSUB_CDNS_406619561349
* cell instance $6 m0 *1 27.595,28.105
X$6 1 3 nmoscap_6p0_CDNS_406619561340
* cell instance $7 m0 *1 39.775,28.105
X$7 1 3 nmoscap_6p0_CDNS_406619561340
* cell instance $8 r0 *1 3.235,33.165
X$8 1 4 nmoscap_6p0_CDNS_406619561340
* cell instance $9 r0 *1 15.415,33.165
X$9 1 4 nmoscap_6p0_CDNS_406619561340
* cell instance $10 r0 *1 27.595,33.165
X$10 1 4 nmoscap_6p0_CDNS_406619561340
* cell instance $11 r0 *1 39.775,33.165
X$11 1 4 nmoscap_6p0_CDNS_406619561340
.ENDS moscap_corner_2

* cell moscap_corner_3
* pin VMINUS
* pin
* pin
* pin
.SUBCKT moscap_corner_3 1 2 3 4
* net 1 VMINUS
* cell instance $1 r90 *1 32.085,61.09
X$1 1 2 M1_PSUB_CDNS_4066195613414
* cell instance $2 r90 *1 44.73,0.67
X$2 1 2 M1_PSUB_CDNS_4066195613415
* cell instance $3 r0 *1 36.835,15.07
X$3 1 2 M1_PSUB_CDNS_4066195613416
* cell instance $4 r90 *1 32.195,30.635
X$4 1 2 M1_PSUB_CDNS_4066195613417
* cell instance $5 r0 *1 52.37,30.88
X$5 1 2 M1_PSUB_CDNS_406619561349
* cell instance $6 m0 *1 39.775,28.105
X$6 1 3 nmoscap_6p0_CDNS_406619561340
* cell instance $7 r0 *1 15.415,33.165
X$7 1 4 nmoscap_6p0_CDNS_406619561340
* cell instance $8 r0 *1 27.595,33.165
X$8 1 4 nmoscap_6p0_CDNS_406619561340
* cell instance $9 r0 *1 39.775,33.165
X$9 1 4 nmoscap_6p0_CDNS_406619561340
.ENDS moscap_corner_3

* cell ESD_CLAMP_COR
* pin gf180mcu_gnd
* pin
* pin
* pin
* pin
* pin
* pin
* pin
* pin
* pin
* pin
.SUBCKT ESD_CLAMP_COR 1 2 3 4 5 6 7 8 17 18 27
* net 1 gf180mcu_gnd
* cell instance $1 m45 *1 0.255,217.825
X$1 18 17 1 16 15 14 13 12 11 10 9 comp018green_esd_clamp_v5p0_2
* cell instance $2 r0 *1 217.82,0.255
X$2 7 27 1 26 25 24 23 22 21 20 19 comp018green_esd_clamp_v5p0_1
* cell instance $3 m45 *1 2.54,212.785
X$3 10 9 18 17 10 18 10 10 18 18 10 18 10 18 10 18 9 9 9 10 10 10 10 9 9 9 9 10
+ 10 10 17 17 17 18 18 18 18 17 17 17 17 18 18 18 9 9 17 17 9 9 9 9 9 9 9 9 9
+ 17 17 17 17 17 17 17 17 17 15 13 13 13 15 13 15 15 12 12 12 10 10 10 12 15 12
+ 17 18 18 18 17 18 17 17 17 17 17 18 18 18 17 17 17 16 16 14 14 16 14 14 14 16
+ 11 11 11 9 9 9 9 11 18 18 17 17 18 17 17 17 18 18 18 18 17 17 17 17 18 12 12
+ 12 17 17 17 9 9 17 17 12 12 12 12 11 11 11 12 12 12 11 12 12 12 12 12 12 12
+ 12 12 12 12 12 12 12 12 9 11 12 12 12 12 11 12 11 12 12 12 12 11 12 12 12 12
+ 12 12 12 12 17 17 17 17 18 18 18 17 17 17 18 17 17 17 17 17 17 17 17 17 17 17
+ 17 17 17 17 17 18 17 17 17 17 18 17 18 17 17 17 17 18 17 17 17 17 17 17 17 17
+ 9 17 9 17 18 18 18 17 17 17 17 17 18 18 17 18 17 18 18 17 17 17 17 18 17 18
+ 17 16 16 11 14 14 14 14 14 16 11 9 10 12 10 13 12 15 15 15 13 15 13 15 3 2
+ power_via_cor_5
* cell instance $4 r0 *1 212.78,2.54
X$4 25 26 23 27 7 7 24 27 22 27 21 7 20 22 19 7 27 27 22 22 22 27 27 27 22 20
+ 20 20 20 19 19 19 19 19 19 19 22 22 20 20 20 22 20 20 20 22 22 22 22 20 20 20
+ 27 7 7 7 7 27 27 27 27 27 27 27 27 27 7 7 7 27 7 7 7 27 27 27 27 7 7 7 22 27
+ 22 27 7 27 7 27 7 26 24 21 25 23 5 4 power_via_cor_3
* cell instance $5 r0 *1 -6.5,283.255
X$5 8 6 27 7 top_routing_cor
.ENDS ESD_CLAMP_COR

* cell moscap_routing
* pin
* pin
* pin
* pin
* pin
* pin
* pin
* pin
* pin
* pin
* pin
* pin
* pin
* pin
* pin
* pin
* pin
* pin
* pin
* pin
* pin
* pin
* pin
* pin
* pin
* pin
* pin
* pin
* pin
* pin
* pin
* pin
* pin
* pin
* pin
* pin
* pin
* pin
* pin
* pin
* pin
* pin
* pin
* pin
* pin
* pin
* pin
* pin
* pin
* pin
* pin
* pin
* pin
* pin
* pin
* pin
* pin
* pin
* pin
* pin
* pin
* pin
* pin
* pin
* pin
* pin
* pin
* pin
* pin
* pin
* pin
* pin
* pin
* pin
.SUBCKT moscap_routing 2 4 6 7 8 11 13 14 17 18 20 21 22 23 24 25 26 28 29 31
+ 33 35 39 40 41 43 45 47 49 52 53 55 59 61 64 65 68 69 75 76 77 78 93 95 102
+ 103 104 105 167 168 175 176 177 178 179 183 184 185 187 189 207 208 209 210
+ 211 212 213 214 215 216 217 218 219 220
* cell instance $1 r0 *1 -80.03,-273.665
X$1 2 1 M1_PSUB_CDNS_4066195613434
* cell instance $2 r0 *1 -80.96,-271.805
X$2 2 1 M1_PSUB_CDNS_4066195613445
* cell instance $3 r0 *1 -80.65,-272.425
X$3 2 1 M1_PSUB_CDNS_4066195613446
* cell instance $4 r0 *1 -80.34,-273.045
X$4 2 1 M1_PSUB_CDNS_4066195613447
* cell instance $5 r0 *1 -83.13,-267.465
X$5 2 1 M1_PSUB_CDNS_4066195613438
* cell instance $6 r0 *1 -82.82,-268.085
X$6 2 1 M1_PSUB_CDNS_4066195613439
* cell instance $7 r0 *1 -82.51,-268.705
X$7 2 1 M1_PSUB_CDNS_4066195613440
* cell instance $8 r0 *1 -82.2,-269.325
X$8 2 1 M1_PSUB_CDNS_4066195613441
* cell instance $9 r0 *1 -81.89,-269.945
X$9 2 1 M1_PSUB_CDNS_4066195613442
* cell instance $10 r0 *1 -81.58,-270.565
X$10 2 1 M1_PSUB_CDNS_4066195613443
* cell instance $11 r0 *1 -81.27,-271.185
X$11 2 1 M1_PSUB_CDNS_4066195613444
* cell instance $12 r0 *1 -84.37,-264.985
X$12 2 1 M1_PSUB_CDNS_4066195613433
* cell instance $13 r0 *1 -84.06,-265.605
X$13 2 1 M1_PSUB_CDNS_4066195613435
* cell instance $14 r0 *1 -83.75,-266.225
X$14 2 1 M1_PSUB_CDNS_4066195613436
* cell instance $15 r0 *1 -83.44,-266.845
X$15 2 1 M1_PSUB_CDNS_4066195613437
* cell instance $16 r0 *1 -92.625,-259.83
X$16 2 3 M1_PSUB_CDNS_4066195613444
* cell instance $17 r0 *1 -92.935,-259.21
X$17 2 3 M1_PSUB_CDNS_4066195613443
* cell instance $18 r0 *1 -93.245,-258.59
X$18 2 3 M1_PSUB_CDNS_4066195613442
* cell instance $19 r0 *1 -93.555,-257.97
X$19 2 3 M1_PSUB_CDNS_4066195613441
* cell instance $20 r0 *1 -93.865,-257.35
X$20 2 3 M1_PSUB_CDNS_4066195613440
* cell instance $21 r0 *1 -94.175,-256.73
X$21 2 3 M1_PSUB_CDNS_4066195613439
* cell instance $22 r0 *1 -94.485,-256.11
X$22 2 3 M1_PSUB_CDNS_4066195613438
* cell instance $23 r0 *1 -91.695,-261.69
X$23 2 3 M1_PSUB_CDNS_4066195613447
* cell instance $24 r0 *1 -92.005,-261.07
X$24 2 3 M1_PSUB_CDNS_4066195613446
* cell instance $25 r0 *1 -92.315,-260.45
X$25 2 3 M1_PSUB_CDNS_4066195613445
* cell instance $26 r0 *1 -91.385,-262.31
X$26 2 3 M1_PSUB_CDNS_4066195613434
* cell instance $27 r0 *1 -95.105,-254.87
X$27 2 3 M1_PSUB_CDNS_4066195613436
* cell instance $28 r0 *1 -95.415,-254.25
X$28 2 3 M1_PSUB_CDNS_4066195613435
* cell instance $29 r0 *1 -95.725,-253.63
X$29 2 3 M1_PSUB_CDNS_4066195613433
* cell instance $30 r0 *1 -94.795,-255.49
X$30 2 3 M1_PSUB_CDNS_4066195613437
* cell instance $31 r0 *1 -45.87,-268.96
X$31 2 221 M2_M1_CDNS_40661956134110
* cell instance $32 r0 *1 -47.34,-270.46
X$32 2 M1_PSUB_CDNS_4066195613418
* cell instance $33 r0 *1 -45.87,-268.96
X$33 2 221 M3_M2_CDNS_40661956134111
* cell instance $34 r0 *1 -81.405,-260.315
X$34 4 5 M2_M1_CDNS_4066195613470
* cell instance $35 r0 *1 -92.45,-203.825
X$35 4 5 M2_M1_CDNS_4066195613467
* cell instance $36 r0 *1 -46.07,-203.825
X$36 4 5 M2_M1_CDNS_4066195613468
* cell instance $37 r0 *1 -71.495,-203.95
X$37 4 5 M3_M2_CDNS_4066195613474
* cell instance $38 r0 *1 -46.07,-260.315
X$38 4 5 M2_M1_CDNS_4066195613468
* cell instance $39 r0 *1 -94.575,-247.89
X$39 7 6 M1_PSUB_CDNS_4066195613453
* cell instance $40 r0 *1 -99.845,-237.625
X$40 8 6 M1_PSUB_CDNS_4066195613452
* cell instance $41 r0 *1 -114.53,-235.215
X$41 8 6 M1_PSUB_CDNS_4066195613437
* cell instance $42 r0 *1 -104.01,-245.42
X$42 7 6 M1_PSUB_CDNS_4066195613437
* cell instance $43 r0 *1 -114.84,-234.595
X$43 8 6 M1_PSUB_CDNS_4066195613436
* cell instance $44 r0 *1 -104.32,-244.8
X$44 7 6 M1_PSUB_CDNS_4066195613436
* cell instance $45 r0 *1 -115.15,-233.975
X$45 8 6 M1_PSUB_CDNS_4066195613435
* cell instance $46 r0 *1 -104.63,-244.18
X$46 7 6 M1_PSUB_CDNS_4066195613435
* cell instance $47 r0 *1 -104.94,-243.56
X$47 7 6 M1_PSUB_CDNS_4066195613433
* cell instance $48 r0 *1 -115.46,-233.355
X$48 105 6 M1_PSUB_CDNS_4066195613433
* cell instance $49 r0 *1 -101.84,-249.76
X$49 7 6 M1_PSUB_CDNS_4066195613444
* cell instance $50 r0 *1 -112.36,-239.555
X$50 8 6 M1_PSUB_CDNS_4066195613444
* cell instance $51 r0 *1 -102.15,-249.14
X$51 7 6 M1_PSUB_CDNS_4066195613443
* cell instance $52 r0 *1 -112.67,-238.935
X$52 8 6 M1_PSUB_CDNS_4066195613443
* cell instance $53 r0 *1 -102.46,-248.52
X$53 7 6 M1_PSUB_CDNS_4066195613442
* cell instance $54 r0 *1 -112.98,-238.315
X$54 8 6 M1_PSUB_CDNS_4066195613442
* cell instance $55 r0 *1 -113.29,-237.695
X$55 8 6 M1_PSUB_CDNS_4066195613441
* cell instance $56 r0 *1 -102.77,-247.9
X$56 7 6 M1_PSUB_CDNS_4066195613441
* cell instance $57 r0 *1 -113.6,-237.075
X$57 8 6 M1_PSUB_CDNS_4066195613440
* cell instance $58 r0 *1 -103.08,-247.28
X$58 7 6 M1_PSUB_CDNS_4066195613440
* cell instance $59 r0 *1 -103.39,-246.66
X$59 7 6 M1_PSUB_CDNS_4066195613439
* cell instance $60 r0 *1 -113.91,-236.455
X$60 8 6 M1_PSUB_CDNS_4066195613439
* cell instance $61 r0 *1 -114.22,-235.835
X$61 8 6 M1_PSUB_CDNS_4066195613438
* cell instance $62 r0 *1 -103.7,-246.04
X$62 7 6 M1_PSUB_CDNS_4066195613438
* cell instance $63 r0 *1 -100.91,-251.62
X$63 7 6 M1_PSUB_CDNS_4066195613447
* cell instance $64 r0 *1 -111.43,-241.415
X$64 8 6 M1_PSUB_CDNS_4066195613447
* cell instance $65 r0 *1 -111.74,-240.795
X$65 8 6 M1_PSUB_CDNS_4066195613446
* cell instance $66 r0 *1 -101.22,-251
X$66 7 6 M1_PSUB_CDNS_4066195613446
* cell instance $67 r0 *1 -101.53,-250.38
X$67 7 6 M1_PSUB_CDNS_4066195613445
* cell instance $68 r0 *1 -112.05,-240.175
X$68 8 6 M1_PSUB_CDNS_4066195613445
* cell instance $69 r0 *1 -100.6,-252.24
X$69 7 6 M1_PSUB_CDNS_4066195613434
* cell instance $70 r0 *1 -111.12,-242.035
X$70 8 6 M1_PSUB_CDNS_4066195613434
* cell instance $71 r0 *1 -98.635,-237.095
X$71 8 190 M2_M1_CDNS_4066195613480
* cell instance $72 r0 *1 -98.635,-237.095
X$72 8 190 M3_M2_CDNS_4066195613481
* cell instance $73 r0 *1 -117.705,-227.215
X$73 11 9 M1_PSUB_CDNS_4066195613456
* cell instance $74 r0 *1 -125.54,-224.745
X$74 11 9 M1_PSUB_CDNS_4066195613437
* cell instance $75 r0 *1 -125.85,-224.125
X$75 11 9 M1_PSUB_CDNS_4066195613436
* cell instance $76 r0 *1 -126.16,-223.505
X$76 11 9 M1_PSUB_CDNS_4066195613435
* cell instance $77 r0 *1 -126.47,-222.885
X$77 11 9 M1_PSUB_CDNS_4066195613433
* cell instance $78 r0 *1 -123.37,-229.085
X$78 11 9 M1_PSUB_CDNS_4066195613444
* cell instance $79 r0 *1 -123.68,-228.465
X$79 11 9 M1_PSUB_CDNS_4066195613443
* cell instance $80 r0 *1 -123.99,-227.845
X$80 11 9 M1_PSUB_CDNS_4066195613442
* cell instance $81 r0 *1 -124.3,-227.225
X$81 11 9 M1_PSUB_CDNS_4066195613441
* cell instance $82 r0 *1 -124.61,-226.605
X$82 11 9 M1_PSUB_CDNS_4066195613440
* cell instance $83 r0 *1 -124.92,-225.985
X$83 11 9 M1_PSUB_CDNS_4066195613439
* cell instance $84 r0 *1 -125.23,-225.365
X$84 11 9 M1_PSUB_CDNS_4066195613438
* cell instance $85 r0 *1 -122.44,-230.945
X$85 11 9 M1_PSUB_CDNS_4066195613447
* cell instance $86 r0 *1 -122.75,-230.325
X$86 11 9 M1_PSUB_CDNS_4066195613446
* cell instance $87 r0 *1 -123.06,-229.705
X$87 11 9 M1_PSUB_CDNS_4066195613445
* cell instance $88 r0 *1 -122.13,-231.565
X$88 11 9 M1_PSUB_CDNS_4066195613434
* cell instance $89 r0 *1 -134.755,-214.675
X$89 13 10 M1_PSUB_CDNS_4066195613437
* cell instance $90 r0 *1 -135.065,-214.055
X$90 13 10 M1_PSUB_CDNS_4066195613436
* cell instance $91 r0 *1 -135.375,-213.435
X$91 13 10 M1_PSUB_CDNS_4066195613435
* cell instance $92 r0 *1 -135.685,-212.815
X$92 13 10 M1_PSUB_CDNS_4066195613433
* cell instance $93 r0 *1 -132.585,-219.015
X$93 13 10 M1_PSUB_CDNS_4066195613444
* cell instance $94 r0 *1 -132.895,-218.395
X$94 13 10 M1_PSUB_CDNS_4066195613443
* cell instance $95 r0 *1 -133.205,-217.775
X$95 13 10 M1_PSUB_CDNS_4066195613442
* cell instance $96 r0 *1 -133.515,-217.155
X$96 13 10 M1_PSUB_CDNS_4066195613441
* cell instance $97 r0 *1 -133.825,-216.535
X$97 13 10 M1_PSUB_CDNS_4066195613440
* cell instance $98 r0 *1 -134.135,-215.915
X$98 13 10 M1_PSUB_CDNS_4066195613439
* cell instance $99 r0 *1 -134.445,-215.295
X$99 13 10 M1_PSUB_CDNS_4066195613438
* cell instance $100 r0 *1 -131.655,-220.875
X$100 13 10 M1_PSUB_CDNS_4066195613447
* cell instance $101 r0 *1 -131.965,-220.255
X$101 13 10 M1_PSUB_CDNS_4066195613446
* cell instance $102 r0 *1 -132.275,-219.635
X$102 13 10 M1_PSUB_CDNS_4066195613445
* cell instance $103 r0 *1 -131.345,-221.495
X$103 13 10 M1_PSUB_CDNS_4066195613434
* cell instance $104 r0 *1 -127.45,-206.88
X$104 14 12 M1_PSUB_CDNS_4066195613451
* cell instance $105 r0 *1 -145.275,-204.47
X$105 14 12 M1_PSUB_CDNS_4066195613437
* cell instance $106 r0 *1 -145.585,-203.85
X$106 14 12 M1_PSUB_CDNS_4066195613436
* cell instance $107 r0 *1 -145.895,-203.23
X$107 14 12 M1_PSUB_CDNS_4066195613435
* cell instance $108 r0 *1 -146.205,-202.61
X$108 14 12 M1_PSUB_CDNS_4066195613433
* cell instance $109 r0 *1 -143.105,-208.81
X$109 14 12 M1_PSUB_CDNS_4066195613444
* cell instance $110 r0 *1 -143.415,-208.19
X$110 14 12 M1_PSUB_CDNS_4066195613443
* cell instance $111 r0 *1 -143.725,-207.57
X$111 14 12 M1_PSUB_CDNS_4066195613442
* cell instance $112 r0 *1 -144.035,-206.95
X$112 14 12 M1_PSUB_CDNS_4066195613441
* cell instance $113 r0 *1 -144.345,-206.33
X$113 14 12 M1_PSUB_CDNS_4066195613440
* cell instance $114 r0 *1 -144.655,-205.71
X$114 14 12 M1_PSUB_CDNS_4066195613439
* cell instance $115 r0 *1 -144.965,-205.09
X$115 14 12 M1_PSUB_CDNS_4066195613438
* cell instance $116 r0 *1 -142.175,-210.67
X$116 14 12 M1_PSUB_CDNS_4066195613447
* cell instance $117 r0 *1 -142.485,-210.05
X$117 14 12 M1_PSUB_CDNS_4066195613446
* cell instance $118 r0 *1 -142.795,-209.43
X$118 14 12 M1_PSUB_CDNS_4066195613445
* cell instance $119 r0 *1 -141.865,-211.29
X$119 14 12 M1_PSUB_CDNS_4066195613434
* cell instance $120 r0 *1 -118.905,-216.825
X$120 13 192 M2_M1_CDNS_4066195613480
* cell instance $121 r0 *1 -122.18,-217.145
X$121 13 M1_PSUB_CDNS_4066195613455
* cell instance $122 r0 *1 -118.905,-216.825
X$122 13 192 M3_M2_CDNS_4066195613481
* cell instance $123 r0 *1 -129.395,-206.335
X$123 14 191 M2_M1_CDNS_4066195613480
* cell instance $124 r0 *1 -129.395,-206.335
X$124 14 191 M3_M2_CDNS_4066195613481
* cell instance $125 r0 *1 -156.185,-186.28
X$125 17 15 M1_PSUB_CDNS_4066195613453
* cell instance $126 r0 *1 -165.62,-183.81
X$126 17 15 M1_PSUB_CDNS_4066195613437
* cell instance $127 r0 *1 -165.93,-183.19
X$127 17 15 M1_PSUB_CDNS_4066195613436
* cell instance $128 r0 *1 -166.24,-182.57
X$128 17 15 M1_PSUB_CDNS_4066195613435
* cell instance $129 r0 *1 -166.55,-181.95
X$129 17 15 M1_PSUB_CDNS_4066195613433
* cell instance $130 r0 *1 -163.45,-188.15
X$130 17 15 M1_PSUB_CDNS_4066195613444
* cell instance $131 r0 *1 -163.76,-187.53
X$131 17 15 M1_PSUB_CDNS_4066195613443
* cell instance $132 r0 *1 -164.07,-186.91
X$132 17 15 M1_PSUB_CDNS_4066195613442
* cell instance $133 r0 *1 -164.38,-186.29
X$133 17 15 M1_PSUB_CDNS_4066195613441
* cell instance $134 r0 *1 -164.69,-185.67
X$134 17 15 M1_PSUB_CDNS_4066195613440
* cell instance $135 r0 *1 -165,-185.05
X$135 17 15 M1_PSUB_CDNS_4066195613439
* cell instance $136 r0 *1 -165.31,-184.43
X$136 17 15 M1_PSUB_CDNS_4066195613438
* cell instance $137 r0 *1 -162.52,-190.01
X$137 17 15 M1_PSUB_CDNS_4066195613447
* cell instance $138 r0 *1 -162.83,-189.39
X$138 17 15 M1_PSUB_CDNS_4066195613446
* cell instance $139 r0 *1 -163.14,-188.77
X$139 17 15 M1_PSUB_CDNS_4066195613445
* cell instance $140 r0 *1 -162.21,-190.63
X$140 17 15 M1_PSUB_CDNS_4066195613434
* cell instance $141 r0 *1 -156.405,-193.88
X$141 17 16 M1_PSUB_CDNS_4066195613437
* cell instance $142 r0 *1 -156.715,-193.26
X$142 17 16 M1_PSUB_CDNS_4066195613436
* cell instance $143 r0 *1 -157.025,-192.64
X$143 17 16 M1_PSUB_CDNS_4066195613435
* cell instance $144 r0 *1 -157.335,-192.02
X$144 17 16 M1_PSUB_CDNS_4066195613433
* cell instance $145 r0 *1 -154.235,-198.22
X$145 17 16 M1_PSUB_CDNS_4066195613444
* cell instance $146 r0 *1 -154.545,-197.6
X$146 17 16 M1_PSUB_CDNS_4066195613443
* cell instance $147 r0 *1 -154.855,-196.98
X$147 17 16 M1_PSUB_CDNS_4066195613442
* cell instance $148 r0 *1 -155.165,-196.36
X$148 17 16 M1_PSUB_CDNS_4066195613441
* cell instance $149 r0 *1 -155.475,-195.74
X$149 17 16 M1_PSUB_CDNS_4066195613440
* cell instance $150 r0 *1 -155.785,-195.12
X$150 17 16 M1_PSUB_CDNS_4066195613439
* cell instance $151 r0 *1 -156.095,-194.5
X$151 17 16 M1_PSUB_CDNS_4066195613438
* cell instance $152 r0 *1 -153.305,-200.08
X$152 17 16 M1_PSUB_CDNS_4066195613447
* cell instance $153 r0 *1 -153.615,-199.46
X$153 17 16 M1_PSUB_CDNS_4066195613446
* cell instance $154 r0 *1 -153.925,-198.84
X$154 17 16 M1_PSUB_CDNS_4066195613445
* cell instance $155 r0 *1 -152.995,-200.7
X$155 17 16 M1_PSUB_CDNS_4066195613434
* cell instance $156 r0 *1 -155.37,-184.955
X$156 17 169 M2_M1_CDNS_4066195613478
* cell instance $157 r0 *1 -155.37,-184.955
X$157 17 169 M3_M2_CDNS_4066195613479
* cell instance $158 r0 *1 -137.985,-198.59
X$158 18 19 M2_M1_CDNS_4066195613469
* cell instance $159 r0 *1 -52.435,-191.625
X$159 18 19 M2_M1_CDNS_40661956134109
* cell instance $160 r0 *1 -52.435,-191.625
X$160 18 19 M3_M2_CDNS_40661956134108
* cell instance $161 r0 *1 -76.87,-198.575
X$161 18 19 M3_M2_CDNS_4066195613474
* cell instance $162 r0 *1 -97.73,-198.59
X$162 18 19 M2_M1_CDNS_4066195613468
* cell instance $163 r0 *1 -46.07,-198.59
X$163 18 19 M2_M1_CDNS_4066195613468
* cell instance $164 r0 *1 -161.455,-176.015
X$164 21 20 M1_PSUB_CDNS_4066195613452
* cell instance $165 r0 *1 -176.14,-173.605
X$165 21 20 M1_PSUB_CDNS_4066195613437
* cell instance $166 r0 *1 -176.45,-172.985
X$166 21 20 M1_PSUB_CDNS_4066195613436
* cell instance $167 r0 *1 -176.76,-172.365
X$167 21 20 M1_PSUB_CDNS_4066195613435
* cell instance $168 r0 *1 -177.07,-171.745
X$168 21 20 M1_PSUB_CDNS_4066195613433
* cell instance $169 r0 *1 -173.97,-177.945
X$169 21 20 M1_PSUB_CDNS_4066195613444
* cell instance $170 r0 *1 -174.28,-177.325
X$170 21 20 M1_PSUB_CDNS_4066195613443
* cell instance $171 r0 *1 -174.59,-176.705
X$171 21 20 M1_PSUB_CDNS_4066195613442
* cell instance $172 r0 *1 -174.9,-176.085
X$172 21 20 M1_PSUB_CDNS_4066195613441
* cell instance $173 r0 *1 -175.21,-175.465
X$173 21 20 M1_PSUB_CDNS_4066195613440
* cell instance $174 r0 *1 -175.52,-174.845
X$174 21 20 M1_PSUB_CDNS_4066195613439
* cell instance $175 r0 *1 -175.83,-174.225
X$175 21 20 M1_PSUB_CDNS_4066195613438
* cell instance $176 r0 *1 -173.04,-179.805
X$176 21 20 M1_PSUB_CDNS_4066195613447
* cell instance $177 r0 *1 -173.35,-179.185
X$177 21 20 M1_PSUB_CDNS_4066195613446
* cell instance $178 r0 *1 -173.66,-178.565
X$178 21 20 M1_PSUB_CDNS_4066195613445
* cell instance $179 r0 *1 -172.73,-180.425
X$179 21 20 M1_PSUB_CDNS_4066195613434
* cell instance $180 r0 *1 -158.895,-177.595
X$180 21 106 M2_M1_CDNS_4066195613475
* cell instance $181 r0 *1 -158.895,-177.595
X$181 21 106 M3_M2_CDNS_4066195613476
* cell instance $182 r0 *1 -161.175,-175.315
X$182 21 113 M2_M1_CDNS_4066195613475
* cell instance $183 r0 *1 -161.175,-175.315
X$183 21 113 M3_M2_CDNS_4066195613476
* cell instance $184 r0 *1 -160.415,-176.075
X$184 21 114 M2_M1_CDNS_4066195613475
* cell instance $185 r0 *1 -160.415,-176.075
X$185 21 114 M3_M2_CDNS_4066195613476
* cell instance $186 r0 *1 -159.655,-176.835
X$186 21 163 M2_M1_CDNS_4066195613475
* cell instance $187 r0 *1 -159.655,-176.835
X$187 21 163 M3_M2_CDNS_4066195613476
* cell instance $188 r0 *1 -163.455,-173.035
X$188 21 154 M3_M2_CDNS_4066195613476
* cell instance $189 r0 *1 -163.455,-173.035
X$189 21 154 M2_M1_CDNS_4066195613475
* cell instance $190 r0 *1 -162.695,-173.795
X$190 21 111 M2_M1_CDNS_4066195613475
* cell instance $191 r0 *1 -162.695,-173.795
X$191 21 111 M3_M2_CDNS_4066195613476
* cell instance $192 r0 *1 -161.935,-174.555
X$192 21 112 M2_M1_CDNS_4066195613475
* cell instance $193 r0 *1 -161.935,-174.555
X$193 21 112 M3_M2_CDNS_4066195613476
* cell instance $194 r0 *1 -164.975,-171.515
X$194 21 164 M2_M1_CDNS_4066195613475
* cell instance $195 r0 *1 -164.975,-171.515
X$195 21 164 M3_M2_CDNS_4066195613476
* cell instance $196 r0 *1 -164.215,-172.275
X$196 21 155 M2_M1_CDNS_4066195613475
* cell instance $197 r0 *1 -164.215,-172.275
X$197 21 155 M3_M2_CDNS_4066195613476
* cell instance $198 r0 *1 -183.375,-169.77
X$198 24 22 M1_PSUB_CDNS_4066195613458
* cell instance $199 r0 *1 -179.21,-165.42
X$199 24 22 M1_PSUB_CDNS_4066195613456
* cell instance $200 r0 *1 -187.095,-162.95
X$200 24 22 M1_PSUB_CDNS_4066195613437
* cell instance $201 r0 *1 -187.405,-162.33
X$201 24 22 M1_PSUB_CDNS_4066195613436
* cell instance $202 r0 *1 -187.715,-161.71
X$202 24 22 M1_PSUB_CDNS_4066195613435
* cell instance $203 r0 *1 -188.025,-161.09
X$203 24 22 M1_PSUB_CDNS_4066195613433
* cell instance $204 r0 *1 -184.925,-167.29
X$204 24 22 M1_PSUB_CDNS_4066195613444
* cell instance $205 r0 *1 -185.235,-166.67
X$205 24 22 M1_PSUB_CDNS_4066195613443
* cell instance $206 r0 *1 -185.545,-166.05
X$206 24 22 M1_PSUB_CDNS_4066195613442
* cell instance $207 r0 *1 -185.855,-165.43
X$207 24 22 M1_PSUB_CDNS_4066195613441
* cell instance $208 r0 *1 -186.165,-164.81
X$208 24 22 M1_PSUB_CDNS_4066195613440
* cell instance $209 r0 *1 -186.475,-164.19
X$209 24 22 M1_PSUB_CDNS_4066195613439
* cell instance $210 r0 *1 -186.785,-163.57
X$210 24 22 M1_PSUB_CDNS_4066195613438
* cell instance $211 r0 *1 -183.995,-169.15
X$211 24 22 M1_PSUB_CDNS_4066195613447
* cell instance $212 r0 *1 -184.305,-168.53
X$212 24 22 M1_PSUB_CDNS_4066195613446
* cell instance $213 r0 *1 -184.615,-167.91
X$213 24 22 M1_PSUB_CDNS_4066195613445
* cell instance $214 r0 *1 -184.735,-154.71
X$214 25 23 M1_PSUB_CDNS_4066195613450
* cell instance $215 r0 *1 -194.36,-159.06
X$215 25 23 M1_PSUB_CDNS_4066195613458
* cell instance $216 r0 *1 -198.08,-152.24
X$216 25 23 M1_PSUB_CDNS_4066195613437
* cell instance $217 r0 *1 -198.39,-151.62
X$217 25 23 M1_PSUB_CDNS_4066195613436
* cell instance $218 r0 *1 -198.7,-151
X$218 25 23 M1_PSUB_CDNS_4066195613435
* cell instance $219 r0 *1 -199.01,-150.38
X$219 25 23 M1_PSUB_CDNS_4066195613433
* cell instance $220 r0 *1 -195.91,-156.58
X$220 25 23 M1_PSUB_CDNS_4066195613444
* cell instance $221 r0 *1 -196.22,-155.96
X$221 25 23 M1_PSUB_CDNS_4066195613443
* cell instance $222 r0 *1 -196.53,-155.34
X$222 25 23 M1_PSUB_CDNS_4066195613442
* cell instance $223 r0 *1 -196.84,-154.72
X$223 25 23 M1_PSUB_CDNS_4066195613441
* cell instance $224 r0 *1 -197.15,-154.1
X$224 25 23 M1_PSUB_CDNS_4066195613440
* cell instance $225 r0 *1 -197.46,-153.48
X$225 25 23 M1_PSUB_CDNS_4066195613439
* cell instance $226 r0 *1 -197.77,-152.86
X$226 25 23 M1_PSUB_CDNS_4066195613438
* cell instance $227 r0 *1 -194.98,-158.44
X$227 25 23 M1_PSUB_CDNS_4066195613447
* cell instance $228 r0 *1 -195.29,-157.82
X$228 25 23 M1_PSUB_CDNS_4066195613446
* cell instance $229 r0 *1 -195.6,-157.2
X$229 25 23 M1_PSUB_CDNS_4066195613445
* cell instance $230 r0 *1 -167.255,-169.235
X$230 24 97 M2_M1_CDNS_4066195613469
* cell instance $231 r0 *1 -167.255,-169.235
X$231 24 97 M3_M2_CDNS_4066195613477
* cell instance $232 r0 *1 -174.61,-160.57
X$232 25 96 M2_M1_CDNS_4066195613471
* cell instance $233 r0 *1 -174.61,-160.57
X$233 25 96 M3_M2_CDNS_4066195613472
* cell instance $234 r0 *1 -206.22,-146.15
X$234 26 27 M1_PSUB_CDNS_4066195613444
* cell instance $235 r0 *1 -206.53,-145.53
X$235 26 27 M1_PSUB_CDNS_4066195613443
* cell instance $236 r0 *1 -206.84,-144.91
X$236 26 27 M1_PSUB_CDNS_4066195613442
* cell instance $237 r0 *1 -207.15,-144.29
X$237 26 27 M1_PSUB_CDNS_4066195613441
* cell instance $238 r0 *1 -207.46,-143.67
X$238 26 27 M1_PSUB_CDNS_4066195613440
* cell instance $239 r0 *1 -207.77,-143.05
X$239 26 27 M1_PSUB_CDNS_4066195613439
* cell instance $240 r0 *1 -208.08,-142.43
X$240 26 27 M1_PSUB_CDNS_4066195613438
* cell instance $241 r0 *1 -205.29,-148.01
X$241 26 27 M1_PSUB_CDNS_4066195613447
* cell instance $242 r0 *1 -205.6,-147.39
X$242 26 27 M1_PSUB_CDNS_4066195613446
* cell instance $243 r0 *1 -205.91,-146.77
X$243 26 27 M1_PSUB_CDNS_4066195613445
* cell instance $244 r0 *1 -204.98,-148.63
X$244 26 27 M1_PSUB_CDNS_4066195613434
* cell instance $245 r0 *1 -188.77,-147.72
X$245 26 156 M2_M1_CDNS_4066195613475
* cell instance $246 r0 *1 -189.695,-144.28
X$246 26 28 M1_PSUB_CDNS_4066195613448
* cell instance $247 r0 *1 -188.77,-147.72
X$247 26 156 M3_M2_CDNS_4066195613476
* cell instance $248 r0 *1 -188.01,-148.48
X$248 26 128 M2_M1_CDNS_4066195613475
* cell instance $249 r0 *1 -188.01,-148.48
X$249 26 128 M3_M2_CDNS_4066195613476
* cell instance $250 r0 *1 -193.33,-143.16
X$250 26 157 M2_M1_CDNS_4066195613475
* cell instance $251 r0 *1 -193.33,-143.16
X$251 26 157 M3_M2_CDNS_4066195613476
* cell instance $252 r0 *1 -192.57,-143.92
X$252 26 132 M2_M1_CDNS_4066195613475
* cell instance $253 r0 *1 -192.57,-143.92
X$253 26 132 M3_M2_CDNS_4066195613476
* cell instance $254 r0 *1 -191.81,-144.68
X$254 26 161 M2_M1_CDNS_4066195613475
* cell instance $255 r0 *1 -191.81,-144.68
X$255 26 161 M3_M2_CDNS_4066195613476
* cell instance $256 r0 *1 -191.05,-145.44
X$256 26 160 M2_M1_CDNS_4066195613475
* cell instance $257 r0 *1 -191.05,-145.44
X$257 26 160 M3_M2_CDNS_4066195613476
* cell instance $258 r0 *1 -190.29,-146.2
X$258 26 159 M2_M1_CDNS_4066195613475
* cell instance $259 r0 *1 -190.29,-146.2
X$259 26 159 M3_M2_CDNS_4066195613476
* cell instance $260 r0 *1 -189.53,-146.96
X$260 26 158 M2_M1_CDNS_4066195613475
* cell instance $261 r0 *1 -189.53,-146.96
X$261 26 158 M3_M2_CDNS_4066195613476
* cell instance $262 r0 *1 -194.09,-142.4
X$262 26 116 M2_M1_CDNS_4066195613475
* cell instance $263 r0 *1 -194.09,-142.4
X$263 26 116 M3_M2_CDNS_4066195613476
* cell instance $264 r0 *1 -196.37,-140.12
X$264 26 100 M3_M2_CDNS_4066195613477
* cell instance $265 r0 *1 -196.37,-140.12
X$265 26 100 M2_M1_CDNS_4066195613469
* cell instance $266 r0 *1 -195.61,-140.88
X$266 26 138 M2_M1_CDNS_4066195613475
* cell instance $267 r0 *1 -209.01,-140.57
X$267 26 27 M1_PSUB_CDNS_4066195613435
* cell instance $268 r0 *1 -208.7,-141.19
X$268 26 27 M1_PSUB_CDNS_4066195613436
* cell instance $269 r0 *1 -195.61,-140.88
X$269 26 138 M3_M2_CDNS_4066195613476
* cell instance $270 r0 *1 -194.85,-141.64
X$270 26 133 M2_M1_CDNS_4066195613475
* cell instance $271 r0 *1 -208.39,-141.81
X$271 26 27 M1_PSUB_CDNS_4066195613437
* cell instance $272 r0 *1 -194.85,-141.64
X$272 26 133 M3_M2_CDNS_4066195613476
* cell instance $273 r0 *1 -209.32,-139.95
X$273 26 27 M1_PSUB_CDNS_4066195613433
* cell instance $274 r0 *1 -127.31,-133.88
X$274 31 28 M1_PSUB_CDNS_4066195613449
* cell instance $275 r0 *1 -229.615,-89.65
X$275 31 28 M1_PSUB_CDNS_4066195613431
* cell instance $276 r0 *1 -132.125,-63.61
X$276 31 28 M1_PSUB_CDNS_4066195613429
* cell instance $277 r0 *1 -218.99,-131.1
X$277 31 28 M1_PSUB_CDNS_4066195613437
* cell instance $278 r0 *1 -228.685,-121.42
X$278 31 28 M1_PSUB_CDNS_4066195613437
* cell instance $279 r0 *1 -228.995,-120.8
X$279 31 28 M1_PSUB_CDNS_4066195613436
* cell instance $280 r0 *1 -219.3,-130.48
X$280 31 28 M1_PSUB_CDNS_4066195613436
* cell instance $281 r0 *1 -219.61,-129.86
X$281 31 28 M1_PSUB_CDNS_4066195613435
* cell instance $282 r0 *1 -229.305,-120.18
X$282 31 28 M1_PSUB_CDNS_4066195613435
* cell instance $283 r0 *1 -229.615,-119.56
X$283 31 28 M1_PSUB_CDNS_4066195613433
* cell instance $284 r0 *1 -219.92,-129.24
X$284 31 28 M1_PSUB_CDNS_4066195613433
* cell instance $285 r0 *1 -226.515,-125.76
X$285 31 28 M1_PSUB_CDNS_4066195613444
* cell instance $286 r0 *1 -216.82,-135.44
X$286 31 28 M1_PSUB_CDNS_4066195613444
* cell instance $287 r0 *1 -226.825,-125.14
X$287 31 28 M1_PSUB_CDNS_4066195613443
* cell instance $288 r0 *1 -217.13,-134.82
X$288 31 28 M1_PSUB_CDNS_4066195613443
* cell instance $289 r0 *1 -227.135,-124.52
X$289 31 28 M1_PSUB_CDNS_4066195613442
* cell instance $290 r0 *1 -217.44,-134.2
X$290 31 28 M1_PSUB_CDNS_4066195613442
* cell instance $291 r0 *1 -227.445,-123.9
X$291 31 28 M1_PSUB_CDNS_4066195613441
* cell instance $292 r0 *1 -217.75,-133.58
X$292 31 28 M1_PSUB_CDNS_4066195613441
* cell instance $293 r0 *1 -227.755,-123.28
X$293 31 28 M1_PSUB_CDNS_4066195613440
* cell instance $294 r0 *1 -218.06,-132.96
X$294 31 28 M1_PSUB_CDNS_4066195613440
* cell instance $295 r0 *1 -228.065,-122.66
X$295 31 28 M1_PSUB_CDNS_4066195613439
* cell instance $296 r0 *1 -218.37,-132.34
X$296 31 28 M1_PSUB_CDNS_4066195613439
* cell instance $297 r0 *1 -228.375,-122.04
X$297 31 28 M1_PSUB_CDNS_4066195613438
* cell instance $298 r0 *1 -218.68,-131.72
X$298 31 28 M1_PSUB_CDNS_4066195613438
* cell instance $299 r0 *1 -225.585,-127.62
X$299 31 28 M1_PSUB_CDNS_4066195613447
* cell instance $300 r0 *1 -215.89,-137.3
X$300 31 28 M1_PSUB_CDNS_4066195613447
* cell instance $301 r0 *1 -225.895,-127
X$301 31 28 M1_PSUB_CDNS_4066195613446
* cell instance $302 r0 *1 -216.2,-136.68
X$302 31 28 M1_PSUB_CDNS_4066195613446
* cell instance $303 r0 *1 -226.205,-126.38
X$303 31 28 M1_PSUB_CDNS_4066195613445
* cell instance $304 r0 *1 -216.51,-136.06
X$304 31 28 M1_PSUB_CDNS_4066195613445
* cell instance $305 r0 *1 -225.275,-128.24
X$305 31 28 M1_PSUB_CDNS_4066195613434
* cell instance $306 r0 *1 -215.58,-137.92
X$306 31 28 M1_PSUB_CDNS_4066195613434
* cell instance $307 r0 *1 -104.16,-146.01
X$307 29 30 M3_M2_CDNS_4066195613488
* cell instance $308 r0 *1 -104.16,-146.01
X$308 29 30 M2_M1_CDNS_4066195613486
* cell instance $309 r0 *1 -79.795,-146.01
X$309 29 30 M3_M2_CDNS_4066195613488
* cell instance $310 r0 *1 -79.795,-146.01
X$310 29 30 M2_M1_CDNS_4066195613486
* cell instance $311 r0 *1 -149.98,-142.125
X$311 29 30 M2_M1_CDNS_4066195613468
* cell instance $312 r0 *1 -131.605,-142.165
X$312 29 30 M3_M2_CDNS_4066195613473
* cell instance $313 r0 *1 -97.73,-142.125
X$313 29 30 M2_M1_CDNS_4066195613468
* cell instance $314 r0 *1 -46.07,-142.125
X$314 29 30 M2_M1_CDNS_4066195613468
* cell instance $315 r0 *1 -227.01,-87.255
X$315 31 70 M2_M1_CDNS_4066195613459
* cell instance $316 r0 *1 -227.01,-87.255
X$316 31 70 M3_M2_CDNS_4066195613454
* cell instance $317 r0 *1 -209.265,-64.285
X$317 31 56 M2_M1_CDNS_4066195613421
* cell instance $318 r0 *1 -209.265,-64.285
X$318 31 56 M3_M2_CDNS_4066195613482
* cell instance $319 r0 *1 -193.41,-64.285
X$319 31 57 M2_M1_CDNS_4066195613421
* cell instance $320 r0 *1 -193.41,-64.285
X$320 31 57 M3_M2_CDNS_4066195613482
* cell instance $321 r0 *1 -173.345,-64.285
X$321 31 M2_M1_CDNS_4066195613483
* cell instance $322 r0 *1 -198.45,-138.04
X$322 31 117 M2_M1_CDNS_4066195613475
* cell instance $323 r0 *1 -198.45,-138.04
X$323 31 117 M3_M2_CDNS_4066195613476
* cell instance $324 r0 *1 -175.33,-138.04
X$324 31 147 M2_M1_CDNS_4066195613475
* cell instance $325 r0 *1 -175.33,-138.04
X$325 31 147 M3_M2_CDNS_4066195613476
* cell instance $326 r0 *1 -152.835,-138.04
X$326 31 165 M2_M1_CDNS_4066195613475
* cell instance $327 r0 *1 -152.835,-138.04
X$327 31 165 M3_M2_CDNS_4066195613476
* cell instance $328 r0 *1 -124.59,-138.04
X$328 31 79 M2_M1_CDNS_4066195613487
* cell instance $329 r0 *1 -124.59,-138.04
X$329 31 79 M3_M2_CDNS_40661956134101
* cell instance $330 r0 *1 -199.21,-137.28
X$330 31 127 M2_M1_CDNS_4066195613475
* cell instance $331 r0 *1 -199.21,-137.28
X$331 31 127 M3_M2_CDNS_4066195613476
* cell instance $332 r0 *1 -176.09,-137.28
X$332 31 134 M2_M1_CDNS_4066195613475
* cell instance $333 r0 *1 -176.09,-137.28
X$333 31 134 M3_M2_CDNS_4066195613476
* cell instance $334 r0 *1 -153.595,-137.28
X$334 31 166 M2_M1_CDNS_4066195613475
* cell instance $335 r0 *1 -153.595,-137.28
X$335 31 166 M3_M2_CDNS_4066195613476
* cell instance $336 r0 *1 -125.35,-137.28
X$336 31 86 M2_M1_CDNS_4066195613487
* cell instance $337 r0 *1 -125.35,-137.28
X$337 31 86 M3_M2_CDNS_40661956134101
* cell instance $338 r0 *1 -199.97,-136.52
X$338 31 126 M2_M1_CDNS_4066195613475
* cell instance $339 r0 *1 -199.97,-136.52
X$339 31 126 M3_M2_CDNS_4066195613476
* cell instance $340 r0 *1 -176.85,-136.52
X$340 31 118 M2_M1_CDNS_4066195613475
* cell instance $341 r0 *1 -176.85,-136.52
X$341 31 118 M3_M2_CDNS_4066195613476
* cell instance $342 r0 *1 -154.355,-136.52
X$342 31 140 M2_M1_CDNS_4066195613475
* cell instance $343 r0 *1 -154.355,-136.52
X$343 31 140 M3_M2_CDNS_4066195613476
* cell instance $344 r0 *1 -126.11,-136.52
X$344 31 92 M2_M1_CDNS_4066195613487
* cell instance $345 r0 *1 -126.11,-136.52
X$345 31 92 M3_M2_CDNS_40661956134101
* cell instance $346 r0 *1 -200.73,-135.76
X$346 31 125 M2_M1_CDNS_4066195613475
* cell instance $347 r0 *1 -200.73,-135.76
X$347 31 125 M3_M2_CDNS_4066195613476
* cell instance $348 r0 *1 -177.61,-135.76
X$348 31 139 M2_M1_CDNS_4066195613475
* cell instance $349 r0 *1 -177.61,-135.76
X$349 31 139 M3_M2_CDNS_4066195613476
* cell instance $350 r0 *1 -155.115,-135.76
X$350 31 131 M2_M1_CDNS_4066195613475
* cell instance $351 r0 *1 -155.115,-135.76
X$351 31 131 M3_M2_CDNS_4066195613476
* cell instance $352 r0 *1 -126.87,-135.76
X$352 31 83 M2_M1_CDNS_4066195613487
* cell instance $353 r0 *1 -126.87,-135.76
X$353 31 83 M3_M2_CDNS_40661956134101
* cell instance $354 r0 *1 -201.49,-135
X$354 31 124 M2_M1_CDNS_4066195613475
* cell instance $355 r0 *1 -201.49,-135
X$355 31 124 M3_M2_CDNS_4066195613476
* cell instance $356 r0 *1 -178.37,-135
X$356 31 137 M2_M1_CDNS_4066195613475
* cell instance $357 r0 *1 -178.37,-135
X$357 31 137 M3_M2_CDNS_4066195613476
* cell instance $358 r0 *1 -155.875,-135
X$358 31 130 M2_M1_CDNS_4066195613475
* cell instance $359 r0 *1 -155.875,-135
X$359 31 130 M3_M2_CDNS_4066195613476
* cell instance $360 r0 *1 -127.63,-135
X$360 31 82 M2_M1_CDNS_4066195613487
* cell instance $361 r0 *1 -127.63,-135
X$361 31 82 M3_M2_CDNS_40661956134101
* cell instance $362 r0 *1 -202.25,-134.24
X$362 31 152 M2_M1_CDNS_4066195613475
* cell instance $363 r0 *1 -202.25,-134.24
X$363 31 152 M3_M2_CDNS_4066195613476
* cell instance $364 r0 *1 -179.13,-134.24
X$364 31 146 M2_M1_CDNS_4066195613475
* cell instance $365 r0 *1 -179.13,-134.24
X$365 31 146 M3_M2_CDNS_4066195613476
* cell instance $366 r0 *1 -156.635,-134.24
X$366 31 145 M2_M1_CDNS_4066195613475
* cell instance $367 r0 *1 -156.635,-134.24
X$367 31 145 M3_M2_CDNS_4066195613476
* cell instance $368 r0 *1 -128.39,-134.24
X$368 31 88 M2_M1_CDNS_4066195613487
* cell instance $369 r0 *1 -128.39,-134.24
X$369 31 88 M3_M2_CDNS_40661956134101
* cell instance $370 r0 *1 -203.01,-133.48
X$370 31 123 M2_M1_CDNS_4066195613475
* cell instance $371 r0 *1 -203.01,-133.48
X$371 31 123 M3_M2_CDNS_4066195613476
* cell instance $372 r0 *1 -179.89,-133.48
X$372 31 135 M2_M1_CDNS_4066195613475
* cell instance $373 r0 *1 -179.89,-133.48
X$373 31 135 M3_M2_CDNS_4066195613476
* cell instance $374 r0 *1 -157.395,-133.48
X$374 31 107 M2_M1_CDNS_4066195613475
* cell instance $375 r0 *1 -157.395,-133.48
X$375 31 107 M3_M2_CDNS_4066195613476
* cell instance $376 r0 *1 -129.15,-133.48
X$376 31 89 M2_M1_CDNS_4066195613487
* cell instance $377 r0 *1 -129.15,-133.48
X$377 31 89 M3_M2_CDNS_40661956134101
* cell instance $378 r0 *1 -203.77,-132.72
X$378 31 122 M2_M1_CDNS_4066195613475
* cell instance $379 r0 *1 -203.77,-132.72
X$379 31 122 M3_M2_CDNS_4066195613476
* cell instance $380 r0 *1 -180.65,-132.72
X$380 31 141 M2_M1_CDNS_4066195613475
* cell instance $381 r0 *1 -180.65,-132.72
X$381 31 141 M3_M2_CDNS_4066195613476
* cell instance $382 r0 *1 -158.155,-132.72
X$382 31 108 M2_M1_CDNS_4066195613475
* cell instance $383 r0 *1 -158.155,-132.72
X$383 31 108 M3_M2_CDNS_4066195613476
* cell instance $384 r0 *1 -129.91,-132.72
X$384 31 87 M2_M1_CDNS_4066195613487
* cell instance $385 r0 *1 -129.91,-132.72
X$385 31 87 M3_M2_CDNS_40661956134101
* cell instance $386 r0 *1 -205.29,-131.2
X$386 31 151 M3_M2_CDNS_4066195613476
* cell instance $387 r0 *1 -205.29,-131.2
X$387 31 151 M2_M1_CDNS_4066195613475
* cell instance $388 r0 *1 -204.53,-131.96
X$388 31 150 M2_M1_CDNS_4066195613475
* cell instance $389 r0 *1 -204.53,-131.96
X$389 31 150 M3_M2_CDNS_4066195613476
* cell instance $390 r0 *1 -182.17,-131.2
X$390 31 148 M2_M1_CDNS_4066195613475
* cell instance $391 r0 *1 -182.17,-131.2
X$391 31 148 M3_M2_CDNS_4066195613476
* cell instance $392 r0 *1 -181.41,-131.96
X$392 31 121 M2_M1_CDNS_4066195613475
* cell instance $393 r0 *1 -181.41,-131.96
X$393 31 121 M3_M2_CDNS_4066195613476
* cell instance $394 r0 *1 -159.675,-131.2
X$394 31 109 M2_M1_CDNS_4066195613475
* cell instance $395 r0 *1 -159.675,-131.2
X$395 31 109 M3_M2_CDNS_4066195613476
* cell instance $396 r0 *1 -158.915,-131.96
X$396 31 143 M2_M1_CDNS_4066195613475
* cell instance $397 r0 *1 -158.915,-131.96
X$397 31 143 M3_M2_CDNS_4066195613476
* cell instance $398 r0 *1 -131.43,-131.2
X$398 31 85 M2_M1_CDNS_4066195613487
* cell instance $399 r0 *1 -131.43,-131.2
X$399 31 85 M3_M2_CDNS_40661956134101
* cell instance $400 r0 *1 -130.67,-131.96
X$400 31 84 M2_M1_CDNS_4066195613487
* cell instance $401 r0 *1 -130.67,-131.96
X$401 31 84 M3_M2_CDNS_40661956134101
* cell instance $402 r0 *1 -206.05,-130.44
X$402 31 153 M2_M1_CDNS_4066195613475
* cell instance $403 r0 *1 -206.05,-130.44
X$403 31 153 M3_M2_CDNS_4066195613476
* cell instance $404 r0 *1 -182.93,-130.44
X$404 31 136 M2_M1_CDNS_4066195613475
* cell instance $405 r0 *1 -182.93,-130.44
X$405 31 136 M3_M2_CDNS_4066195613476
* cell instance $406 r0 *1 -160.435,-130.44
X$406 31 110 M2_M1_CDNS_4066195613475
* cell instance $407 r0 *1 -160.435,-130.44
X$407 31 110 M3_M2_CDNS_4066195613476
* cell instance $408 r0 *1 -132.19,-130.44
X$408 31 91 M2_M1_CDNS_4066195613487
* cell instance $409 r0 *1 -132.19,-130.44
X$409 31 91 M3_M2_CDNS_40661956134101
* cell instance $410 r0 *1 -206.81,-129.68
X$410 31 149 M2_M1_CDNS_4066195613475
* cell instance $411 r0 *1 -206.81,-129.68
X$411 31 149 M3_M2_CDNS_4066195613476
* cell instance $412 r0 *1 -183.69,-129.68
X$412 31 119 M2_M1_CDNS_4066195613475
* cell instance $413 r0 *1 -183.69,-129.68
X$413 31 119 M3_M2_CDNS_4066195613476
* cell instance $414 r0 *1 -161.195,-129.68
X$414 31 144 M2_M1_CDNS_4066195613475
* cell instance $415 r0 *1 -161.195,-129.68
X$415 31 144 M3_M2_CDNS_4066195613476
* cell instance $416 r0 *1 -132.95,-129.68
X$416 31 90 M2_M1_CDNS_4066195613487
* cell instance $417 r0 *1 -132.95,-129.68
X$417 31 90 M3_M2_CDNS_40661956134101
* cell instance $418 r0 *1 -207.57,-128.92
X$418 31 129 M2_M1_CDNS_4066195613475
* cell instance $419 r0 *1 -207.57,-128.92
X$419 31 129 M3_M2_CDNS_4066195613476
* cell instance $420 r0 *1 -184.45,-128.92
X$420 31 120 M2_M1_CDNS_4066195613475
* cell instance $421 r0 *1 -184.45,-128.92
X$421 31 120 M3_M2_CDNS_4066195613476
* cell instance $422 r0 *1 -161.955,-128.92
X$422 31 142 M2_M1_CDNS_4066195613475
* cell instance $423 r0 *1 -161.955,-128.92
X$423 31 142 M3_M2_CDNS_4066195613476
* cell instance $424 r0 *1 -133.71,-128.92
X$424 31 80 M2_M1_CDNS_4066195613487
* cell instance $425 r0 *1 -133.71,-128.92
X$425 31 80 M3_M2_CDNS_40661956134101
* cell instance $426 r0 *1 -209.845,-126.405
X$426 33 32 M2_M1_CDNS_4066195613466
* cell instance $427 r0 *1 -66.63,-126.405
X$427 33 32 M2_M1_CDNS_4066195613468
* cell instance $428 r0 *1 -170.2,-126.405
X$428 33 32 M2_M1_CDNS_4066195613468
* cell instance $429 r0 *1 -118.29,-126.405
X$429 33 32 M2_M1_CDNS_4066195613468
* cell instance $430 r0 *1 -209.845,-69.925
X$430 35 34 M2_M1_CDNS_4066195613466
* cell instance $431 r0 *1 -164.12,-80.095
X$431 35 34 M3_M2_CDNS_4066195613485
* cell instance $432 r0 *1 -164.12,-80.095
X$432 35 34 M2_M1_CDNS_4066195613484
* cell instance $433 r0 *1 -181.22,-69.925
X$433 35 34 M3_M2_CDNS_4066195613474
* cell instance $434 r0 *1 -170.2,-69.925
X$434 35 34 M2_M1_CDNS_4066195613468
* cell instance $435 r0 *1 -164.705,-69.925
X$435 35 34 M3_M2_CDNS_4066195613474
* cell instance $436 r0 *1 -118.29,-69.925
X$436 35 34 M2_M1_CDNS_4066195613468
* cell instance $437 r0 *1 -66.63,-69.925
X$437 35 34 M2_M1_CDNS_4066195613468
* cell instance $438 r0 *1 48.175,-38.98
X$438 39 36 M3_M2_CDNS_4066195613427
* cell instance $439 r0 *1 48.175,-38.98
X$439 39 36 M2_M1_CDNS_4066195613432
* cell instance $440 r0 *1 48.275,-14.96
X$440 40 37 M2_M1_CDNS_4066195613432
* cell instance $441 r0 *1 48.275,-14.96
X$441 40 37 M3_M2_CDNS_4066195613427
* cell instance $442 r0 *1 48.215,-54.725
X$442 41 38 M3_M2_CDNS_4066195613427
* cell instance $443 r0 *1 48.215,-54.725
X$443 41 38 M2_M1_CDNS_4066195613432
* cell instance $444 r0 *1 41.385,-7.02
X$444 43 42 M2_M1_CDNS_4066195613457
* cell instance $445 r0 *1 41.385,-7.02
X$445 43 42 M3_M2_CDNS_4066195613422
* cell instance $446 r0 *1 44.345,0.19
X$446 45 44 M2_M1_CDNS_4066195613419
* cell instance $447 r0 *1 44.345,0.19
X$447 45 44 M3_M2_CDNS_4066195613424
* cell instance $448 r0 *1 34.75,-1.885
X$448 47 46 M2_M1_CDNS_4066195613420
* cell instance $449 r0 *1 34.75,-1.885
X$449 47 46 M3_M2_CDNS_4066195613423
* cell instance $450 r0 *1 29.12,-47.045
X$450 49 48 M2_M1_CDNS_4066195613425
* cell instance $451 r0 *1 29.12,-47.045
X$451 49 48 M3_M2_CDNS_4066195613426
* cell instance $452 r0 *1 2.71,0.19
X$452 52 50 M2_M1_CDNS_4066195613428
* cell instance $453 r0 *1 2.71,0.19
X$453 52 50 M3_M2_CDNS_4066195613430
* cell instance $454 r0 *1 26.585,0.19
X$454 53 51 M2_M1_CDNS_4066195613428
* cell instance $455 r0 *1 26.585,0.19
X$455 53 51 M3_M2_CDNS_4066195613430
* cell instance $456 r0 *1 -124.635,-77.375
X$456 55 54 M3_M2_CDNS_4066195613495
* cell instance $457 r0 *1 -124.635,-77.375
X$457 55 54 M2_M1_CDNS_4066195613496
* cell instance $458 r0 *1 -85.075,-90.39
X$458 59 58 M3_M2_CDNS_4066195613499
* cell instance $459 r0 *1 -85.075,-90.39
X$459 59 58 M2_M1_CDNS_40661956134100
* cell instance $460 r0 *1 -100.23,-78.34
X$460 61 60 M3_M2_CDNS_4066195613497
* cell instance $461 r0 *1 -100.23,-78.34
X$461 61 60 M2_M1_CDNS_4066195613498
* cell instance $462 r0 *1 -164.59,-98.275
X$462 64 62 M3_M2_CDNS_4066195613465
* cell instance $463 r0 *1 -164.59,-98.275
X$463 64 62 M2_M1_CDNS_4066195613464
* cell instance $464 r0 *1 -164.135,-109.68
X$464 65 63 M3_M2_CDNS_4066195613465
* cell instance $465 r0 *1 -164.135,-109.68
X$465 65 63 M2_M1_CDNS_4066195613464
* cell instance $466 r0 *1 -209.265,-98.275
X$466 68 66 M3_M2_CDNS_4066195613461
* cell instance $467 r0 *1 -209.265,-98.275
X$467 68 66 M2_M1_CDNS_4066195613460
* cell instance $468 r0 *1 -192.165,-98.275
X$468 69 67 M3_M2_CDNS_4066195613461
* cell instance $469 r0 *1 -192.165,-98.275
X$469 69 67 M2_M1_CDNS_4066195613460
* cell instance $470 r0 *1 -112.415,-110.555
X$470 75 71 M3_M2_CDNS_4066195613462
* cell instance $471 r0 *1 -112.415,-110.555
X$471 75 71 M2_M1_CDNS_4066195613463
* cell instance $472 r0 *1 -136.77,-86.675
X$472 76 72 M3_M2_CDNS_4066195613462
* cell instance $473 r0 *1 -136.77,-86.675
X$473 76 72 M2_M1_CDNS_4066195613463
* cell instance $474 r0 *1 -112.415,-87.825
X$474 77 73 M3_M2_CDNS_4066195613462
* cell instance $475 r0 *1 -112.415,-87.825
X$475 77 73 M2_M1_CDNS_4066195613463
* cell instance $476 r0 *1 -136.83,-109.09
X$476 78 74 M3_M2_CDNS_4066195613462
* cell instance $477 r0 *1 -136.83,-109.09
X$477 78 74 M2_M1_CDNS_4066195613463
* cell instance $478 r0 *1 -134.47,-128.16
X$478 93 81 M2_M1_CDNS_4066195613487
* cell instance $479 r0 *1 -134.47,-128.16
X$479 93 81 M3_M2_CDNS_40661956134101
* cell instance $480 r0 *1 -52.49,-165.09
X$480 95 94 M3_M2_CDNS_4066195613491
* cell instance $481 r0 *1 -52.49,-165.09
X$481 95 94 M2_M1_CDNS_4066195613492
* cell instance $482 r0 *1 -162.715,-128.16
X$482 102 98 M3_M2_CDNS_4066195613477
* cell instance $483 r0 *1 -162.715,-128.16
X$483 102 98 M2_M1_CDNS_4066195613469
* cell instance $484 r0 *1 -185.21,-128.16
X$484 103 99 M3_M2_CDNS_4066195613477
* cell instance $485 r0 *1 -185.21,-128.16
X$485 103 99 M2_M1_CDNS_4066195613469
* cell instance $486 r0 *1 -208.33,-128.16
X$486 104 101 M2_M1_CDNS_4066195613469
* cell instance $487 r0 *1 -208.33,-128.16
X$487 104 101 M3_M2_CDNS_4066195613477
* cell instance $488 r0 *1 -165.735,-170.755
X$488 168 115 M2_M1_CDNS_4066195613475
* cell instance $489 r0 *1 -165.735,-170.755
X$489 168 115 M3_M2_CDNS_4066195613476
* cell instance $490 r0 *1 -166.495,-169.995
X$490 167 162 M3_M2_CDNS_4066195613476
* cell instance $491 r0 *1 -166.495,-169.995
X$491 167 162 M2_M1_CDNS_4066195613475
* cell instance $492 r0 *1 -64.605,-180.695
X$492 175 170 M3_M2_CDNS_4066195613489
* cell instance $493 r0 *1 -64.605,-180.695
X$493 175 170 M2_M1_CDNS_4066195613490
* cell instance $494 r0 *1 -64.605,-158.325
X$494 176 171 M2_M1_CDNS_4066195613490
* cell instance $495 r0 *1 -64.605,-158.325
X$495 176 171 M3_M2_CDNS_4066195613489
* cell instance $496 r0 *1 -40.205,-159.985
X$496 177 172 M2_M1_CDNS_4066195613490
* cell instance $497 r0 *1 -40.205,-159.985
X$497 177 172 M3_M2_CDNS_4066195613489
* cell instance $498 r0 *1 -92.095,-153.39
X$498 178 173 M2_M1_CDNS_4066195613490
* cell instance $499 r0 *1 -92.095,-153.39
X$499 178 173 M3_M2_CDNS_4066195613489
* cell instance $500 r0 *1 -40.39,-182.515
X$500 179 174 M3_M2_CDNS_4066195613489
* cell instance $501 r0 *1 -40.39,-182.515
X$501 179 174 M2_M1_CDNS_4066195613490
* cell instance $502 r0 *1 -27.95,-187.26
X$502 183 180 M2_M1_CDNS_4066195613494
* cell instance $503 r0 *1 -27.95,-187.26
X$503 183 180 M3_M2_CDNS_4066195613493
* cell instance $504 r0 *1 -52.49,-149.245
X$504 184 181 M2_M1_CDNS_4066195613494
* cell instance $505 r0 *1 -52.49,-149.245
X$505 184 181 M3_M2_CDNS_4066195613493
* cell instance $506 r0 *1 -27.95,-149.245
X$506 185 182 M2_M1_CDNS_4066195613494
* cell instance $507 r0 *1 -27.95,-149.245
X$507 185 182 M3_M2_CDNS_4066195613493
* cell instance $508 r0 *1 -40.55,-232.115
X$508 187 186 M3_M2_CDNS_40661956134105
* cell instance $509 r0 *1 -40.55,-232.115
X$509 187 186 M2_M1_CDNS_40661956134104
* cell instance $510 r0 *1 -82.115,-232.115
X$510 189 188 M3_M2_CDNS_40661956134106
* cell instance $511 r0 *1 -82.115,-232.115
X$511 189 188 M2_M1_CDNS_40661956134107
* cell instance $512 r0 *1 -58.54,-250.875
X$512 207 193 M3_M2_CDNS_40661956134103
* cell instance $513 r0 *1 -58.54,-250.875
X$513 207 193 M2_M1_CDNS_40661956134102
* cell instance $514 r0 *1 -149.81,-161.15
X$514 208 194 M2_M1_CDNS_40661956134102
* cell instance $515 r0 *1 -149.81,-161.15
X$515 208 194 M3_M2_CDNS_40661956134103
* cell instance $516 r0 *1 -99.44,-215.98
X$516 209 195 M2_M1_CDNS_40661956134102
* cell instance $517 r0 *1 -99.44,-215.98
X$517 209 195 M3_M2_CDNS_40661956134103
* cell instance $518 r0 *1 -123.75,-188.905
X$518 210 196 M2_M1_CDNS_40661956134102
* cell instance $519 r0 *1 -123.75,-188.905
X$519 210 196 M3_M2_CDNS_40661956134103
* cell instance $520 r0 *1 -110.245,-178.38
X$520 211 197 M2_M1_CDNS_40661956134102
* cell instance $521 r0 *1 -110.245,-178.38
X$521 211 197 M3_M2_CDNS_40661956134103
* cell instance $522 r0 *1 -58.54,-231.875
X$522 212 198 M2_M1_CDNS_40661956134102
* cell instance $523 r0 *1 -58.54,-231.875
X$523 212 198 M3_M2_CDNS_40661956134103
* cell instance $524 r0 *1 -73.37,-241.005
X$524 213 199 M2_M1_CDNS_40661956134102
* cell instance $525 r0 *1 -73.37,-241.005
X$525 213 199 M3_M2_CDNS_40661956134103
* cell instance $526 r0 *1 -87.25,-223.4
X$526 214 200 M2_M1_CDNS_40661956134102
* cell instance $527 r0 *1 -87.25,-223.4
X$527 214 200 M3_M2_CDNS_40661956134103
* cell instance $528 r0 *1 -162.005,-152.5
X$528 215 201 M3_M2_CDNS_40661956134103
* cell instance $529 r0 *1 -162.005,-152.5
X$529 215 201 M2_M1_CDNS_40661956134102
* cell instance $530 r0 *1 -137.585,-178.38
X$530 216 202 M3_M2_CDNS_40661956134103
* cell instance $531 r0 *1 -137.585,-178.38
X$531 216 202 M2_M1_CDNS_40661956134102
* cell instance $532 r0 *1 -137.585,-152.5
X$532 217 203 M3_M2_CDNS_40661956134103
* cell instance $533 r0 *1 -137.585,-152.5
X$533 217 203 M2_M1_CDNS_40661956134102
* cell instance $534 r0 *1 -46.41,-250.875
X$534 218 204 M3_M2_CDNS_40661956134103
* cell instance $535 r0 *1 -46.41,-250.875
X$535 218 204 M2_M1_CDNS_40661956134102
* cell instance $536 r0 *1 -34.23,-250.875
X$536 219 205 M3_M2_CDNS_40661956134103
* cell instance $537 r0 *1 -34.23,-250.875
X$537 219 205 M2_M1_CDNS_40661956134102
* cell instance $538 r0 *1 -72.645,-215.98
X$538 220 206 M3_M2_CDNS_40661956134103
* cell instance $539 r0 *1 -72.645,-215.98
X$539 220 206 M2_M1_CDNS_40661956134102
.ENDS moscap_routing

* cell M1_PSUB_CDNS_406619561340
* pin
* pin
.SUBCKT M1_PSUB_CDNS_406619561340 1 2
.ENDS M1_PSUB_CDNS_406619561340

* cell M1_PSUB_CDNS_406619561344
* pin
* pin
.SUBCKT M1_PSUB_CDNS_406619561344 1 2
.ENDS M1_PSUB_CDNS_406619561344

* cell M1_PSUB_CDNS_406619561341
* pin
* pin
.SUBCKT M1_PSUB_CDNS_406619561341 1 2
.ENDS M1_PSUB_CDNS_406619561341

* cell M1_PSUB_CDNS_406619561342
* pin
* pin
.SUBCKT M1_PSUB_CDNS_406619561342 1 2
.ENDS M1_PSUB_CDNS_406619561342

* cell M3_M2_CDNS_406619561347
* pin
* pin
.SUBCKT M3_M2_CDNS_406619561347 1 2
.ENDS M3_M2_CDNS_406619561347

* cell M1_PSUB_CDNS_406619561343
* pin
* pin
.SUBCKT M1_PSUB_CDNS_406619561343 1 2
.ENDS M1_PSUB_CDNS_406619561343

* cell M1_PSUB_CDNS_406619561345
* pin
* pin
.SUBCKT M1_PSUB_CDNS_406619561345 1 2
.ENDS M1_PSUB_CDNS_406619561345

* cell M3_M2_CDNS_406619561346
* pin
* pin
.SUBCKT M3_M2_CDNS_406619561346 1 2
.ENDS M3_M2_CDNS_406619561346

* cell M1_NWELL_CDNS_40661956134483
* pin
* pin
* pin
* pin
.SUBCKT M1_NWELL_CDNS_40661956134483 1 2 3 4
.ENDS M1_NWELL_CDNS_40661956134483

* cell M1_PSUB_CDNS_40661956134199
* pin
* pin
.SUBCKT M1_PSUB_CDNS_40661956134199 1 2
.ENDS M1_PSUB_CDNS_40661956134199

* cell M1_PSUB_CDNS_40661956134499
* pin
.SUBCKT M1_PSUB_CDNS_40661956134499 1
.ENDS M1_PSUB_CDNS_40661956134499

* cell M1_PSUB_CDNS_40661956134484
* pin
* pin
.SUBCKT M1_PSUB_CDNS_40661956134484 1 2
.ENDS M1_PSUB_CDNS_40661956134484

* cell M2_M1_CDNS_40661956134492
* pin
* pin
.SUBCKT M2_M1_CDNS_40661956134492 1 2
.ENDS M2_M1_CDNS_40661956134492

* cell M3_M2_CDNS_40661956134491
* pin
* pin
.SUBCKT M3_M2_CDNS_40661956134491 1 2
.ENDS M3_M2_CDNS_40661956134491

* cell M3_M2_CDNS_40661956134490
* pin
* pin
.SUBCKT M3_M2_CDNS_40661956134490 1 2
.ENDS M3_M2_CDNS_40661956134490

* cell M2_M1_CDNS_40661956134462
* pin
* pin
.SUBCKT M2_M1_CDNS_40661956134462 1 2
.ENDS M2_M1_CDNS_40661956134462

* cell M2_M1_CDNS_40661956134493
* pin
* pin
.SUBCKT M2_M1_CDNS_40661956134493 1 2
.ENDS M2_M1_CDNS_40661956134493

* cell M3_M2_CDNS_40661956134224
* pin
* pin
.SUBCKT M3_M2_CDNS_40661956134224 1 2
.ENDS M3_M2_CDNS_40661956134224

* cell M3_M2_CDNS_40661956134223
* pin
* pin
.SUBCKT M3_M2_CDNS_40661956134223 1 2
.ENDS M3_M2_CDNS_40661956134223

* cell M2_M1_CDNS_40661956134497
* pin
* pin
.SUBCKT M2_M1_CDNS_40661956134497 1 2
.ENDS M2_M1_CDNS_40661956134497

* cell M2_M1_CDNS_40661956134498
* pin
* pin
.SUBCKT M2_M1_CDNS_40661956134498 1 2
.ENDS M2_M1_CDNS_40661956134498

* cell M2_M1_CDNS_40661956134258
* pin
* pin
.SUBCKT M2_M1_CDNS_40661956134258 1 2
.ENDS M2_M1_CDNS_40661956134258

* cell M3_M2_CDNS_40661956134227
* pin
* pin
.SUBCKT M3_M2_CDNS_40661956134227 1 2
.ENDS M3_M2_CDNS_40661956134227

* cell M2_M1_CDNS_40661956134494
* pin
* pin
.SUBCKT M2_M1_CDNS_40661956134494 1 2
.ENDS M2_M1_CDNS_40661956134494

* cell M2_M1_CDNS_40661956134495
* pin
* pin
.SUBCKT M2_M1_CDNS_40661956134495 1 2
.ENDS M2_M1_CDNS_40661956134495

* cell comp018green_esd_hbm
* pin
* pin
* pin
* pin
* pin
* pin
* pin
* pin
* pin
* pin
* pin
* pin
* pin
* pin
* pin
* pin
* pin
* pin
* pin
* pin
* pin
* pin
* pin
* pin
* pin
.SUBCKT comp018green_esd_hbm 3 4 8 9 10 11 12 13 14 15 16 17 18 19 20 21 22 23
+ 24 25 26 27 28 29 30
* cell instance $1 r0 *1 3.645,17.635
X$1 3 1 7 3 M1_NWELL_CDNS_40661956134503
* cell instance $2 r0 *1 30.655,3.595
X$2 3 1 7 3 M1_NWELL_CDNS_40661956134501
* cell instance $3 r0 *1 4.415,7.105
X$3 3 1 7 3 M1_NWELL_CDNS_40661956134321
* cell instance $4 r0 *1 30.655,10.615
X$4 3 3 7 1 M1_NWELL_CDNS_40661956134500
* cell instance $5 r0 *1 30.655,11.385
X$5 3 1 7 3 M1_NWELL_CDNS_40661956134502
* cell instance $6 r0 *1 30.655,23.885
X$6 3 1 7 3 M1_NWELL_CDNS_40661956134502
* cell instance $7 r0 *1 30.655,18.405
X$7 3 1 7 3 M1_NWELL_CDNS_40661956134502
* cell instance $8 r0 *1 30.655,9.845
X$8 3 1 7 3 M1_NWELL_CDNS_40661956134502
* cell instance $9 r0 *1 30.655,16.865
X$9 3 1 7 3 M1_NWELL_CDNS_40661956134502
* cell instance $10 r0 *1 30.655,25.425
X$10 3 1 7 3 M1_NWELL_CDNS_40661956134502
* cell instance $11 r0 *1 30.655,4.365
X$11 3 1 7 3 M1_NWELL_CDNS_40661956134502
* cell instance $12 r0 *1 30.655,30.905
X$12 3 1 7 3 M1_NWELL_CDNS_40661956134502
* cell instance $13 r0 *1 30.655,24.655
X$13 3 3 7 1 M1_NWELL_CDNS_40661956134500
* cell instance $14 r0 *1 30.655,17.635
X$14 3 3 7 1 M1_NWELL_CDNS_40661956134500
* cell instance $15 r0 *1 4.415,14.125
X$15 3 1 7 3 M1_NWELL_CDNS_40661956134321
* cell instance $16 r0 *1 4.415,21.145
X$16 3 1 7 3 M1_NWELL_CDNS_40661956134321
* cell instance $17 r0 *1 4.415,28.165
X$17 3 1 7 3 M1_NWELL_CDNS_40661956134321
* cell instance $18 r0 *1 56.895,21.145
X$18 3 1 7 3 M1_NWELL_CDNS_40661956134321
* cell instance $19 r0 *1 56.895,28.165
X$19 3 1 7 3 M1_NWELL_CDNS_40661956134321
* cell instance $20 r0 *1 56.895,7.105
X$20 3 1 7 3 M1_NWELL_CDNS_40661956134321
* cell instance $21 r0 *1 56.895,14.125
X$21 3 1 7 3 M1_NWELL_CDNS_40661956134321
* cell instance $22 r0 *1 30.655,31.675
X$22 3 1 7 3 M1_NWELL_CDNS_40661956134501
* cell instance $23 r0 *1 57.665,17.635
X$23 3 1 7 3 M1_NWELL_CDNS_40661956134503
* cell instance $24 r0 *1 30.655,40.63
X$24 4 2 M1_PSUB_CDNS_40661956134504
* cell instance $25 r0 *1 3.645,54.67
X$25 4 2 M1_PSUB_CDNS_40661956134505
* cell instance $26 r0 *1 4.415,51.16
X$26 4 2 M1_PSUB_CDNS_40661956134507
* cell instance $27 r0 *1 30.655,54.67
X$27 4 2 M1_PSUB_CDNS_40661956134508
* cell instance $28 r0 *1 30.655,55.44
X$28 4 2 M1_PSUB_CDNS_40661956134506
* cell instance $29 r0 *1 30.655,67.94
X$29 4 2 M1_PSUB_CDNS_40661956134506
* cell instance $30 r0 *1 30.655,46.88
X$30 4 2 M1_PSUB_CDNS_40661956134506
* cell instance $31 r0 *1 30.655,62.46
X$31 4 2 M1_PSUB_CDNS_40661956134506
* cell instance $32 r0 *1 30.655,60.92
X$32 4 2 M1_PSUB_CDNS_40661956134506
* cell instance $33 r0 *1 30.655,41.4
X$33 4 2 M1_PSUB_CDNS_40661956134506
* cell instance $34 r0 *1 30.655,48.42
X$34 4 2 M1_PSUB_CDNS_40661956134506
* cell instance $35 r0 *1 30.655,53.9
X$35 4 2 M1_PSUB_CDNS_40661956134506
* cell instance $36 r0 *1 30.655,61.69
X$36 4 2 M1_PSUB_CDNS_40661956134508
* cell instance $37 r0 *1 30.655,47.65
X$37 4 2 M1_PSUB_CDNS_40661956134508
* cell instance $38 r0 *1 56.895,65.2
X$38 4 2 M1_PSUB_CDNS_40661956134507
* cell instance $39 r0 *1 56.895,58.18
X$39 4 2 M1_PSUB_CDNS_40661956134507
* cell instance $40 r0 *1 56.895,51.16
X$40 4 2 M1_PSUB_CDNS_40661956134507
* cell instance $41 r0 *1 56.895,44.14
X$41 4 2 M1_PSUB_CDNS_40661956134507
* cell instance $42 r0 *1 4.415,65.2
X$42 4 2 M1_PSUB_CDNS_40661956134507
* cell instance $43 r0 *1 4.415,44.14
X$43 4 2 M1_PSUB_CDNS_40661956134507
* cell instance $44 r0 *1 4.415,58.18
X$44 4 2 M1_PSUB_CDNS_40661956134507
* cell instance $45 r0 *1 57.665,54.67
X$45 4 2 M1_PSUB_CDNS_40661956134505
* cell instance $46 r0 *1 30.655,68.71
X$46 4 2 M1_PSUB_CDNS_40661956134504
* cell instance $47 r0 *1 1.385,54.67
X$47 3 5 31 3 M1_NWELL_CDNS_40661956134515
* cell instance $48 r0 *1 59.925,54.67
X$48 3 5 31 3 M1_NWELL_CDNS_40661956134515
* cell instance $49 r0 *1 30.655,38.42
X$49 3 5 3 31 M1_NWELL_CDNS_40661956134510
* cell instance $50 r0 *1 30.655,70.92
X$50 3 5 3 31 M1_NWELL_CDNS_40661956134510
* cell instance $51 r90 *1 55.655,5.605
X$51 30 3 7 pn_6p0_CDNS_4066195613452
* cell instance $52 r90 *1 55.655,12.625
X$52 30 3 7 pn_6p0_CDNS_4066195613452
* cell instance $53 r90 *1 55.655,19.645
X$53 30 3 7 pn_6p0_CDNS_4066195613452
* cell instance $54 r90 *1 55.655,26.665
X$54 30 3 7 pn_6p0_CDNS_4066195613452
* cell instance $55 r0 *1 4.085,17.635
X$55 3 10 M2_M1_CDNS_40661956134511
* cell instance $56 r0 *1 12.605,3.98
X$56 3 15 M2_M1_CDNS_40661956134250
* cell instance $57 r0 *1 23.965,3.98
X$57 3 20 M2_M1_CDNS_40661956134250
* cell instance $58 m90 *1 37.345,3.98
X$58 3 24 M2_M1_CDNS_40661956134250
* cell instance $59 m90 *1 48.705,3.98
X$59 3 28 M2_M1_CDNS_40661956134250
* cell instance $60 m90 *1 57.225,17.635
X$60 3 9 M2_M1_CDNS_40661956134511
* cell instance $61 r0 *1 12.605,10.615
X$61 3 15 M2_M1_CDNS_40661956134207
* cell instance $62 r0 *1 23.965,10.615
X$62 3 20 M2_M1_CDNS_40661956134207
* cell instance $63 m90 *1 37.345,10.615
X$63 3 24 M2_M1_CDNS_40661956134207
* cell instance $64 m90 *1 48.705,10.615
X$64 3 28 M2_M1_CDNS_40661956134207
* cell instance $65 r0 *1 12.605,17.635
X$65 3 15 M2_M1_CDNS_40661956134207
* cell instance $66 r0 *1 23.965,17.635
X$66 3 20 M2_M1_CDNS_40661956134207
* cell instance $67 m90 *1 37.345,17.635
X$67 3 24 M2_M1_CDNS_40661956134207
* cell instance $68 m90 *1 48.705,17.635
X$68 3 28 M2_M1_CDNS_40661956134207
* cell instance $69 r0 *1 12.605,24.655
X$69 3 15 M2_M1_CDNS_40661956134207
* cell instance $70 r0 *1 23.965,24.655
X$70 3 20 M2_M1_CDNS_40661956134207
* cell instance $71 m90 *1 37.345,24.655
X$71 3 24 M2_M1_CDNS_40661956134207
* cell instance $72 m90 *1 48.705,24.655
X$72 3 28 M2_M1_CDNS_40661956134207
* cell instance $73 r0 *1 12.605,31.29
X$73 3 15 M2_M1_CDNS_40661956134250
* cell instance $74 r0 *1 23.965,31.29
X$74 3 20 M2_M1_CDNS_40661956134250
* cell instance $75 m90 *1 37.345,31.29
X$75 3 24 M2_M1_CDNS_40661956134250
* cell instance $76 m90 *1 48.705,31.29
X$76 3 28 M2_M1_CDNS_40661956134250
* cell instance $77 r0 *1 4.085,38.42
X$77 3 10 M2_M1_CDNS_40661956134516
* cell instance $78 r0 *1 12.605,38.42
X$78 3 15 M2_M1_CDNS_40661956134516
* cell instance $79 r0 *1 23.965,38.42
X$79 3 20 M2_M1_CDNS_40661956134516
* cell instance $80 m90 *1 37.345,38.42
X$80 3 24 M2_M1_CDNS_40661956134516
* cell instance $81 m90 *1 48.705,38.42
X$81 3 28 M2_M1_CDNS_40661956134516
* cell instance $82 m90 *1 57.225,38.42
X$82 3 9 M2_M1_CDNS_40661956134516
* cell instance $83 r0 *1 4.085,70.92
X$83 3 10 M2_M1_CDNS_40661956134516
* cell instance $84 r0 *1 12.605,70.92
X$84 3 15 M2_M1_CDNS_40661956134516
* cell instance $85 r0 *1 23.965,70.92
X$85 3 20 M2_M1_CDNS_40661956134516
* cell instance $86 m90 *1 37.345,70.92
X$86 3 24 M2_M1_CDNS_40661956134516
* cell instance $87 m90 *1 48.705,70.92
X$87 3 28 M2_M1_CDNS_40661956134516
* cell instance $88 m90 *1 57.225,70.92
X$88 3 9 M2_M1_CDNS_40661956134516
* cell instance $89 r0 *1 1.615,17.635
X$89 4 12 M2_M1_CDNS_40661956134509
* cell instance $90 r0 *1 1.385,17.635
X$90 4 6 M1_PSUB_CDNS_40661956134512
* cell instance $91 r0 *1 59.925,17.635
X$91 4 6 M1_PSUB_CDNS_40661956134512
* cell instance $92 r0 *1 59.695,17.635
X$92 4 11 M2_M1_CDNS_40661956134513
* cell instance $93 m90 *1 59.695,17.635
X$93 4 11 M2_M1_CDNS_40661956134509
* cell instance $94 r0 *1 6.925,1.385
X$94 4 8 M2_M1_CDNS_40661956134516
* cell instance $95 r0 *1 30.655,1.385
X$95 4 6 M1_PSUB_CDNS_40661956134514
* cell instance $96 r0 *1 18.285,1.385
X$96 4 16 M2_M1_CDNS_40661956134516
* cell instance $97 r0 *1 29.44,1.385
X$97 4 22 M2_M1_CDNS_40661956134517
* cell instance $98 m90 *1 31.87,1.385
X$98 4 18 M2_M1_CDNS_40661956134517
* cell instance $99 m90 *1 43.025,1.385
X$99 4 26 M2_M1_CDNS_40661956134516
* cell instance $100 m90 *1 54.385,1.385
X$100 4 13 M2_M1_CDNS_40661956134516
* cell instance $101 r0 *1 6.925,33.885
X$101 4 8 M2_M1_CDNS_40661956134516
* cell instance $102 r0 *1 30.655,33.885
X$102 4 6 M1_PSUB_CDNS_40661956134514
* cell instance $103 r0 *1 18.285,33.885
X$103 4 16 M2_M1_CDNS_40661956134516
* cell instance $104 r0 *1 29.44,33.885
X$104 4 22 M2_M1_CDNS_40661956134517
* cell instance $105 m90 *1 31.87,33.885
X$105 4 18 M2_M1_CDNS_40661956134517
* cell instance $106 m90 *1 43.025,33.885
X$106 4 26 M2_M1_CDNS_40661956134516
* cell instance $107 m90 *1 54.385,33.885
X$107 4 13 M2_M1_CDNS_40661956134516
* cell instance $108 r0 *1 6.925,41.015
X$108 4 8 M2_M1_CDNS_40661956134250
* cell instance $109 r0 *1 18.285,41.015
X$109 4 16 M2_M1_CDNS_40661956134250
* cell instance $110 r0 *1 29.44,41.015
X$110 4 22 M2_M1_CDNS_40661956134488
* cell instance $111 m90 *1 31.87,41.015
X$111 4 18 M2_M1_CDNS_40661956134488
* cell instance $112 m90 *1 43.025,41.015
X$112 4 26 M2_M1_CDNS_40661956134250
* cell instance $113 m90 *1 54.385,41.015
X$113 4 13 M2_M1_CDNS_40661956134250
* cell instance $114 r0 *1 6.925,68.325
X$114 4 8 M2_M1_CDNS_40661956134250
* cell instance $115 r0 *1 18.285,68.325
X$115 4 16 M2_M1_CDNS_40661956134250
* cell instance $116 r0 *1 29.44,68.325
X$116 4 22 M2_M1_CDNS_40661956134488
* cell instance $117 m90 *1 31.87,68.325
X$117 4 18 M2_M1_CDNS_40661956134488
* cell instance $118 m90 *1 43.025,68.325
X$118 4 26 M2_M1_CDNS_40661956134250
* cell instance $119 m90 *1 54.385,68.325
X$119 4 13 M2_M1_CDNS_40661956134250
* cell instance $120 r0 *1 6.925,47.65
X$120 4 8 M2_M1_CDNS_40661956134207
* cell instance $121 r0 *1 18.285,47.65
X$121 4 16 M2_M1_CDNS_40661956134207
* cell instance $122 r0 *1 29.44,47.65
X$122 4 22 M2_M1_CDNS_40661956134489
* cell instance $123 m90 *1 31.87,47.65
X$123 4 18 M2_M1_CDNS_40661956134489
* cell instance $124 m90 *1 43.025,47.65
X$124 4 26 M2_M1_CDNS_40661956134207
* cell instance $125 m90 *1 54.385,47.65
X$125 4 13 M2_M1_CDNS_40661956134207
* cell instance $126 r0 *1 6.925,54.67
X$126 4 8 M2_M1_CDNS_40661956134207
* cell instance $127 r0 *1 18.285,54.67
X$127 4 16 M2_M1_CDNS_40661956134207
* cell instance $128 r0 *1 29.44,54.67
X$128 4 22 M2_M1_CDNS_40661956134489
* cell instance $129 m90 *1 31.87,54.67
X$129 4 18 M2_M1_CDNS_40661956134489
* cell instance $130 m90 *1 43.025,54.67
X$130 4 26 M2_M1_CDNS_40661956134207
* cell instance $131 m90 *1 54.385,54.67
X$131 4 13 M2_M1_CDNS_40661956134207
* cell instance $132 r0 *1 6.925,61.69
X$132 4 8 M2_M1_CDNS_40661956134207
* cell instance $133 r0 *1 18.285,61.69
X$133 4 16 M2_M1_CDNS_40661956134207
* cell instance $134 r0 *1 29.44,61.69
X$134 4 22 M2_M1_CDNS_40661956134489
* cell instance $135 m90 *1 31.87,61.69
X$135 4 18 M2_M1_CDNS_40661956134489
* cell instance $136 m90 *1 43.025,61.69
X$136 4 26 M2_M1_CDNS_40661956134207
* cell instance $137 m90 *1 54.385,61.69
X$137 4 13 M2_M1_CDNS_40661956134207
* cell instance $138 r0 *1 9.765,7.105
X$138 30 14 M2_M1_CDNS_40661956134496
* cell instance $139 r0 *1 9.765,44.14
X$139 30 14 M2_M1_CDNS_40661956134496
* cell instance $140 r0 *1 9.765,28.165
X$140 30 14 M2_M1_CDNS_40661956134496
* cell instance $141 r0 *1 9.765,65.2
X$141 30 14 M2_M1_CDNS_40661956134496
* cell instance $142 r0 *1 9.765,58.18
X$142 30 14 M2_M1_CDNS_40661956134496
* cell instance $143 r0 *1 9.765,51.16
X$143 30 14 M2_M1_CDNS_40661956134496
* cell instance $144 r0 *1 9.765,21.145
X$144 30 14 M2_M1_CDNS_40661956134496
* cell instance $145 r0 *1 9.765,14.125
X$145 30 14 M2_M1_CDNS_40661956134496
* cell instance $146 r0 *1 15.445,51.16
X$146 30 17 M2_M1_CDNS_40661956134496
* cell instance $147 r0 *1 15.445,65.2
X$147 30 17 M2_M1_CDNS_40661956134496
* cell instance $148 r0 *1 15.445,58.18
X$148 30 17 M2_M1_CDNS_40661956134496
* cell instance $149 r0 *1 15.445,14.125
X$149 30 17 M2_M1_CDNS_40661956134496
* cell instance $150 r0 *1 15.445,7.105
X$150 30 17 M2_M1_CDNS_40661956134496
* cell instance $151 r0 *1 15.445,28.165
X$151 30 17 M2_M1_CDNS_40661956134496
* cell instance $152 r0 *1 15.445,21.145
X$152 30 17 M2_M1_CDNS_40661956134496
* cell instance $153 r0 *1 15.445,44.14
X$153 30 17 M2_M1_CDNS_40661956134496
* cell instance $154 r0 *1 26.805,51.16
X$154 30 19 M2_M1_CDNS_40661956134496
* cell instance $155 r0 *1 26.805,44.14
X$155 30 19 M2_M1_CDNS_40661956134496
* cell instance $156 r0 *1 26.805,58.18
X$156 30 19 M2_M1_CDNS_40661956134496
* cell instance $157 r0 *1 26.805,65.2
X$157 30 19 M2_M1_CDNS_40661956134496
* cell instance $158 r0 *1 26.805,7.105
X$158 30 19 M2_M1_CDNS_40661956134496
* cell instance $159 r0 *1 26.805,14.125
X$159 30 19 M2_M1_CDNS_40661956134496
* cell instance $160 r0 *1 26.805,21.145
X$160 30 19 M2_M1_CDNS_40661956134496
* cell instance $161 r0 *1 26.805,28.165
X$161 30 19 M2_M1_CDNS_40661956134496
* cell instance $162 r0 *1 21.125,51.16
X$162 30 21 M2_M1_CDNS_40661956134496
* cell instance $163 r0 *1 21.125,65.2
X$163 30 21 M2_M1_CDNS_40661956134496
* cell instance $164 r0 *1 21.125,58.18
X$164 30 21 M2_M1_CDNS_40661956134496
* cell instance $165 r0 *1 21.125,44.14
X$165 30 21 M2_M1_CDNS_40661956134496
* cell instance $166 r0 *1 21.125,14.125
X$166 30 21 M2_M1_CDNS_40661956134496
* cell instance $167 r0 *1 21.125,7.105
X$167 30 21 M2_M1_CDNS_40661956134496
* cell instance $168 r0 *1 21.125,21.145
X$168 30 21 M2_M1_CDNS_40661956134496
* cell instance $169 r0 *1 21.125,28.165
X$169 30 21 M2_M1_CDNS_40661956134496
* cell instance $170 r0 *1 34.505,65.2
X$170 30 23 M2_M1_CDNS_40661956134496
* cell instance $171 r0 *1 34.505,44.14
X$171 30 23 M2_M1_CDNS_40661956134496
* cell instance $172 r0 *1 34.505,51.16
X$172 30 23 M2_M1_CDNS_40661956134496
* cell instance $173 r0 *1 34.505,58.18
X$173 30 23 M2_M1_CDNS_40661956134496
* cell instance $174 r0 *1 34.505,21.145
X$174 30 23 M2_M1_CDNS_40661956134496
* cell instance $175 r0 *1 34.505,28.165
X$175 30 23 M2_M1_CDNS_40661956134496
* cell instance $176 r0 *1 34.505,14.125
X$176 30 23 M2_M1_CDNS_40661956134496
* cell instance $177 r0 *1 34.505,7.105
X$177 30 23 M2_M1_CDNS_40661956134496
* cell instance $178 r0 *1 40.185,65.2
X$178 30 25 M2_M1_CDNS_40661956134496
* cell instance $179 r0 *1 40.185,51.16
X$179 30 25 M2_M1_CDNS_40661956134496
* cell instance $180 r0 *1 40.185,44.14
X$180 30 25 M2_M1_CDNS_40661956134496
* cell instance $181 r0 *1 40.185,58.18
X$181 30 25 M2_M1_CDNS_40661956134496
* cell instance $182 r0 *1 40.185,21.145
X$182 30 25 M2_M1_CDNS_40661956134496
* cell instance $183 r0 *1 40.185,28.165
X$183 30 25 M2_M1_CDNS_40661956134496
* cell instance $184 r0 *1 40.185,14.125
X$184 30 25 M2_M1_CDNS_40661956134496
* cell instance $185 r0 *1 40.185,7.105
X$185 30 25 M2_M1_CDNS_40661956134496
* cell instance $186 r0 *1 45.865,44.14
X$186 30 27 M2_M1_CDNS_40661956134496
* cell instance $187 r0 *1 45.865,51.16
X$187 30 27 M2_M1_CDNS_40661956134496
* cell instance $188 r0 *1 45.865,58.18
X$188 30 27 M2_M1_CDNS_40661956134496
* cell instance $189 r0 *1 45.865,65.2
X$189 30 27 M2_M1_CDNS_40661956134496
* cell instance $190 r0 *1 45.865,21.145
X$190 30 27 M2_M1_CDNS_40661956134496
* cell instance $191 r0 *1 45.865,14.125
X$191 30 27 M2_M1_CDNS_40661956134496
* cell instance $192 r0 *1 45.865,7.105
X$192 30 27 M2_M1_CDNS_40661956134496
* cell instance $193 r0 *1 45.865,28.165
X$193 30 27 M2_M1_CDNS_40661956134496
* cell instance $194 r0 *1 51.545,65.2
X$194 30 29 M2_M1_CDNS_40661956134496
* cell instance $195 r0 *1 51.545,51.16
X$195 30 29 M2_M1_CDNS_40661956134496
* cell instance $196 r0 *1 51.545,44.14
X$196 30 29 M2_M1_CDNS_40661956134496
* cell instance $197 r0 *1 51.545,58.18
X$197 30 29 M2_M1_CDNS_40661956134496
* cell instance $198 r0 *1 51.545,21.145
X$198 30 29 M2_M1_CDNS_40661956134496
* cell instance $199 r0 *1 51.545,28.165
X$199 30 29 M2_M1_CDNS_40661956134496
* cell instance $200 r0 *1 51.545,14.125
X$200 30 29 M2_M1_CDNS_40661956134496
* cell instance $201 r0 *1 51.545,7.105
X$201 30 29 M2_M1_CDNS_40661956134496
* cell instance $202 r90 *1 55.655,42.64
X$202 30 np_6p0_CDNS_4066195613453
* cell instance $203 r90 *1 55.655,63.7
X$203 30 np_6p0_CDNS_4066195613453
* cell instance $204 r90 *1 55.655,56.68
X$204 30 np_6p0_CDNS_4066195613453
* cell instance $205 r90 *1 55.655,49.66
X$205 30 np_6p0_CDNS_4066195613453
* device instance $1 r0 *1 30.655,7.105 pn_6p0
D$1 30 3 pn_6p0 A=150P P=106U
* device instance $2 r0 *1 30.655,14.125 pn_6p0
D$2 30 3 pn_6p0 A=150P P=106U
* device instance $3 r0 *1 30.655,21.145 pn_6p0
D$3 30 3 pn_6p0 A=150P P=106U
* device instance $4 r0 *1 30.655,28.165 pn_6p0
D$4 30 3 pn_6p0 A=150P P=106U
.ENDS comp018green_esd_hbm

* cell M1_PSUB_CDNS_40661956134486
* pin
* pin
.SUBCKT M1_PSUB_CDNS_40661956134486 1 2
.ENDS M1_PSUB_CDNS_40661956134486

* cell M1_PSUB_CDNS_40661956134485
* pin
* pin
.SUBCKT M1_PSUB_CDNS_40661956134485 1 2
.ENDS M1_PSUB_CDNS_40661956134485

* cell M1_PSUB_CDNS_40661956134482
* pin
* pin
.SUBCKT M1_PSUB_CDNS_40661956134482 1 2
.ENDS M1_PSUB_CDNS_40661956134482

* cell M1_NWELL_CDNS_40661956134487
* pin
* pin
* pin
* pin
.SUBCKT M1_NWELL_CDNS_40661956134487 1 2 3 4
.ENDS M1_NWELL_CDNS_40661956134487

* cell M1_PSUB_CDNS_40661956134198
* pin
* pin
.SUBCKT M1_PSUB_CDNS_40661956134198 1 2
.ENDS M1_PSUB_CDNS_40661956134198

* cell M1_PSUB_CDNS_40661956134200
* pin
* pin
.SUBCKT M1_PSUB_CDNS_40661956134200 1 2
.ENDS M1_PSUB_CDNS_40661956134200

* cell M3_M2_CDNS_40661956134225
* pin
* pin
.SUBCKT M3_M2_CDNS_40661956134225 1 2
.ENDS M3_M2_CDNS_40661956134225

* cell nmoscap_6p0_CDNS_406619561348
* pin
* pin
.SUBCKT nmoscap_6p0_CDNS_406619561348 1 2
* device instance $1 r0 *1 7.5,7.5 nmoscap_6p0
C$1 2 1 5.175e-13 nmoscap_6p0 A=225P P=60U
.ENDS nmoscap_6p0_CDNS_406619561348

* cell np_6p0_CDNS_406619561349
* pin
.SUBCKT np_6p0_CDNS_406619561349 1
.ENDS np_6p0_CDNS_406619561349

* cell 3LM_METAL_RAIL
* pin
* pin DVSS
* pin VSS
* pin VDD
* pin DVDD
* pin
.SUBCKT 3LM_METAL_RAIL 1 2 3 4 5 6
* net 2 DVSS
* net 3 VSS
* net 4 VDD
* net 5 DVDD
* cell instance $1 r0 *1 0.24,207.62
X$1 6 1 M1_PSUB_CDNS_40661956134176
* cell instance $2 r0 *1 37.665,349.365
X$2 6 1 M1_PSUB_CDNS_40661956134192
* cell instance $3 r0 *1 37.665,65.96
X$3 6 1 M1_PSUB_CDNS_40661956134192
* cell instance $4 r0 *1 74.76,207.62
X$4 6 1 M1_PSUB_CDNS_40661956134176
.ENDS 3LM_METAL_RAIL

* cell Bondpad_3LM
* pin
* pin
.SUBCKT Bondpad_3LM 1 2
* cell instance $1 r0 *1 32.035,1.015
X$1 2 1 M3_M2_CDNS_40661956134196
* cell instance $2 r0 *1 32.04,63.675
X$2 2 1 M3_M2_CDNS_40661956134195
* cell instance $3 r90 *1 64.01,31.27
X$3 2 1 M3_M2_CDNS_40661956134194
* cell instance $4 r90 *1 34.205,31.945
X$4 2 1 M3_M2_CDNS_40661956134193
* cell instance $5 r90 *1 60.2,31.945
X$5 2 1 M3_M2_CDNS_40661956134193
* cell instance $6 r90 *1 36.22,31.945
X$6 2 1 M3_M2_CDNS_40661956134193
* cell instance $7 r90 *1 38.19,31.945
X$7 2 1 M3_M2_CDNS_40661956134193
* cell instance $8 r90 *1 40.195,31.945
X$8 2 1 M3_M2_CDNS_40661956134193
* cell instance $9 r90 *1 42.195,31.945
X$9 2 1 M3_M2_CDNS_40661956134193
* cell instance $10 r90 *1 44.18,31.945
X$10 2 1 M3_M2_CDNS_40661956134193
* cell instance $11 r90 *1 46.165,31.945
X$11 2 1 M3_M2_CDNS_40661956134193
* cell instance $12 r90 *1 48.185,31.945
X$12 2 1 M3_M2_CDNS_40661956134193
* cell instance $13 r90 *1 50.165,31.945
X$13 2 1 M3_M2_CDNS_40661956134193
* cell instance $14 r90 *1 52.165,31.945
X$14 2 1 M3_M2_CDNS_40661956134193
* cell instance $15 r90 *1 54.15,31.945
X$15 2 1 M3_M2_CDNS_40661956134193
* cell instance $16 r90 *1 56.175,31.945
X$16 2 1 M3_M2_CDNS_40661956134193
* cell instance $17 r90 *1 58.175,31.945
X$17 2 1 M3_M2_CDNS_40661956134193
* cell instance $18 r90 *1 32.195,31.945
X$18 2 1 M3_M2_CDNS_40661956134193
* cell instance $19 r90 *1 6.205,31.945
X$19 2 1 M3_M2_CDNS_40661956134193
* cell instance $20 r90 *1 8.205,31.945
X$20 2 1 M3_M2_CDNS_40661956134193
* cell instance $21 r90 *1 10.19,31.945
X$21 2 1 M3_M2_CDNS_40661956134193
* cell instance $22 r90 *1 12.175,31.945
X$22 2 1 M3_M2_CDNS_40661956134193
* cell instance $23 r90 *1 14.195,31.945
X$23 2 1 M3_M2_CDNS_40661956134193
* cell instance $24 r90 *1 16.175,31.945
X$24 2 1 M3_M2_CDNS_40661956134193
* cell instance $25 r90 *1 18.175,31.945
X$25 2 1 M3_M2_CDNS_40661956134193
* cell instance $26 r90 *1 20.16,31.945
X$26 2 1 M3_M2_CDNS_40661956134193
* cell instance $27 r90 *1 22.185,31.945
X$27 2 1 M3_M2_CDNS_40661956134193
* cell instance $28 r90 *1 24.185,31.945
X$28 2 1 M3_M2_CDNS_40661956134193
* cell instance $29 r90 *1 26.21,31.945
X$29 2 1 M3_M2_CDNS_40661956134193
* cell instance $30 r90 *1 28.195,31.945
X$30 2 1 M3_M2_CDNS_40661956134193
* cell instance $31 r90 *1 4.2,31.945
X$31 2 1 M3_M2_CDNS_40661956134193
* cell instance $32 r90 *1 30.18,31.945
X$32 2 1 M3_M2_CDNS_40661956134193
* cell instance $33 r90 *1 -0.05,31.27
X$33 2 1 M3_M2_CDNS_40661956134194
.ENDS Bondpad_3LM

* cell M2_M1_CDNS_40661956134178
* pin
* pin
.SUBCKT M2_M1_CDNS_40661956134178 1 2
.ENDS M2_M1_CDNS_40661956134178

* cell M3_M2_CDNS_40661956134180
* pin
* pin
.SUBCKT M3_M2_CDNS_40661956134180 1 2
.ENDS M3_M2_CDNS_40661956134180

* cell M3_M2_CDNS_40661956134193
* pin
* pin
.SUBCKT M3_M2_CDNS_40661956134193 1 2
.ENDS M3_M2_CDNS_40661956134193

* cell M3_M2_CDNS_40661956134194
* pin
* pin
.SUBCKT M3_M2_CDNS_40661956134194 1 2
.ENDS M3_M2_CDNS_40661956134194

* cell M3_M2_CDNS_40661956134195
* pin
* pin
.SUBCKT M3_M2_CDNS_40661956134195 1 2
.ENDS M3_M2_CDNS_40661956134195

* cell M3_M2_CDNS_40661956134196
* pin
* pin
.SUBCKT M3_M2_CDNS_40661956134196 1 2
.ENDS M3_M2_CDNS_40661956134196

* cell M2_M1_CDNS_40661956134231
* pin
* pin
.SUBCKT M2_M1_CDNS_40661956134231 1 2
.ENDS M2_M1_CDNS_40661956134231

* cell M2_M1_CDNS_40661956134239
* pin
* pin
.SUBCKT M2_M1_CDNS_40661956134239 1 2
.ENDS M2_M1_CDNS_40661956134239

* cell M2_M1_CDNS_40661956134241
* pin
* pin
.SUBCKT M2_M1_CDNS_40661956134241 1 2
.ENDS M2_M1_CDNS_40661956134241

* cell nmos_clamp_20_50_4_DVDD
* pin
* pin
* pin
* pin
* pin
* pin
* pin
* pin
* pin
* pin
* pin
* pin
* pin
* pin
* pin
* pin
* pin gf180mcu_gnd
.SUBCKT nmos_clamp_20_50_4_DVDD 1 3 5 6 7 8 9 10 11 12 13 14 15 16 17 18 19
* net 19 gf180mcu_gnd
* cell instance $1 r90 *1 57.405,66.125
X$1 3 5 3 5 3 5 3 5 3 5 3 5 3 5 3 5 3 5 3 5 3 1 1 1 1 1 1 1 1 1 1 1 1 1 1 1 1 1
+ 1 1 1 19 nmos_6p0_CDNS_406619561341
* cell instance $2 r90 *1 57.405,36.765
X$2 3 5 3 5 3 5 3 5 3 5 3 5 3 5 3 5 3 5 3 5 3 1 1 1 1 1 1 1 1 1 1 1 1 1 1 1 1 1
+ 1 1 1 19 nmos_6p0_CDNS_406619561341
* cell instance $3 r90 *1 57.405,7.405
X$3 3 5 3 5 3 5 3 5 3 5 3 5 3 5 3 5 3 5 3 5 3 1 1 1 1 1 1 1 1 1 1 1 1 1 1 1 1 1
+ 1 1 1 19 nmos_6p0_CDNS_406619561341
* cell instance $4 r90 *1 57.405,95.485
X$4 3 5 3 5 3 5 3 5 3 5 3 5 3 5 3 5 3 5 3 5 3 1 1 1 1 1 1 1 1 1 1 1 1 1 1 1 1 1
+ 1 1 1 19 nmos_6p0_CDNS_406619561341
* cell instance $5 r0 *1 58.245,48.705
X$5 1 16 M2_M1_CDNS_40661956134141
* cell instance $6 m90 *1 58.165,48.705
X$6 1 M1_POLY2_CDNS_40661956134136
* cell instance $7 r0 *1 58.245,19.345
X$7 1 16 M2_M1_CDNS_40661956134141
* cell instance $8 m90 *1 58.165,19.345
X$8 1 M1_POLY2_CDNS_40661956134136
* cell instance $9 r0 *1 58.245,78.065
X$9 1 16 M2_M1_CDNS_40661956134141
* cell instance $10 m90 *1 58.165,78.065
X$10 1 M1_POLY2_CDNS_40661956134136
* cell instance $11 r0 *1 58.245,107.425
X$11 1 16 M2_M1_CDNS_40661956134141
* cell instance $12 m90 *1 58.165,107.425
X$12 1 M1_POLY2_CDNS_40661956134136
* cell instance $13 r0 *1 6.645,19.345
X$13 1 M1_POLY2_CDNS_40661956134136
* cell instance $14 r0 *1 6.565,19.345
X$14 1 7 M2_M1_CDNS_40661956134141
* cell instance $15 r0 *1 6.645,78.065
X$15 1 M1_POLY2_CDNS_40661956134136
* cell instance $16 r0 *1 6.565,78.065
X$16 1 7 M2_M1_CDNS_40661956134141
* cell instance $17 r0 *1 6.645,107.425
X$17 1 M1_POLY2_CDNS_40661956134136
* cell instance $18 r0 *1 6.565,107.425
X$18 1 7 M2_M1_CDNS_40661956134141
* cell instance $19 r0 *1 6.645,48.705
X$19 1 M1_POLY2_CDNS_40661956134136
* cell instance $20 r0 *1 6.565,48.705
X$20 1 7 M2_M1_CDNS_40661956134141
* cell instance $21 r0 *1 32.405,125.635
X$21 3 20 3 2 M1_NWELL_CDNS_40661956134139
* cell instance $22 r0 *1 32.405,1.135
X$22 3 20 3 2 M1_NWELL_CDNS_40661956134139
* cell instance $23 r0 *1 63.675,63.385
X$23 3 2 3 20 M1_NWELL_CDNS_40661956134135
* cell instance $24 r0 *1 1.135,63.385
X$24 3 2 3 20 M1_NWELL_CDNS_40661956134135
* cell instance $25 r0 *1 13.79,107.425
X$25 3 14 M2_M1_CDNS_40661956134249
* cell instance $26 r0 *1 25.64,107.425
X$26 3 13 M2_M1_CDNS_40661956134249
* cell instance $27 m90 *1 39.17,107.425
X$27 3 11 M2_M1_CDNS_40661956134249
* cell instance $28 m90 *1 51.02,107.425
X$28 3 9 M2_M1_CDNS_40661956134249
* cell instance $29 r0 *1 13.79,109.865
X$29 3 14 M2_M1_CDNS_40661956134249
* cell instance $30 r0 *1 25.64,109.865
X$30 3 13 M2_M1_CDNS_40661956134249
* cell instance $31 m90 *1 39.17,109.865
X$31 3 11 M2_M1_CDNS_40661956134249
* cell instance $32 m90 *1 51.02,109.865
X$32 3 9 M2_M1_CDNS_40661956134249
* cell instance $33 r0 *1 13.79,21.785
X$33 3 14 M2_M1_CDNS_40661956134249
* cell instance $34 r0 *1 25.64,21.785
X$34 3 13 M2_M1_CDNS_40661956134249
* cell instance $35 m90 *1 39.17,21.785
X$35 3 11 M2_M1_CDNS_40661956134249
* cell instance $36 m90 *1 51.02,21.785
X$36 3 9 M2_M1_CDNS_40661956134249
* cell instance $37 r0 *1 13.79,97.665
X$37 3 14 M2_M1_CDNS_40661956134249
* cell instance $38 r0 *1 25.64,97.665
X$38 3 13 M2_M1_CDNS_40661956134249
* cell instance $39 m90 *1 39.17,97.665
X$39 3 11 M2_M1_CDNS_40661956134249
* cell instance $40 m90 *1 51.02,97.665
X$40 3 9 M2_M1_CDNS_40661956134249
* cell instance $41 r0 *1 13.79,114.745
X$41 3 14 M2_M1_CDNS_40661956134249
* cell instance $42 r0 *1 25.64,114.745
X$42 3 13 M2_M1_CDNS_40661956134249
* cell instance $43 m90 *1 39.17,114.745
X$43 3 11 M2_M1_CDNS_40661956134249
* cell instance $44 m90 *1 51.02,114.745
X$44 3 9 M2_M1_CDNS_40661956134249
* cell instance $45 r0 *1 13.79,9.585
X$45 3 14 M2_M1_CDNS_40661956134249
* cell instance $46 r0 *1 25.64,9.585
X$46 3 13 M2_M1_CDNS_40661956134249
* cell instance $47 m90 *1 39.17,9.585
X$47 3 11 M2_M1_CDNS_40661956134249
* cell instance $48 m90 *1 51.02,9.585
X$48 3 9 M2_M1_CDNS_40661956134249
* cell instance $49 r0 *1 13.79,12.025
X$49 3 14 M2_M1_CDNS_40661956134249
* cell instance $50 r0 *1 25.64,12.025
X$50 3 13 M2_M1_CDNS_40661956134249
* cell instance $51 m90 *1 39.17,12.025
X$51 3 11 M2_M1_CDNS_40661956134249
* cell instance $52 m90 *1 51.02,12.025
X$52 3 9 M2_M1_CDNS_40661956134249
* cell instance $53 r0 *1 13.79,14.465
X$53 3 14 M2_M1_CDNS_40661956134249
* cell instance $54 r0 *1 25.64,14.465
X$54 3 13 M2_M1_CDNS_40661956134249
* cell instance $55 m90 *1 39.17,14.465
X$55 3 11 M2_M1_CDNS_40661956134249
* cell instance $56 m90 *1 51.02,14.465
X$56 3 9 M2_M1_CDNS_40661956134249
* cell instance $57 r0 *1 13.79,16.905
X$57 3 14 M2_M1_CDNS_40661956134249
* cell instance $58 r0 *1 25.64,16.905
X$58 3 13 M2_M1_CDNS_40661956134249
* cell instance $59 m90 *1 39.17,16.905
X$59 3 11 M2_M1_CDNS_40661956134249
* cell instance $60 m90 *1 51.02,16.905
X$60 3 9 M2_M1_CDNS_40661956134249
* cell instance $61 r0 *1 13.79,19.345
X$61 3 14 M2_M1_CDNS_40661956134249
* cell instance $62 r0 *1 25.64,19.345
X$62 3 13 M2_M1_CDNS_40661956134249
* cell instance $63 m90 *1 39.17,19.345
X$63 3 11 M2_M1_CDNS_40661956134249
* cell instance $64 m90 *1 51.02,19.345
X$64 3 9 M2_M1_CDNS_40661956134249
* cell instance $65 r0 *1 13.79,112.305
X$65 3 14 M2_M1_CDNS_40661956134249
* cell instance $66 r0 *1 25.64,112.305
X$66 3 13 M2_M1_CDNS_40661956134249
* cell instance $67 m90 *1 39.17,112.305
X$67 3 11 M2_M1_CDNS_40661956134249
* cell instance $68 m90 *1 51.02,112.305
X$68 3 9 M2_M1_CDNS_40661956134249
* cell instance $69 r0 *1 13.79,95.225
X$69 3 14 M2_M1_CDNS_40661956134249
* cell instance $70 r0 *1 25.64,95.225
X$70 3 13 M2_M1_CDNS_40661956134249
* cell instance $71 m90 *1 39.17,95.225
X$71 3 11 M2_M1_CDNS_40661956134249
* cell instance $72 m90 *1 51.02,95.225
X$72 3 9 M2_M1_CDNS_40661956134249
* cell instance $73 r0 *1 13.79,90.265
X$73 3 14 M2_M1_CDNS_40661956134249
* cell instance $74 r0 *1 25.64,90.265
X$74 3 13 M2_M1_CDNS_40661956134249
* cell instance $75 m90 *1 39.17,90.265
X$75 3 11 M2_M1_CDNS_40661956134249
* cell instance $76 m90 *1 51.02,90.265
X$76 3 9 M2_M1_CDNS_40661956134249
* cell instance $77 r0 *1 13.79,87.825
X$77 3 14 M2_M1_CDNS_40661956134249
* cell instance $78 r0 *1 25.64,87.825
X$78 3 13 M2_M1_CDNS_40661956134249
* cell instance $79 m90 *1 39.17,87.825
X$79 3 11 M2_M1_CDNS_40661956134249
* cell instance $80 m90 *1 51.02,87.825
X$80 3 9 M2_M1_CDNS_40661956134249
* cell instance $81 r0 *1 13.79,85.385
X$81 3 14 M2_M1_CDNS_40661956134249
* cell instance $82 r0 *1 25.64,85.385
X$82 3 13 M2_M1_CDNS_40661956134249
* cell instance $83 m90 *1 39.17,85.385
X$83 3 11 M2_M1_CDNS_40661956134249
* cell instance $84 m90 *1 51.02,85.385
X$84 3 9 M2_M1_CDNS_40661956134249
* cell instance $85 r0 *1 13.79,82.945
X$85 3 14 M2_M1_CDNS_40661956134249
* cell instance $86 r0 *1 25.64,82.945
X$86 3 13 M2_M1_CDNS_40661956134249
* cell instance $87 m90 *1 39.17,82.945
X$87 3 11 M2_M1_CDNS_40661956134249
* cell instance $88 m90 *1 51.02,82.945
X$88 3 9 M2_M1_CDNS_40661956134249
* cell instance $89 r0 *1 13.79,80.505
X$89 3 14 M2_M1_CDNS_40661956134249
* cell instance $90 r0 *1 25.64,80.505
X$90 3 13 M2_M1_CDNS_40661956134249
* cell instance $91 m90 *1 39.17,80.505
X$91 3 11 M2_M1_CDNS_40661956134249
* cell instance $92 m90 *1 51.02,80.505
X$92 3 9 M2_M1_CDNS_40661956134249
* cell instance $93 r0 *1 13.79,78.065
X$93 3 14 M2_M1_CDNS_40661956134249
* cell instance $94 r0 *1 25.64,78.065
X$94 3 13 M2_M1_CDNS_40661956134249
* cell instance $95 m90 *1 39.17,78.065
X$95 3 11 M2_M1_CDNS_40661956134249
* cell instance $96 m90 *1 51.02,78.065
X$96 3 9 M2_M1_CDNS_40661956134249
* cell instance $97 r0 *1 13.79,102.545
X$97 3 14 M2_M1_CDNS_40661956134249
* cell instance $98 r0 *1 25.64,102.545
X$98 3 13 M2_M1_CDNS_40661956134249
* cell instance $99 m90 *1 39.17,102.545
X$99 3 11 M2_M1_CDNS_40661956134249
* cell instance $100 m90 *1 51.02,102.545
X$100 3 9 M2_M1_CDNS_40661956134249
* cell instance $101 r0 *1 13.79,104.985
X$101 3 14 M2_M1_CDNS_40661956134249
* cell instance $102 r0 *1 25.64,104.985
X$102 3 13 M2_M1_CDNS_40661956134249
* cell instance $103 m90 *1 39.17,104.985
X$103 3 11 M2_M1_CDNS_40661956134249
* cell instance $104 m90 *1 51.02,104.985
X$104 3 9 M2_M1_CDNS_40661956134249
* cell instance $105 r0 *1 13.79,73.185
X$105 3 14 M2_M1_CDNS_40661956134249
* cell instance $106 r0 *1 25.64,73.185
X$106 3 13 M2_M1_CDNS_40661956134249
* cell instance $107 m90 *1 39.17,73.185
X$107 3 11 M2_M1_CDNS_40661956134249
* cell instance $108 m90 *1 51.02,73.185
X$108 3 9 M2_M1_CDNS_40661956134249
* cell instance $109 r0 *1 13.79,75.625
X$109 3 14 M2_M1_CDNS_40661956134249
* cell instance $110 r0 *1 25.64,75.625
X$110 3 13 M2_M1_CDNS_40661956134249
* cell instance $111 m90 *1 39.17,75.625
X$111 3 11 M2_M1_CDNS_40661956134249
* cell instance $112 m90 *1 51.02,75.625
X$112 3 9 M2_M1_CDNS_40661956134249
* cell instance $113 r0 *1 13.79,119.625
X$113 3 14 M2_M1_CDNS_40661956134249
* cell instance $114 r0 *1 25.64,119.625
X$114 3 13 M2_M1_CDNS_40661956134249
* cell instance $115 m90 *1 39.17,119.625
X$115 3 11 M2_M1_CDNS_40661956134249
* cell instance $116 m90 *1 51.02,119.625
X$116 3 9 M2_M1_CDNS_40661956134249
* cell instance $117 r0 *1 13.79,117.185
X$117 3 14 M2_M1_CDNS_40661956134249
* cell instance $118 r0 *1 25.64,117.185
X$118 3 13 M2_M1_CDNS_40661956134249
* cell instance $119 m90 *1 39.17,117.185
X$119 3 11 M2_M1_CDNS_40661956134249
* cell instance $120 m90 *1 51.02,117.185
X$120 3 9 M2_M1_CDNS_40661956134249
* cell instance $121 r0 *1 13.79,65.865
X$121 3 14 M2_M1_CDNS_40661956134249
* cell instance $122 r0 *1 25.64,65.865
X$122 3 13 M2_M1_CDNS_40661956134249
* cell instance $123 m90 *1 39.17,65.865
X$123 3 11 M2_M1_CDNS_40661956134249
* cell instance $124 m90 *1 51.02,65.865
X$124 3 9 M2_M1_CDNS_40661956134249
* cell instance $125 r0 *1 13.79,68.305
X$125 3 14 M2_M1_CDNS_40661956134249
* cell instance $126 r0 *1 25.64,68.305
X$126 3 13 M2_M1_CDNS_40661956134249
* cell instance $127 m90 *1 39.17,68.305
X$127 3 11 M2_M1_CDNS_40661956134249
* cell instance $128 m90 *1 51.02,68.305
X$128 3 9 M2_M1_CDNS_40661956134249
* cell instance $129 r0 *1 13.79,70.745
X$129 3 14 M2_M1_CDNS_40661956134249
* cell instance $130 r0 *1 25.64,70.745
X$130 3 13 M2_M1_CDNS_40661956134249
* cell instance $131 m90 *1 39.17,70.745
X$131 3 11 M2_M1_CDNS_40661956134249
* cell instance $132 m90 *1 51.02,70.745
X$132 3 9 M2_M1_CDNS_40661956134249
* cell instance $133 r0 *1 13.79,31.545
X$133 3 14 M2_M1_CDNS_40661956134249
* cell instance $134 r0 *1 25.64,31.545
X$134 3 13 M2_M1_CDNS_40661956134249
* cell instance $135 m90 *1 39.17,31.545
X$135 3 11 M2_M1_CDNS_40661956134249
* cell instance $136 m90 *1 51.02,31.545
X$136 3 9 M2_M1_CDNS_40661956134249
* cell instance $137 r0 *1 13.79,58.465
X$137 3 14 M2_M1_CDNS_40661956134249
* cell instance $138 r0 *1 25.64,58.465
X$138 3 13 M2_M1_CDNS_40661956134249
* cell instance $139 m90 *1 39.17,58.465
X$139 3 11 M2_M1_CDNS_40661956134249
* cell instance $140 m90 *1 51.02,58.465
X$140 3 9 M2_M1_CDNS_40661956134249
* cell instance $141 r0 *1 13.79,56.025
X$141 3 14 M2_M1_CDNS_40661956134249
* cell instance $142 r0 *1 25.64,56.025
X$142 3 13 M2_M1_CDNS_40661956134249
* cell instance $143 m90 *1 39.17,56.025
X$143 3 11 M2_M1_CDNS_40661956134249
* cell instance $144 m90 *1 51.02,56.025
X$144 3 9 M2_M1_CDNS_40661956134249
* cell instance $145 r0 *1 13.79,53.585
X$145 3 14 M2_M1_CDNS_40661956134249
* cell instance $146 r0 *1 25.64,53.585
X$146 3 13 M2_M1_CDNS_40661956134249
* cell instance $147 m90 *1 39.17,53.585
X$147 3 11 M2_M1_CDNS_40661956134249
* cell instance $148 m90 *1 51.02,53.585
X$148 3 9 M2_M1_CDNS_40661956134249
* cell instance $149 r0 *1 13.79,51.145
X$149 3 14 M2_M1_CDNS_40661956134249
* cell instance $150 r0 *1 25.64,51.145
X$150 3 13 M2_M1_CDNS_40661956134249
* cell instance $151 m90 *1 39.17,51.145
X$151 3 11 M2_M1_CDNS_40661956134249
* cell instance $152 m90 *1 51.02,51.145
X$152 3 9 M2_M1_CDNS_40661956134249
* cell instance $153 r0 *1 13.79,48.705
X$153 3 14 M2_M1_CDNS_40661956134249
* cell instance $154 r0 *1 25.64,48.705
X$154 3 13 M2_M1_CDNS_40661956134249
* cell instance $155 m90 *1 39.17,48.705
X$155 3 11 M2_M1_CDNS_40661956134249
* cell instance $156 m90 *1 51.02,48.705
X$156 3 9 M2_M1_CDNS_40661956134249
* cell instance $157 r0 *1 13.79,46.265
X$157 3 14 M2_M1_CDNS_40661956134249
* cell instance $158 r0 *1 25.64,46.265
X$158 3 13 M2_M1_CDNS_40661956134249
* cell instance $159 m90 *1 39.17,46.265
X$159 3 11 M2_M1_CDNS_40661956134249
* cell instance $160 m90 *1 51.02,46.265
X$160 3 9 M2_M1_CDNS_40661956134249
* cell instance $161 r0 *1 13.79,26.665
X$161 3 14 M2_M1_CDNS_40661956134249
* cell instance $162 r0 *1 25.64,26.665
X$162 3 13 M2_M1_CDNS_40661956134249
* cell instance $163 m90 *1 39.17,26.665
X$163 3 11 M2_M1_CDNS_40661956134249
* cell instance $164 m90 *1 51.02,26.665
X$164 3 9 M2_M1_CDNS_40661956134249
* cell instance $165 r0 *1 13.79,29.105
X$165 3 14 M2_M1_CDNS_40661956134249
* cell instance $166 r0 *1 25.64,29.105
X$166 3 13 M2_M1_CDNS_40661956134249
* cell instance $167 m90 *1 39.17,29.105
X$167 3 11 M2_M1_CDNS_40661956134249
* cell instance $168 m90 *1 51.02,29.105
X$168 3 9 M2_M1_CDNS_40661956134249
* cell instance $169 r0 *1 13.79,41.385
X$169 3 14 M2_M1_CDNS_40661956134249
* cell instance $170 r0 *1 25.64,41.385
X$170 3 13 M2_M1_CDNS_40661956134249
* cell instance $171 m90 *1 39.17,41.385
X$171 3 11 M2_M1_CDNS_40661956134249
* cell instance $172 m90 *1 51.02,41.385
X$172 3 9 M2_M1_CDNS_40661956134249
* cell instance $173 r0 *1 13.79,38.945
X$173 3 14 M2_M1_CDNS_40661956134249
* cell instance $174 r0 *1 25.64,38.945
X$174 3 13 M2_M1_CDNS_40661956134249
* cell instance $175 m90 *1 39.17,38.945
X$175 3 11 M2_M1_CDNS_40661956134249
* cell instance $176 m90 *1 51.02,38.945
X$176 3 9 M2_M1_CDNS_40661956134249
* cell instance $177 r0 *1 13.79,36.505
X$177 3 14 M2_M1_CDNS_40661956134249
* cell instance $178 r0 *1 25.64,36.505
X$178 3 13 M2_M1_CDNS_40661956134249
* cell instance $179 m90 *1 39.17,36.505
X$179 3 11 M2_M1_CDNS_40661956134249
* cell instance $180 m90 *1 51.02,36.505
X$180 3 9 M2_M1_CDNS_40661956134249
* cell instance $181 r0 *1 13.79,24.225
X$181 3 14 M2_M1_CDNS_40661956134249
* cell instance $182 r0 *1 25.64,24.225
X$182 3 13 M2_M1_CDNS_40661956134249
* cell instance $183 m90 *1 39.17,24.225
X$183 3 11 M2_M1_CDNS_40661956134249
* cell instance $184 m90 *1 51.02,24.225
X$184 3 9 M2_M1_CDNS_40661956134249
* cell instance $185 r0 *1 13.79,43.825
X$185 3 14 M2_M1_CDNS_40661956134249
* cell instance $186 r0 *1 25.64,43.825
X$186 3 13 M2_M1_CDNS_40661956134249
* cell instance $187 m90 *1 39.17,43.825
X$187 3 11 M2_M1_CDNS_40661956134249
* cell instance $188 m90 *1 51.02,43.825
X$188 3 9 M2_M1_CDNS_40661956134249
* cell instance $189 r0 *1 13.79,100.105
X$189 3 14 M2_M1_CDNS_40661956134249
* cell instance $190 r0 *1 25.64,100.105
X$190 3 13 M2_M1_CDNS_40661956134249
* cell instance $191 m90 *1 39.17,100.105
X$191 3 11 M2_M1_CDNS_40661956134249
* cell instance $192 m90 *1 51.02,100.105
X$192 3 9 M2_M1_CDNS_40661956134249
* cell instance $193 r0 *1 13.79,60.905
X$193 3 14 M2_M1_CDNS_40661956134249
* cell instance $194 r0 *1 25.64,60.905
X$194 3 13 M2_M1_CDNS_40661956134249
* cell instance $195 m90 *1 39.17,60.905
X$195 3 11 M2_M1_CDNS_40661956134249
* cell instance $196 m90 *1 51.02,60.905
X$196 3 9 M2_M1_CDNS_40661956134249
* cell instance $197 r0 *1 3.97,125.635
X$197 3 6 M2_M1_CDNS_40661956134248
* cell instance $198 r0 *1 13.79,125.635
X$198 3 14 M2_M1_CDNS_40661956134247
* cell instance $199 r0 *1 25.64,125.635
X$199 3 13 M2_M1_CDNS_40661956134247
* cell instance $200 m90 *1 39.17,125.635
X$200 3 11 M2_M1_CDNS_40661956134247
* cell instance $201 m90 *1 51.02,125.635
X$201 3 9 M2_M1_CDNS_40661956134247
* cell instance $202 r0 *1 60.84,125.635
X$202 3 18 M2_M1_CDNS_40661956134248
* cell instance $203 r0 *1 63.675,63.385
X$203 3 18 M2_M1_CDNS_40661956134246
* cell instance $204 r0 *1 13.79,7.145
X$204 3 14 M2_M1_CDNS_40661956134249
* cell instance $205 r0 *1 25.64,7.145
X$205 3 13 M2_M1_CDNS_40661956134249
* cell instance $206 m90 *1 39.17,7.145
X$206 3 11 M2_M1_CDNS_40661956134249
* cell instance $207 m90 *1 51.02,7.145
X$207 3 9 M2_M1_CDNS_40661956134249
* cell instance $208 r0 *1 3.97,1.135
X$208 3 6 M2_M1_CDNS_40661956134248
* cell instance $209 r0 *1 13.79,1.135
X$209 3 14 M2_M1_CDNS_40661956134247
* cell instance $210 r0 *1 25.64,1.135
X$210 3 13 M2_M1_CDNS_40661956134247
* cell instance $211 m90 *1 39.17,1.135
X$211 3 11 M2_M1_CDNS_40661956134247
* cell instance $212 m90 *1 51.02,1.135
X$212 3 9 M2_M1_CDNS_40661956134247
* cell instance $213 r0 *1 60.84,1.135
X$213 3 18 M2_M1_CDNS_40661956134248
* cell instance $214 r0 *1 1.135,63.385
X$214 3 6 M2_M1_CDNS_40661956134246
* cell instance $215 r0 *1 32.405,34.025
X$215 5 4 M1_PSUB_CDNS_40661956134134
* cell instance $216 r0 *1 32.405,63.385
X$216 5 4 M1_PSUB_CDNS_40661956134134
* cell instance $217 r0 *1 32.405,92.745
X$217 5 4 M1_PSUB_CDNS_40661956134134
* cell instance $218 r0 *1 32.405,4.135
X$218 5 4 M1_PSUB_CDNS_40661956134138
* cell instance $219 r0 *1 32.405,122.635
X$219 5 4 M1_PSUB_CDNS_40661956134138
* cell instance $220 r0 *1 3.885,63.385
X$220 5 4 M1_PSUB_CDNS_40661956134137
* cell instance $221 r0 *1 60.925,63.385
X$221 5 4 M1_PSUB_CDNS_40661956134137
* cell instance $222 r0 *1 7.865,63.385
X$222 5 8 M2_M1_CDNS_40661956134126
* cell instance $223 m90 *1 19.715,63.385
X$223 5 15 M2_M1_CDNS_40661956134126
* cell instance $224 r0 *1 32.405,63.385
X$224 5 12 M2_M1_CDNS_40661956134250
* cell instance $225 m90 *1 45.095,63.385
X$225 5 10 M2_M1_CDNS_40661956134126
* cell instance $226 m90 *1 56.945,63.385
X$226 5 17 M2_M1_CDNS_40661956134126
* cell instance $227 r0 *1 7.865,92.745
X$227 5 8 M2_M1_CDNS_40661956134126
* cell instance $228 m90 *1 19.715,92.745
X$228 5 15 M2_M1_CDNS_40661956134126
* cell instance $229 r0 *1 32.405,92.745
X$229 5 12 M2_M1_CDNS_40661956134250
* cell instance $230 m90 *1 45.095,92.745
X$230 5 10 M2_M1_CDNS_40661956134126
* cell instance $231 m90 *1 56.945,92.745
X$231 5 17 M2_M1_CDNS_40661956134126
* cell instance $232 r0 *1 7.865,115.965
X$232 5 8 M2_M1_CDNS_40661956134218
* cell instance $233 m90 *1 19.715,115.965
X$233 5 15 M2_M1_CDNS_40661956134218
* cell instance $234 r0 *1 32.405,115.965
X$234 5 12 M2_M1_CDNS_40661956134217
* cell instance $235 m90 *1 45.095,115.965
X$235 5 10 M2_M1_CDNS_40661956134218
* cell instance $236 m90 *1 56.945,115.965
X$236 5 17 M2_M1_CDNS_40661956134218
* cell instance $237 r0 *1 7.865,74.405
X$237 5 8 M2_M1_CDNS_40661956134218
* cell instance $238 m90 *1 19.715,74.405
X$238 5 15 M2_M1_CDNS_40661956134218
* cell instance $239 r0 *1 32.405,74.405
X$239 5 12 M2_M1_CDNS_40661956134217
* cell instance $240 m90 *1 45.095,74.405
X$240 5 10 M2_M1_CDNS_40661956134218
* cell instance $241 m90 *1 56.945,74.405
X$241 5 17 M2_M1_CDNS_40661956134218
* cell instance $242 r0 *1 7.865,118.405
X$242 5 8 M2_M1_CDNS_40661956134218
* cell instance $243 m90 *1 19.715,118.405
X$243 5 15 M2_M1_CDNS_40661956134218
* cell instance $244 r0 *1 32.405,118.405
X$244 5 12 M2_M1_CDNS_40661956134217
* cell instance $245 m90 *1 45.095,118.405
X$245 5 10 M2_M1_CDNS_40661956134218
* cell instance $246 m90 *1 56.945,118.405
X$246 5 17 M2_M1_CDNS_40661956134218
* cell instance $247 r0 *1 7.865,111.085
X$247 5 8 M2_M1_CDNS_40661956134218
* cell instance $248 m90 *1 19.715,111.085
X$248 5 15 M2_M1_CDNS_40661956134218
* cell instance $249 r0 *1 32.405,111.085
X$249 5 12 M2_M1_CDNS_40661956134217
* cell instance $250 m90 *1 45.095,111.085
X$250 5 10 M2_M1_CDNS_40661956134218
* cell instance $251 m90 *1 56.945,111.085
X$251 5 17 M2_M1_CDNS_40661956134218
* cell instance $252 r0 *1 7.865,101.325
X$252 5 8 M2_M1_CDNS_40661956134218
* cell instance $253 m90 *1 19.715,101.325
X$253 5 15 M2_M1_CDNS_40661956134218
* cell instance $254 r0 *1 32.405,101.325
X$254 5 12 M2_M1_CDNS_40661956134217
* cell instance $255 m90 *1 45.095,101.325
X$255 5 10 M2_M1_CDNS_40661956134218
* cell instance $256 m90 *1 56.945,101.325
X$256 5 17 M2_M1_CDNS_40661956134218
* cell instance $257 r0 *1 7.865,30.325
X$257 5 8 M2_M1_CDNS_40661956134218
* cell instance $258 m90 *1 19.715,30.325
X$258 5 15 M2_M1_CDNS_40661956134218
* cell instance $259 r0 *1 32.405,30.325
X$259 5 12 M2_M1_CDNS_40661956134217
* cell instance $260 m90 *1 45.095,30.325
X$260 5 10 M2_M1_CDNS_40661956134218
* cell instance $261 m90 *1 56.945,30.325
X$261 5 17 M2_M1_CDNS_40661956134218
* cell instance $262 r0 *1 7.865,10.805
X$262 5 8 M2_M1_CDNS_40661956134218
* cell instance $263 m90 *1 19.715,10.805
X$263 5 15 M2_M1_CDNS_40661956134218
* cell instance $264 r0 *1 32.405,10.805
X$264 5 12 M2_M1_CDNS_40661956134217
* cell instance $265 m90 *1 45.095,10.805
X$265 5 10 M2_M1_CDNS_40661956134218
* cell instance $266 m90 *1 56.945,10.805
X$266 5 17 M2_M1_CDNS_40661956134218
* cell instance $267 r0 *1 7.865,20.565
X$267 5 8 M2_M1_CDNS_40661956134218
* cell instance $268 m90 *1 19.715,20.565
X$268 5 15 M2_M1_CDNS_40661956134218
* cell instance $269 r0 *1 32.405,20.565
X$269 5 12 M2_M1_CDNS_40661956134217
* cell instance $270 m90 *1 45.095,20.565
X$270 5 10 M2_M1_CDNS_40661956134218
* cell instance $271 m90 *1 56.945,20.565
X$271 5 17 M2_M1_CDNS_40661956134218
* cell instance $272 r0 *1 7.865,84.165
X$272 5 8 M2_M1_CDNS_40661956134218
* cell instance $273 m90 *1 19.715,84.165
X$273 5 15 M2_M1_CDNS_40661956134218
* cell instance $274 r0 *1 32.405,84.165
X$274 5 12 M2_M1_CDNS_40661956134217
* cell instance $275 m90 *1 45.095,84.165
X$275 5 10 M2_M1_CDNS_40661956134218
* cell instance $276 m90 *1 56.945,84.165
X$276 5 17 M2_M1_CDNS_40661956134218
* cell instance $277 r0 *1 7.865,37.725
X$277 5 8 M2_M1_CDNS_40661956134218
* cell instance $278 m90 *1 19.715,37.725
X$278 5 15 M2_M1_CDNS_40661956134218
* cell instance $279 r0 *1 32.405,37.725
X$279 5 12 M2_M1_CDNS_40661956134217
* cell instance $280 m90 *1 45.095,37.725
X$280 5 10 M2_M1_CDNS_40661956134218
* cell instance $281 m90 *1 56.945,37.725
X$281 5 17 M2_M1_CDNS_40661956134218
* cell instance $282 r0 *1 7.865,57.245
X$282 5 8 M2_M1_CDNS_40661956134218
* cell instance $283 m90 *1 19.715,57.245
X$283 5 15 M2_M1_CDNS_40661956134218
* cell instance $284 r0 *1 32.405,57.245
X$284 5 12 M2_M1_CDNS_40661956134217
* cell instance $285 m90 *1 45.095,57.245
X$285 5 10 M2_M1_CDNS_40661956134218
* cell instance $286 m90 *1 56.945,57.245
X$286 5 17 M2_M1_CDNS_40661956134218
* cell instance $287 r0 *1 7.865,54.805
X$287 5 8 M2_M1_CDNS_40661956134218
* cell instance $288 m90 *1 19.715,54.805
X$288 5 15 M2_M1_CDNS_40661956134218
* cell instance $289 r0 *1 32.405,54.805
X$289 5 12 M2_M1_CDNS_40661956134217
* cell instance $290 m90 *1 45.095,54.805
X$290 5 10 M2_M1_CDNS_40661956134218
* cell instance $291 m90 *1 56.945,54.805
X$291 5 17 M2_M1_CDNS_40661956134218
* cell instance $292 r0 *1 7.865,13.245
X$292 5 8 M2_M1_CDNS_40661956134218
* cell instance $293 m90 *1 19.715,13.245
X$293 5 15 M2_M1_CDNS_40661956134218
* cell instance $294 r0 *1 32.405,13.245
X$294 5 12 M2_M1_CDNS_40661956134217
* cell instance $295 m90 *1 45.095,13.245
X$295 5 10 M2_M1_CDNS_40661956134218
* cell instance $296 m90 *1 56.945,13.245
X$296 5 17 M2_M1_CDNS_40661956134218
* cell instance $297 r0 *1 7.865,45.045
X$297 5 8 M2_M1_CDNS_40661956134218
* cell instance $298 m90 *1 19.715,45.045
X$298 5 15 M2_M1_CDNS_40661956134218
* cell instance $299 r0 *1 32.405,45.045
X$299 5 12 M2_M1_CDNS_40661956134217
* cell instance $300 m90 *1 45.095,45.045
X$300 5 10 M2_M1_CDNS_40661956134218
* cell instance $301 m90 *1 56.945,45.045
X$301 5 17 M2_M1_CDNS_40661956134218
* cell instance $302 r0 *1 7.865,23.005
X$302 5 8 M2_M1_CDNS_40661956134218
* cell instance $303 m90 *1 19.715,23.005
X$303 5 15 M2_M1_CDNS_40661956134218
* cell instance $304 r0 *1 32.405,23.005
X$304 5 12 M2_M1_CDNS_40661956134217
* cell instance $305 m90 *1 45.095,23.005
X$305 5 10 M2_M1_CDNS_40661956134218
* cell instance $306 m90 *1 56.945,23.005
X$306 5 17 M2_M1_CDNS_40661956134218
* cell instance $307 r0 *1 7.865,18.125
X$307 5 8 M2_M1_CDNS_40661956134218
* cell instance $308 m90 *1 19.715,18.125
X$308 5 15 M2_M1_CDNS_40661956134218
* cell instance $309 r0 *1 32.405,18.125
X$309 5 12 M2_M1_CDNS_40661956134217
* cell instance $310 m90 *1 45.095,18.125
X$310 5 10 M2_M1_CDNS_40661956134218
* cell instance $311 m90 *1 56.945,18.125
X$311 5 17 M2_M1_CDNS_40661956134218
* cell instance $312 r0 *1 7.865,49.925
X$312 5 8 M2_M1_CDNS_40661956134218
* cell instance $313 m90 *1 19.715,49.925
X$313 5 15 M2_M1_CDNS_40661956134218
* cell instance $314 r0 *1 32.405,49.925
X$314 5 12 M2_M1_CDNS_40661956134217
* cell instance $315 m90 *1 45.095,49.925
X$315 5 10 M2_M1_CDNS_40661956134218
* cell instance $316 m90 *1 56.945,49.925
X$316 5 17 M2_M1_CDNS_40661956134218
* cell instance $317 r0 *1 7.865,42.605
X$317 5 8 M2_M1_CDNS_40661956134218
* cell instance $318 m90 *1 19.715,42.605
X$318 5 15 M2_M1_CDNS_40661956134218
* cell instance $319 r0 *1 32.405,42.605
X$319 5 12 M2_M1_CDNS_40661956134217
* cell instance $320 m90 *1 45.095,42.605
X$320 5 10 M2_M1_CDNS_40661956134218
* cell instance $321 m90 *1 56.945,42.605
X$321 5 17 M2_M1_CDNS_40661956134218
* cell instance $322 r0 *1 7.865,47.485
X$322 5 8 M2_M1_CDNS_40661956134218
* cell instance $323 m90 *1 19.715,47.485
X$323 5 15 M2_M1_CDNS_40661956134218
* cell instance $324 r0 *1 32.405,47.485
X$324 5 12 M2_M1_CDNS_40661956134217
* cell instance $325 m90 *1 45.095,47.485
X$325 5 10 M2_M1_CDNS_40661956134218
* cell instance $326 m90 *1 56.945,47.485
X$326 5 17 M2_M1_CDNS_40661956134218
* cell instance $327 r0 *1 7.865,89.045
X$327 5 8 M2_M1_CDNS_40661956134218
* cell instance $328 m90 *1 19.715,89.045
X$328 5 15 M2_M1_CDNS_40661956134218
* cell instance $329 r0 *1 32.405,89.045
X$329 5 12 M2_M1_CDNS_40661956134217
* cell instance $330 m90 *1 45.095,89.045
X$330 5 10 M2_M1_CDNS_40661956134218
* cell instance $331 m90 *1 56.945,89.045
X$331 5 17 M2_M1_CDNS_40661956134218
* cell instance $332 r0 *1 7.865,40.165
X$332 5 8 M2_M1_CDNS_40661956134218
* cell instance $333 m90 *1 19.715,40.165
X$333 5 15 M2_M1_CDNS_40661956134218
* cell instance $334 r0 *1 32.405,40.165
X$334 5 12 M2_M1_CDNS_40661956134217
* cell instance $335 m90 *1 45.095,40.165
X$335 5 10 M2_M1_CDNS_40661956134218
* cell instance $336 m90 *1 56.945,40.165
X$336 5 17 M2_M1_CDNS_40661956134218
* cell instance $337 r0 *1 7.865,52.365
X$337 5 8 M2_M1_CDNS_40661956134218
* cell instance $338 m90 *1 19.715,52.365
X$338 5 15 M2_M1_CDNS_40661956134218
* cell instance $339 r0 *1 32.405,52.365
X$339 5 12 M2_M1_CDNS_40661956134217
* cell instance $340 m90 *1 45.095,52.365
X$340 5 10 M2_M1_CDNS_40661956134218
* cell instance $341 m90 *1 56.945,52.365
X$341 5 17 M2_M1_CDNS_40661956134218
* cell instance $342 r0 *1 7.865,27.885
X$342 5 8 M2_M1_CDNS_40661956134218
* cell instance $343 m90 *1 19.715,27.885
X$343 5 15 M2_M1_CDNS_40661956134218
* cell instance $344 r0 *1 32.405,27.885
X$344 5 12 M2_M1_CDNS_40661956134217
* cell instance $345 m90 *1 45.095,27.885
X$345 5 10 M2_M1_CDNS_40661956134218
* cell instance $346 m90 *1 56.945,27.885
X$346 5 17 M2_M1_CDNS_40661956134218
* cell instance $347 r0 *1 7.865,69.525
X$347 5 8 M2_M1_CDNS_40661956134218
* cell instance $348 m90 *1 19.715,69.525
X$348 5 15 M2_M1_CDNS_40661956134218
* cell instance $349 r0 *1 32.405,69.525
X$349 5 12 M2_M1_CDNS_40661956134217
* cell instance $350 m90 *1 45.095,69.525
X$350 5 10 M2_M1_CDNS_40661956134218
* cell instance $351 m90 *1 56.945,69.525
X$351 5 17 M2_M1_CDNS_40661956134218
* cell instance $352 r0 *1 7.865,103.765
X$352 5 8 M2_M1_CDNS_40661956134218
* cell instance $353 m90 *1 19.715,103.765
X$353 5 15 M2_M1_CDNS_40661956134218
* cell instance $354 r0 *1 32.405,103.765
X$354 5 12 M2_M1_CDNS_40661956134217
* cell instance $355 m90 *1 45.095,103.765
X$355 5 10 M2_M1_CDNS_40661956134218
* cell instance $356 m90 *1 56.945,103.765
X$356 5 17 M2_M1_CDNS_40661956134218
* cell instance $357 r0 *1 7.865,25.445
X$357 5 8 M2_M1_CDNS_40661956134218
* cell instance $358 m90 *1 19.715,25.445
X$358 5 15 M2_M1_CDNS_40661956134218
* cell instance $359 r0 *1 32.405,25.445
X$359 5 12 M2_M1_CDNS_40661956134217
* cell instance $360 m90 *1 45.095,25.445
X$360 5 10 M2_M1_CDNS_40661956134218
* cell instance $361 m90 *1 56.945,25.445
X$361 5 17 M2_M1_CDNS_40661956134218
* cell instance $362 r0 *1 7.865,108.645
X$362 5 8 M2_M1_CDNS_40661956134218
* cell instance $363 m90 *1 19.715,108.645
X$363 5 15 M2_M1_CDNS_40661956134218
* cell instance $364 r0 *1 32.405,108.645
X$364 5 12 M2_M1_CDNS_40661956134217
* cell instance $365 m90 *1 45.095,108.645
X$365 5 10 M2_M1_CDNS_40661956134218
* cell instance $366 m90 *1 56.945,108.645
X$366 5 17 M2_M1_CDNS_40661956134218
* cell instance $367 r0 *1 7.865,86.605
X$367 5 8 M2_M1_CDNS_40661956134218
* cell instance $368 m90 *1 19.715,86.605
X$368 5 15 M2_M1_CDNS_40661956134218
* cell instance $369 r0 *1 32.405,86.605
X$369 5 12 M2_M1_CDNS_40661956134217
* cell instance $370 m90 *1 45.095,86.605
X$370 5 10 M2_M1_CDNS_40661956134218
* cell instance $371 m90 *1 56.945,86.605
X$371 5 17 M2_M1_CDNS_40661956134218
* cell instance $372 r0 *1 7.865,113.525
X$372 5 8 M2_M1_CDNS_40661956134218
* cell instance $373 m90 *1 19.715,113.525
X$373 5 15 M2_M1_CDNS_40661956134218
* cell instance $374 r0 *1 32.405,113.525
X$374 5 12 M2_M1_CDNS_40661956134217
* cell instance $375 m90 *1 45.095,113.525
X$375 5 10 M2_M1_CDNS_40661956134218
* cell instance $376 m90 *1 56.945,113.525
X$376 5 17 M2_M1_CDNS_40661956134218
* cell instance $377 r0 *1 7.865,15.685
X$377 5 8 M2_M1_CDNS_40661956134218
* cell instance $378 m90 *1 19.715,15.685
X$378 5 15 M2_M1_CDNS_40661956134218
* cell instance $379 r0 *1 32.405,15.685
X$379 5 12 M2_M1_CDNS_40661956134217
* cell instance $380 m90 *1 45.095,15.685
X$380 5 10 M2_M1_CDNS_40661956134218
* cell instance $381 m90 *1 56.945,15.685
X$381 5 17 M2_M1_CDNS_40661956134218
* cell instance $382 r0 *1 7.865,79.285
X$382 5 8 M2_M1_CDNS_40661956134218
* cell instance $383 m90 *1 19.715,79.285
X$383 5 15 M2_M1_CDNS_40661956134218
* cell instance $384 r0 *1 32.405,79.285
X$384 5 12 M2_M1_CDNS_40661956134217
* cell instance $385 m90 *1 45.095,79.285
X$385 5 10 M2_M1_CDNS_40661956134218
* cell instance $386 m90 *1 56.945,79.285
X$386 5 17 M2_M1_CDNS_40661956134218
* cell instance $387 r0 *1 7.865,96.445
X$387 5 8 M2_M1_CDNS_40661956134218
* cell instance $388 m90 *1 19.715,96.445
X$388 5 15 M2_M1_CDNS_40661956134218
* cell instance $389 r0 *1 32.405,96.445
X$389 5 12 M2_M1_CDNS_40661956134217
* cell instance $390 m90 *1 45.095,96.445
X$390 5 10 M2_M1_CDNS_40661956134218
* cell instance $391 m90 *1 56.945,96.445
X$391 5 17 M2_M1_CDNS_40661956134218
* cell instance $392 r0 *1 7.865,76.845
X$392 5 8 M2_M1_CDNS_40661956134218
* cell instance $393 m90 *1 19.715,76.845
X$393 5 15 M2_M1_CDNS_40661956134218
* cell instance $394 r0 *1 32.405,76.845
X$394 5 12 M2_M1_CDNS_40661956134217
* cell instance $395 m90 *1 45.095,76.845
X$395 5 10 M2_M1_CDNS_40661956134218
* cell instance $396 m90 *1 56.945,76.845
X$396 5 17 M2_M1_CDNS_40661956134218
* cell instance $397 r0 *1 7.865,106.205
X$397 5 8 M2_M1_CDNS_40661956134218
* cell instance $398 m90 *1 19.715,106.205
X$398 5 15 M2_M1_CDNS_40661956134218
* cell instance $399 r0 *1 32.405,106.205
X$399 5 12 M2_M1_CDNS_40661956134217
* cell instance $400 m90 *1 45.095,106.205
X$400 5 10 M2_M1_CDNS_40661956134218
* cell instance $401 m90 *1 56.945,106.205
X$401 5 17 M2_M1_CDNS_40661956134218
* cell instance $402 r0 *1 7.865,98.885
X$402 5 8 M2_M1_CDNS_40661956134218
* cell instance $403 m90 *1 19.715,98.885
X$403 5 15 M2_M1_CDNS_40661956134218
* cell instance $404 r0 *1 32.405,98.885
X$404 5 12 M2_M1_CDNS_40661956134217
* cell instance $405 m90 *1 45.095,98.885
X$405 5 10 M2_M1_CDNS_40661956134218
* cell instance $406 m90 *1 56.945,98.885
X$406 5 17 M2_M1_CDNS_40661956134218
* cell instance $407 r0 *1 7.865,59.685
X$407 5 8 M2_M1_CDNS_40661956134218
* cell instance $408 m90 *1 19.715,59.685
X$408 5 15 M2_M1_CDNS_40661956134218
* cell instance $409 r0 *1 32.405,59.685
X$409 5 12 M2_M1_CDNS_40661956134217
* cell instance $410 m90 *1 45.095,59.685
X$410 5 10 M2_M1_CDNS_40661956134218
* cell instance $411 m90 *1 56.945,59.685
X$411 5 17 M2_M1_CDNS_40661956134218
* cell instance $412 r0 *1 7.865,71.965
X$412 5 8 M2_M1_CDNS_40661956134218
* cell instance $413 m90 *1 19.715,71.965
X$413 5 15 M2_M1_CDNS_40661956134218
* cell instance $414 r0 *1 32.405,71.965
X$414 5 12 M2_M1_CDNS_40661956134217
* cell instance $415 m90 *1 45.095,71.965
X$415 5 10 M2_M1_CDNS_40661956134218
* cell instance $416 m90 *1 56.945,71.965
X$416 5 17 M2_M1_CDNS_40661956134218
* cell instance $417 r0 *1 7.865,67.085
X$417 5 8 M2_M1_CDNS_40661956134218
* cell instance $418 m90 *1 19.715,67.085
X$418 5 15 M2_M1_CDNS_40661956134218
* cell instance $419 r0 *1 32.405,67.085
X$419 5 12 M2_M1_CDNS_40661956134217
* cell instance $420 m90 *1 45.095,67.085
X$420 5 10 M2_M1_CDNS_40661956134218
* cell instance $421 m90 *1 56.945,67.085
X$421 5 17 M2_M1_CDNS_40661956134218
* cell instance $422 r0 *1 7.865,81.725
X$422 5 8 M2_M1_CDNS_40661956134218
* cell instance $423 m90 *1 19.715,81.725
X$423 5 15 M2_M1_CDNS_40661956134218
* cell instance $424 r0 *1 32.405,81.725
X$424 5 12 M2_M1_CDNS_40661956134217
* cell instance $425 m90 *1 45.095,81.725
X$425 5 10 M2_M1_CDNS_40661956134218
* cell instance $426 m90 *1 56.945,81.725
X$426 5 17 M2_M1_CDNS_40661956134218
* cell instance $427 r0 *1 7.865,122.635
X$427 5 8 M2_M1_CDNS_40661956134206
* cell instance $428 m90 *1 19.715,122.635
X$428 5 15 M2_M1_CDNS_40661956134206
* cell instance $429 r0 *1 32.405,122.635
X$429 5 12 M2_M1_CDNS_40661956134207
* cell instance $430 m90 *1 45.095,122.635
X$430 5 10 M2_M1_CDNS_40661956134206
* cell instance $431 m90 *1 56.945,122.635
X$431 5 17 M2_M1_CDNS_40661956134206
* cell instance $432 r0 *1 7.865,34.025
X$432 5 8 M2_M1_CDNS_40661956134126
* cell instance $433 m90 *1 19.715,34.025
X$433 5 15 M2_M1_CDNS_40661956134126
* cell instance $434 r0 *1 32.405,34.025
X$434 5 12 M2_M1_CDNS_40661956134250
* cell instance $435 m90 *1 45.095,34.025
X$435 5 10 M2_M1_CDNS_40661956134126
* cell instance $436 m90 *1 56.945,34.025
X$436 5 17 M2_M1_CDNS_40661956134126
* cell instance $437 r0 *1 7.865,8.365
X$437 5 8 M2_M1_CDNS_40661956134218
* cell instance $438 m90 *1 19.715,8.365
X$438 5 15 M2_M1_CDNS_40661956134218
* cell instance $439 r0 *1 32.405,8.365
X$439 5 12 M2_M1_CDNS_40661956134217
* cell instance $440 m90 *1 45.095,8.365
X$440 5 10 M2_M1_CDNS_40661956134218
* cell instance $441 m90 *1 56.945,8.365
X$441 5 17 M2_M1_CDNS_40661956134218
* cell instance $442 r0 *1 7.865,4.135
X$442 5 8 M2_M1_CDNS_40661956134206
* cell instance $443 m90 *1 19.715,4.135
X$443 5 15 M2_M1_CDNS_40661956134206
* cell instance $444 r0 *1 32.405,4.135
X$444 5 12 M2_M1_CDNS_40661956134207
* cell instance $445 m90 *1 45.095,4.135
X$445 5 10 M2_M1_CDNS_40661956134206
* cell instance $446 m90 *1 56.945,4.135
X$446 5 17 M2_M1_CDNS_40661956134206
.ENDS nmos_clamp_20_50_4_DVDD

* cell M2_M1_CDNS_40661956134234
* pin
* pin
.SUBCKT M2_M1_CDNS_40661956134234 1 2
.ENDS M2_M1_CDNS_40661956134234

* cell M2_M1_CDNS_40661956134236
* pin
* pin
.SUBCKT M2_M1_CDNS_40661956134236 1 2
.ENDS M2_M1_CDNS_40661956134236

* cell M2_M1_CDNS_40661956134240
* pin
* pin
.SUBCKT M2_M1_CDNS_40661956134240 1 2
.ENDS M2_M1_CDNS_40661956134240

* cell M2_M1_CDNS_40661956134235
* pin
* pin
.SUBCKT M2_M1_CDNS_40661956134235 1 2
.ENDS M2_M1_CDNS_40661956134235

* cell M2_M1_CDNS_40661956134265
* pin
* pin
.SUBCKT M2_M1_CDNS_40661956134265 1 2
.ENDS M2_M1_CDNS_40661956134265

* cell M2_M1_CDNS_40661956134266
* pin
* pin
.SUBCKT M2_M1_CDNS_40661956134266 1 2
.ENDS M2_M1_CDNS_40661956134266

* cell M2_M1_CDNS_40661956134267
* pin
* pin
.SUBCKT M2_M1_CDNS_40661956134267 1 2
.ENDS M2_M1_CDNS_40661956134267

* cell nmos_clamp_20_50_4_DVSS
* pin
* pin
* pin
* pin
* pin
* pin
* pin
* pin
* pin
* pin
* pin
* pin
* pin
* pin
* pin
* pin
* pin gf180mcu_gnd
.SUBCKT nmos_clamp_20_50_4_DVSS 1 3 5 6 7 8 9 10 11 12 13 14 15 16 17 18 19
* net 19 gf180mcu_gnd
* cell instance $1 r90 *1 57.405,36.765
X$1 5 3 5 3 5 3 5 3 5 3 5 3 5 3 5 3 5 3 5 3 5 1 1 1 1 1 1 1 1 1 1 1 1 1 1 1 1 1
+ 1 1 1 19 nmos_6p0_CDNS_406619561341
* cell instance $2 r90 *1 57.405,7.405
X$2 5 3 5 3 5 3 5 3 5 3 5 3 5 3 5 3 5 3 5 3 5 1 1 1 1 1 1 1 1 1 1 1 1 1 1 1 1 1
+ 1 1 1 19 nmos_6p0_CDNS_406619561341
* cell instance $3 r90 *1 57.405,95.485
X$3 5 3 5 3 5 3 5 3 5 3 5 3 5 3 5 3 5 3 5 3 5 1 1 1 1 1 1 1 1 1 1 1 1 1 1 1 1 1
+ 1 1 1 19 nmos_6p0_CDNS_406619561341
* cell instance $4 r90 *1 57.405,66.125
X$4 5 3 5 3 5 3 5 3 5 3 5 3 5 3 5 3 5 3 5 3 5 1 1 1 1 1 1 1 1 1 1 1 1 1 1 1 1 1
+ 1 1 1 19 nmos_6p0_CDNS_406619561341
* cell instance $5 r0 *1 58.245,107.425
X$5 1 16 M2_M1_CDNS_40661956134141
* cell instance $6 m90 *1 58.165,107.425
X$6 1 M1_POLY2_CDNS_40661956134136
* cell instance $7 r0 *1 58.245,48.705
X$7 1 16 M2_M1_CDNS_40661956134141
* cell instance $8 m90 *1 58.165,48.705
X$8 1 M1_POLY2_CDNS_40661956134136
* cell instance $9 r0 *1 58.245,19.345
X$9 1 16 M2_M1_CDNS_40661956134141
* cell instance $10 m90 *1 58.165,19.345
X$10 1 M1_POLY2_CDNS_40661956134136
* cell instance $11 r0 *1 58.245,78.065
X$11 1 16 M2_M1_CDNS_40661956134141
* cell instance $12 m90 *1 58.165,78.065
X$12 1 M1_POLY2_CDNS_40661956134136
* cell instance $13 r0 *1 6.645,19.345
X$13 1 M1_POLY2_CDNS_40661956134136
* cell instance $14 r0 *1 6.565,19.345
X$14 1 7 M2_M1_CDNS_40661956134141
* cell instance $15 r0 *1 6.645,48.705
X$15 1 M1_POLY2_CDNS_40661956134136
* cell instance $16 r0 *1 6.565,48.705
X$16 1 7 M2_M1_CDNS_40661956134141
* cell instance $17 r0 *1 6.645,78.065
X$17 1 M1_POLY2_CDNS_40661956134136
* cell instance $18 r0 *1 6.565,78.065
X$18 1 7 M2_M1_CDNS_40661956134141
* cell instance $19 r0 *1 6.645,107.425
X$19 1 M1_POLY2_CDNS_40661956134136
* cell instance $20 r0 *1 6.565,107.425
X$20 1 7 M2_M1_CDNS_40661956134141
* cell instance $21 r0 *1 32.405,125.635
X$21 3 20 3 2 M1_NWELL_CDNS_40661956134139
* cell instance $22 r0 *1 32.405,1.135
X$22 3 20 3 2 M1_NWELL_CDNS_40661956134139
* cell instance $23 r0 *1 63.675,63.385
X$23 3 2 3 20 M1_NWELL_CDNS_40661956134135
* cell instance $24 r0 *1 1.135,63.385
X$24 3 2 3 20 M1_NWELL_CDNS_40661956134135
* cell instance $25 r0 *1 7.865,13.245
X$25 3 8 M2_M1_CDNS_40661956134218
* cell instance $26 m90 *1 19.715,13.245
X$26 3 15 M2_M1_CDNS_40661956134218
* cell instance $27 r0 *1 32.405,13.245
X$27 3 12 M2_M1_CDNS_40661956134217
* cell instance $28 m90 *1 45.095,13.245
X$28 3 10 M2_M1_CDNS_40661956134218
* cell instance $29 m90 *1 56.945,13.245
X$29 3 17 M2_M1_CDNS_40661956134218
* cell instance $30 r0 *1 7.865,15.685
X$30 3 8 M2_M1_CDNS_40661956134218
* cell instance $31 m90 *1 19.715,15.685
X$31 3 15 M2_M1_CDNS_40661956134218
* cell instance $32 r0 *1 32.405,15.685
X$32 3 12 M2_M1_CDNS_40661956134217
* cell instance $33 m90 *1 45.095,15.685
X$33 3 10 M2_M1_CDNS_40661956134218
* cell instance $34 m90 *1 56.945,15.685
X$34 3 17 M2_M1_CDNS_40661956134218
* cell instance $35 r0 *1 7.865,18.125
X$35 3 8 M2_M1_CDNS_40661956134218
* cell instance $36 m90 *1 19.715,18.125
X$36 3 15 M2_M1_CDNS_40661956134218
* cell instance $37 r0 *1 32.405,18.125
X$37 3 12 M2_M1_CDNS_40661956134217
* cell instance $38 m90 *1 45.095,18.125
X$38 3 10 M2_M1_CDNS_40661956134218
* cell instance $39 m90 *1 56.945,18.125
X$39 3 17 M2_M1_CDNS_40661956134218
* cell instance $40 r0 *1 7.865,20.565
X$40 3 8 M2_M1_CDNS_40661956134218
* cell instance $41 m90 *1 19.715,20.565
X$41 3 15 M2_M1_CDNS_40661956134218
* cell instance $42 r0 *1 32.405,20.565
X$42 3 12 M2_M1_CDNS_40661956134217
* cell instance $43 m90 *1 45.095,20.565
X$43 3 10 M2_M1_CDNS_40661956134218
* cell instance $44 m90 *1 56.945,20.565
X$44 3 17 M2_M1_CDNS_40661956134218
* cell instance $45 r0 *1 7.865,23.005
X$45 3 8 M2_M1_CDNS_40661956134218
* cell instance $46 m90 *1 19.715,23.005
X$46 3 15 M2_M1_CDNS_40661956134218
* cell instance $47 r0 *1 32.405,23.005
X$47 3 12 M2_M1_CDNS_40661956134217
* cell instance $48 m90 *1 45.095,23.005
X$48 3 10 M2_M1_CDNS_40661956134218
* cell instance $49 m90 *1 56.945,23.005
X$49 3 17 M2_M1_CDNS_40661956134218
* cell instance $50 r0 *1 7.865,25.445
X$50 3 8 M2_M1_CDNS_40661956134218
* cell instance $51 m90 *1 19.715,25.445
X$51 3 15 M2_M1_CDNS_40661956134218
* cell instance $52 r0 *1 32.405,25.445
X$52 3 12 M2_M1_CDNS_40661956134217
* cell instance $53 m90 *1 45.095,25.445
X$53 3 10 M2_M1_CDNS_40661956134218
* cell instance $54 m90 *1 56.945,25.445
X$54 3 17 M2_M1_CDNS_40661956134218
* cell instance $55 r0 *1 7.865,27.885
X$55 3 8 M2_M1_CDNS_40661956134218
* cell instance $56 m90 *1 19.715,27.885
X$56 3 15 M2_M1_CDNS_40661956134218
* cell instance $57 r0 *1 32.405,27.885
X$57 3 12 M2_M1_CDNS_40661956134217
* cell instance $58 m90 *1 45.095,27.885
X$58 3 10 M2_M1_CDNS_40661956134218
* cell instance $59 m90 *1 56.945,27.885
X$59 3 17 M2_M1_CDNS_40661956134218
* cell instance $60 r0 *1 7.865,71.965
X$60 3 8 M2_M1_CDNS_40661956134218
* cell instance $61 m90 *1 19.715,71.965
X$61 3 15 M2_M1_CDNS_40661956134218
* cell instance $62 r0 *1 32.405,71.965
X$62 3 12 M2_M1_CDNS_40661956134217
* cell instance $63 m90 *1 45.095,71.965
X$63 3 10 M2_M1_CDNS_40661956134218
* cell instance $64 m90 *1 56.945,71.965
X$64 3 17 M2_M1_CDNS_40661956134218
* cell instance $65 r0 *1 7.865,103.765
X$65 3 8 M2_M1_CDNS_40661956134218
* cell instance $66 m90 *1 19.715,103.765
X$66 3 15 M2_M1_CDNS_40661956134218
* cell instance $67 r0 *1 32.405,103.765
X$67 3 12 M2_M1_CDNS_40661956134217
* cell instance $68 m90 *1 45.095,103.765
X$68 3 10 M2_M1_CDNS_40661956134218
* cell instance $69 m90 *1 56.945,103.765
X$69 3 17 M2_M1_CDNS_40661956134218
* cell instance $70 r0 *1 7.865,98.885
X$70 3 8 M2_M1_CDNS_40661956134218
* cell instance $71 m90 *1 19.715,98.885
X$71 3 15 M2_M1_CDNS_40661956134218
* cell instance $72 r0 *1 32.405,98.885
X$72 3 12 M2_M1_CDNS_40661956134217
* cell instance $73 m90 *1 45.095,98.885
X$73 3 10 M2_M1_CDNS_40661956134218
* cell instance $74 m90 *1 56.945,98.885
X$74 3 17 M2_M1_CDNS_40661956134218
* cell instance $75 r0 *1 7.865,111.085
X$75 3 8 M2_M1_CDNS_40661956134218
* cell instance $76 m90 *1 19.715,111.085
X$76 3 15 M2_M1_CDNS_40661956134218
* cell instance $77 r0 *1 32.405,111.085
X$77 3 12 M2_M1_CDNS_40661956134217
* cell instance $78 m90 *1 45.095,111.085
X$78 3 10 M2_M1_CDNS_40661956134218
* cell instance $79 m90 *1 56.945,111.085
X$79 3 17 M2_M1_CDNS_40661956134218
* cell instance $80 r0 *1 7.865,115.965
X$80 3 8 M2_M1_CDNS_40661956134218
* cell instance $81 m90 *1 19.715,115.965
X$81 3 15 M2_M1_CDNS_40661956134218
* cell instance $82 r0 *1 32.405,115.965
X$82 3 12 M2_M1_CDNS_40661956134217
* cell instance $83 m90 *1 45.095,115.965
X$83 3 10 M2_M1_CDNS_40661956134218
* cell instance $84 m90 *1 56.945,115.965
X$84 3 17 M2_M1_CDNS_40661956134218
* cell instance $85 r0 *1 7.865,118.405
X$85 3 8 M2_M1_CDNS_40661956134218
* cell instance $86 m90 *1 19.715,118.405
X$86 3 15 M2_M1_CDNS_40661956134218
* cell instance $87 r0 *1 32.405,118.405
X$87 3 12 M2_M1_CDNS_40661956134217
* cell instance $88 m90 *1 45.095,118.405
X$88 3 10 M2_M1_CDNS_40661956134218
* cell instance $89 m90 *1 56.945,118.405
X$89 3 17 M2_M1_CDNS_40661956134218
* cell instance $90 r0 *1 7.865,69.525
X$90 3 8 M2_M1_CDNS_40661956134218
* cell instance $91 m90 *1 19.715,69.525
X$91 3 15 M2_M1_CDNS_40661956134218
* cell instance $92 r0 *1 32.405,69.525
X$92 3 12 M2_M1_CDNS_40661956134217
* cell instance $93 m90 *1 45.095,69.525
X$93 3 10 M2_M1_CDNS_40661956134218
* cell instance $94 m90 *1 56.945,69.525
X$94 3 17 M2_M1_CDNS_40661956134218
* cell instance $95 r0 *1 7.865,96.445
X$95 3 8 M2_M1_CDNS_40661956134218
* cell instance $96 m90 *1 19.715,96.445
X$96 3 15 M2_M1_CDNS_40661956134218
* cell instance $97 r0 *1 32.405,96.445
X$97 3 12 M2_M1_CDNS_40661956134217
* cell instance $98 m90 *1 45.095,96.445
X$98 3 10 M2_M1_CDNS_40661956134218
* cell instance $99 m90 *1 56.945,96.445
X$99 3 17 M2_M1_CDNS_40661956134218
* cell instance $100 r0 *1 7.865,84.165
X$100 3 8 M2_M1_CDNS_40661956134218
* cell instance $101 m90 *1 19.715,84.165
X$101 3 15 M2_M1_CDNS_40661956134218
* cell instance $102 r0 *1 32.405,84.165
X$102 3 12 M2_M1_CDNS_40661956134217
* cell instance $103 m90 *1 45.095,84.165
X$103 3 10 M2_M1_CDNS_40661956134218
* cell instance $104 m90 *1 56.945,84.165
X$104 3 17 M2_M1_CDNS_40661956134218
* cell instance $105 r0 *1 7.865,86.605
X$105 3 8 M2_M1_CDNS_40661956134218
* cell instance $106 m90 *1 19.715,86.605
X$106 3 15 M2_M1_CDNS_40661956134218
* cell instance $107 r0 *1 32.405,86.605
X$107 3 12 M2_M1_CDNS_40661956134217
* cell instance $108 m90 *1 45.095,86.605
X$108 3 10 M2_M1_CDNS_40661956134218
* cell instance $109 m90 *1 56.945,86.605
X$109 3 17 M2_M1_CDNS_40661956134218
* cell instance $110 r0 *1 7.865,47.485
X$110 3 8 M2_M1_CDNS_40661956134218
* cell instance $111 m90 *1 19.715,47.485
X$111 3 15 M2_M1_CDNS_40661956134218
* cell instance $112 r0 *1 32.405,47.485
X$112 3 12 M2_M1_CDNS_40661956134217
* cell instance $113 m90 *1 45.095,47.485
X$113 3 10 M2_M1_CDNS_40661956134218
* cell instance $114 m90 *1 56.945,47.485
X$114 3 17 M2_M1_CDNS_40661956134218
* cell instance $115 r0 *1 7.865,45.045
X$115 3 8 M2_M1_CDNS_40661956134218
* cell instance $116 m90 *1 19.715,45.045
X$116 3 15 M2_M1_CDNS_40661956134218
* cell instance $117 r0 *1 32.405,45.045
X$117 3 12 M2_M1_CDNS_40661956134217
* cell instance $118 m90 *1 45.095,45.045
X$118 3 10 M2_M1_CDNS_40661956134218
* cell instance $119 m90 *1 56.945,45.045
X$119 3 17 M2_M1_CDNS_40661956134218
* cell instance $120 r0 *1 7.865,40.165
X$120 3 8 M2_M1_CDNS_40661956134218
* cell instance $121 m90 *1 19.715,40.165
X$121 3 15 M2_M1_CDNS_40661956134218
* cell instance $122 r0 *1 32.405,40.165
X$122 3 12 M2_M1_CDNS_40661956134217
* cell instance $123 m90 *1 45.095,40.165
X$123 3 10 M2_M1_CDNS_40661956134218
* cell instance $124 m90 *1 56.945,40.165
X$124 3 17 M2_M1_CDNS_40661956134218
* cell instance $125 r0 *1 7.865,30.325
X$125 3 8 M2_M1_CDNS_40661956134218
* cell instance $126 m90 *1 19.715,30.325
X$126 3 15 M2_M1_CDNS_40661956134218
* cell instance $127 r0 *1 32.405,30.325
X$127 3 12 M2_M1_CDNS_40661956134217
* cell instance $128 m90 *1 45.095,30.325
X$128 3 10 M2_M1_CDNS_40661956134218
* cell instance $129 m90 *1 56.945,30.325
X$129 3 17 M2_M1_CDNS_40661956134218
* cell instance $130 r0 *1 7.865,89.045
X$130 3 8 M2_M1_CDNS_40661956134218
* cell instance $131 m90 *1 19.715,89.045
X$131 3 15 M2_M1_CDNS_40661956134218
* cell instance $132 r0 *1 32.405,89.045
X$132 3 12 M2_M1_CDNS_40661956134217
* cell instance $133 m90 *1 45.095,89.045
X$133 3 10 M2_M1_CDNS_40661956134218
* cell instance $134 m90 *1 56.945,89.045
X$134 3 17 M2_M1_CDNS_40661956134218
* cell instance $135 r0 *1 7.865,108.645
X$135 3 8 M2_M1_CDNS_40661956134218
* cell instance $136 m90 *1 19.715,108.645
X$136 3 15 M2_M1_CDNS_40661956134218
* cell instance $137 r0 *1 32.405,108.645
X$137 3 12 M2_M1_CDNS_40661956134217
* cell instance $138 m90 *1 45.095,108.645
X$138 3 10 M2_M1_CDNS_40661956134218
* cell instance $139 m90 *1 56.945,108.645
X$139 3 17 M2_M1_CDNS_40661956134218
* cell instance $140 r0 *1 7.865,106.205
X$140 3 8 M2_M1_CDNS_40661956134218
* cell instance $141 m90 *1 19.715,106.205
X$141 3 15 M2_M1_CDNS_40661956134218
* cell instance $142 r0 *1 32.405,106.205
X$142 3 12 M2_M1_CDNS_40661956134217
* cell instance $143 m90 *1 45.095,106.205
X$143 3 10 M2_M1_CDNS_40661956134218
* cell instance $144 m90 *1 56.945,106.205
X$144 3 17 M2_M1_CDNS_40661956134218
* cell instance $145 r0 *1 7.865,81.725
X$145 3 8 M2_M1_CDNS_40661956134218
* cell instance $146 m90 *1 19.715,81.725
X$146 3 15 M2_M1_CDNS_40661956134218
* cell instance $147 r0 *1 32.405,81.725
X$147 3 12 M2_M1_CDNS_40661956134217
* cell instance $148 m90 *1 45.095,81.725
X$148 3 10 M2_M1_CDNS_40661956134218
* cell instance $149 m90 *1 56.945,81.725
X$149 3 17 M2_M1_CDNS_40661956134218
* cell instance $150 r0 *1 7.865,10.805
X$150 3 8 M2_M1_CDNS_40661956134218
* cell instance $151 m90 *1 19.715,10.805
X$151 3 15 M2_M1_CDNS_40661956134218
* cell instance $152 r0 *1 32.405,10.805
X$152 3 12 M2_M1_CDNS_40661956134217
* cell instance $153 m90 *1 45.095,10.805
X$153 3 10 M2_M1_CDNS_40661956134218
* cell instance $154 m90 *1 56.945,10.805
X$154 3 17 M2_M1_CDNS_40661956134218
* cell instance $155 r0 *1 7.865,8.365
X$155 3 8 M2_M1_CDNS_40661956134218
* cell instance $156 m90 *1 19.715,8.365
X$156 3 15 M2_M1_CDNS_40661956134218
* cell instance $157 r0 *1 32.405,8.365
X$157 3 12 M2_M1_CDNS_40661956134217
* cell instance $158 m90 *1 45.095,8.365
X$158 3 10 M2_M1_CDNS_40661956134218
* cell instance $159 m90 *1 56.945,8.365
X$159 3 17 M2_M1_CDNS_40661956134218
* cell instance $160 r0 *1 7.865,59.685
X$160 3 8 M2_M1_CDNS_40661956134218
* cell instance $161 m90 *1 19.715,59.685
X$161 3 15 M2_M1_CDNS_40661956134218
* cell instance $162 r0 *1 32.405,59.685
X$162 3 12 M2_M1_CDNS_40661956134217
* cell instance $163 m90 *1 45.095,59.685
X$163 3 10 M2_M1_CDNS_40661956134218
* cell instance $164 m90 *1 56.945,59.685
X$164 3 17 M2_M1_CDNS_40661956134218
* cell instance $165 r0 *1 7.865,42.605
X$165 3 8 M2_M1_CDNS_40661956134218
* cell instance $166 m90 *1 19.715,42.605
X$166 3 15 M2_M1_CDNS_40661956134218
* cell instance $167 r0 *1 32.405,42.605
X$167 3 12 M2_M1_CDNS_40661956134217
* cell instance $168 m90 *1 45.095,42.605
X$168 3 10 M2_M1_CDNS_40661956134218
* cell instance $169 m90 *1 56.945,42.605
X$169 3 17 M2_M1_CDNS_40661956134218
* cell instance $170 r0 *1 7.865,79.285
X$170 3 8 M2_M1_CDNS_40661956134218
* cell instance $171 m90 *1 19.715,79.285
X$171 3 15 M2_M1_CDNS_40661956134218
* cell instance $172 r0 *1 32.405,79.285
X$172 3 12 M2_M1_CDNS_40661956134217
* cell instance $173 m90 *1 45.095,79.285
X$173 3 10 M2_M1_CDNS_40661956134218
* cell instance $174 m90 *1 56.945,79.285
X$174 3 17 M2_M1_CDNS_40661956134218
* cell instance $175 r0 *1 7.865,76.845
X$175 3 8 M2_M1_CDNS_40661956134218
* cell instance $176 m90 *1 19.715,76.845
X$176 3 15 M2_M1_CDNS_40661956134218
* cell instance $177 r0 *1 32.405,76.845
X$177 3 12 M2_M1_CDNS_40661956134217
* cell instance $178 m90 *1 45.095,76.845
X$178 3 10 M2_M1_CDNS_40661956134218
* cell instance $179 m90 *1 56.945,76.845
X$179 3 17 M2_M1_CDNS_40661956134218
* cell instance $180 r0 *1 7.865,74.405
X$180 3 8 M2_M1_CDNS_40661956134218
* cell instance $181 m90 *1 19.715,74.405
X$181 3 15 M2_M1_CDNS_40661956134218
* cell instance $182 r0 *1 32.405,74.405
X$182 3 12 M2_M1_CDNS_40661956134217
* cell instance $183 m90 *1 45.095,74.405
X$183 3 10 M2_M1_CDNS_40661956134218
* cell instance $184 m90 *1 56.945,74.405
X$184 3 17 M2_M1_CDNS_40661956134218
* cell instance $185 r0 *1 7.865,67.085
X$185 3 8 M2_M1_CDNS_40661956134218
* cell instance $186 m90 *1 19.715,67.085
X$186 3 15 M2_M1_CDNS_40661956134218
* cell instance $187 r0 *1 32.405,67.085
X$187 3 12 M2_M1_CDNS_40661956134217
* cell instance $188 m90 *1 45.095,67.085
X$188 3 10 M2_M1_CDNS_40661956134218
* cell instance $189 m90 *1 56.945,67.085
X$189 3 17 M2_M1_CDNS_40661956134218
* cell instance $190 r0 *1 7.865,101.325
X$190 3 8 M2_M1_CDNS_40661956134218
* cell instance $191 m90 *1 19.715,101.325
X$191 3 15 M2_M1_CDNS_40661956134218
* cell instance $192 r0 *1 32.405,101.325
X$192 3 12 M2_M1_CDNS_40661956134217
* cell instance $193 m90 *1 45.095,101.325
X$193 3 10 M2_M1_CDNS_40661956134218
* cell instance $194 m90 *1 56.945,101.325
X$194 3 17 M2_M1_CDNS_40661956134218
* cell instance $195 r0 *1 7.865,37.725
X$195 3 8 M2_M1_CDNS_40661956134218
* cell instance $196 m90 *1 19.715,37.725
X$196 3 15 M2_M1_CDNS_40661956134218
* cell instance $197 r0 *1 32.405,37.725
X$197 3 12 M2_M1_CDNS_40661956134217
* cell instance $198 m90 *1 45.095,37.725
X$198 3 10 M2_M1_CDNS_40661956134218
* cell instance $199 m90 *1 56.945,37.725
X$199 3 17 M2_M1_CDNS_40661956134218
* cell instance $200 r0 *1 7.865,57.245
X$200 3 8 M2_M1_CDNS_40661956134218
* cell instance $201 m90 *1 19.715,57.245
X$201 3 15 M2_M1_CDNS_40661956134218
* cell instance $202 r0 *1 32.405,57.245
X$202 3 12 M2_M1_CDNS_40661956134217
* cell instance $203 m90 *1 45.095,57.245
X$203 3 10 M2_M1_CDNS_40661956134218
* cell instance $204 m90 *1 56.945,57.245
X$204 3 17 M2_M1_CDNS_40661956134218
* cell instance $205 r0 *1 7.865,54.805
X$205 3 8 M2_M1_CDNS_40661956134218
* cell instance $206 m90 *1 19.715,54.805
X$206 3 15 M2_M1_CDNS_40661956134218
* cell instance $207 r0 *1 32.405,54.805
X$207 3 12 M2_M1_CDNS_40661956134217
* cell instance $208 m90 *1 45.095,54.805
X$208 3 10 M2_M1_CDNS_40661956134218
* cell instance $209 m90 *1 56.945,54.805
X$209 3 17 M2_M1_CDNS_40661956134218
* cell instance $210 r0 *1 7.865,52.365
X$210 3 8 M2_M1_CDNS_40661956134218
* cell instance $211 m90 *1 19.715,52.365
X$211 3 15 M2_M1_CDNS_40661956134218
* cell instance $212 r0 *1 32.405,52.365
X$212 3 12 M2_M1_CDNS_40661956134217
* cell instance $213 m90 *1 45.095,52.365
X$213 3 10 M2_M1_CDNS_40661956134218
* cell instance $214 m90 *1 56.945,52.365
X$214 3 17 M2_M1_CDNS_40661956134218
* cell instance $215 r0 *1 7.865,113.525
X$215 3 8 M2_M1_CDNS_40661956134218
* cell instance $216 m90 *1 19.715,113.525
X$216 3 15 M2_M1_CDNS_40661956134218
* cell instance $217 r0 *1 32.405,113.525
X$217 3 12 M2_M1_CDNS_40661956134217
* cell instance $218 m90 *1 45.095,113.525
X$218 3 10 M2_M1_CDNS_40661956134218
* cell instance $219 m90 *1 56.945,113.525
X$219 3 17 M2_M1_CDNS_40661956134218
* cell instance $220 r0 *1 7.865,49.925
X$220 3 8 M2_M1_CDNS_40661956134218
* cell instance $221 m90 *1 19.715,49.925
X$221 3 15 M2_M1_CDNS_40661956134218
* cell instance $222 r0 *1 32.405,49.925
X$222 3 12 M2_M1_CDNS_40661956134217
* cell instance $223 m90 *1 45.095,49.925
X$223 3 10 M2_M1_CDNS_40661956134218
* cell instance $224 m90 *1 56.945,49.925
X$224 3 17 M2_M1_CDNS_40661956134218
* cell instance $225 r0 *1 7.865,1.135
X$225 3 8 M2_M1_CDNS_40661956134206
* cell instance $226 m90 *1 19.715,1.135
X$226 3 15 M2_M1_CDNS_40661956134206
* cell instance $227 r0 *1 32.405,1.135
X$227 3 12 M2_M1_CDNS_40661956134207
* cell instance $228 m90 *1 45.095,1.135
X$228 3 10 M2_M1_CDNS_40661956134206
* cell instance $229 m90 *1 56.945,1.135
X$229 3 17 M2_M1_CDNS_40661956134206
* cell instance $230 r0 *1 7.865,125.635
X$230 3 8 M2_M1_CDNS_40661956134206
* cell instance $231 m90 *1 19.715,125.635
X$231 3 15 M2_M1_CDNS_40661956134206
* cell instance $232 r0 *1 32.405,125.635
X$232 3 12 M2_M1_CDNS_40661956134207
* cell instance $233 m90 *1 45.095,125.635
X$233 3 10 M2_M1_CDNS_40661956134206
* cell instance $234 m90 *1 56.945,125.635
X$234 3 17 M2_M1_CDNS_40661956134206
* cell instance $235 r0 *1 32.405,34.025
X$235 5 4 M1_PSUB_CDNS_40661956134134
* cell instance $236 r0 *1 32.405,63.385
X$236 5 4 M1_PSUB_CDNS_40661956134134
* cell instance $237 r0 *1 32.405,92.745
X$237 5 4 M1_PSUB_CDNS_40661956134134
* cell instance $238 r0 *1 32.405,4.135
X$238 5 4 M1_PSUB_CDNS_40661956134138
* cell instance $239 r0 *1 32.405,122.635
X$239 5 4 M1_PSUB_CDNS_40661956134138
* cell instance $240 r0 *1 3.885,63.385
X$240 5 4 M1_PSUB_CDNS_40661956134137
* cell instance $241 r0 *1 60.925,63.385
X$241 5 4 M1_PSUB_CDNS_40661956134137
* cell instance $242 r0 *1 13.79,63.385
X$242 5 14 M2_M1_CDNS_40661956134255
* cell instance $243 r0 *1 25.64,63.385
X$243 5 13 M2_M1_CDNS_40661956134255
* cell instance $244 m90 *1 39.17,63.385
X$244 5 11 M2_M1_CDNS_40661956134255
* cell instance $245 m90 *1 51.02,63.385
X$245 5 9 M2_M1_CDNS_40661956134255
* cell instance $246 r0 *1 13.79,92.745
X$246 5 14 M2_M1_CDNS_40661956134255
* cell instance $247 r0 *1 25.64,92.745
X$247 5 13 M2_M1_CDNS_40661956134255
* cell instance $248 m90 *1 39.17,92.745
X$248 5 11 M2_M1_CDNS_40661956134255
* cell instance $249 m90 *1 51.02,92.745
X$249 5 9 M2_M1_CDNS_40661956134255
* cell instance $250 r0 *1 60.925,63.385
X$250 5 18 M2_M1_CDNS_40661956134268
* cell instance $251 r0 *1 13.79,43.825
X$251 5 14 M2_M1_CDNS_40661956134249
* cell instance $252 r0 *1 25.64,43.825
X$252 5 13 M2_M1_CDNS_40661956134249
* cell instance $253 m90 *1 39.17,43.825
X$253 5 11 M2_M1_CDNS_40661956134249
* cell instance $254 m90 *1 51.02,43.825
X$254 5 9 M2_M1_CDNS_40661956134249
* cell instance $255 r0 *1 13.79,46.265
X$255 5 14 M2_M1_CDNS_40661956134249
* cell instance $256 r0 *1 25.64,46.265
X$256 5 13 M2_M1_CDNS_40661956134249
* cell instance $257 m90 *1 39.17,46.265
X$257 5 11 M2_M1_CDNS_40661956134249
* cell instance $258 m90 *1 51.02,46.265
X$258 5 9 M2_M1_CDNS_40661956134249
* cell instance $259 r0 *1 13.79,29.105
X$259 5 14 M2_M1_CDNS_40661956134249
* cell instance $260 r0 *1 25.64,29.105
X$260 5 13 M2_M1_CDNS_40661956134249
* cell instance $261 m90 *1 39.17,29.105
X$261 5 11 M2_M1_CDNS_40661956134249
* cell instance $262 m90 *1 51.02,29.105
X$262 5 9 M2_M1_CDNS_40661956134249
* cell instance $263 r0 *1 13.79,41.385
X$263 5 14 M2_M1_CDNS_40661956134249
* cell instance $264 r0 *1 25.64,41.385
X$264 5 13 M2_M1_CDNS_40661956134249
* cell instance $265 m90 *1 39.17,41.385
X$265 5 11 M2_M1_CDNS_40661956134249
* cell instance $266 m90 *1 51.02,41.385
X$266 5 9 M2_M1_CDNS_40661956134249
* cell instance $267 r0 *1 13.79,38.945
X$267 5 14 M2_M1_CDNS_40661956134249
* cell instance $268 r0 *1 25.64,38.945
X$268 5 13 M2_M1_CDNS_40661956134249
* cell instance $269 m90 *1 39.17,38.945
X$269 5 11 M2_M1_CDNS_40661956134249
* cell instance $270 m90 *1 51.02,38.945
X$270 5 9 M2_M1_CDNS_40661956134249
* cell instance $271 r0 *1 13.79,36.505
X$271 5 14 M2_M1_CDNS_40661956134249
* cell instance $272 r0 *1 25.64,36.505
X$272 5 13 M2_M1_CDNS_40661956134249
* cell instance $273 m90 *1 39.17,36.505
X$273 5 11 M2_M1_CDNS_40661956134249
* cell instance $274 m90 *1 51.02,36.505
X$274 5 9 M2_M1_CDNS_40661956134249
* cell instance $275 r0 *1 13.79,31.545
X$275 5 14 M2_M1_CDNS_40661956134249
* cell instance $276 r0 *1 25.64,31.545
X$276 5 13 M2_M1_CDNS_40661956134249
* cell instance $277 m90 *1 39.17,31.545
X$277 5 11 M2_M1_CDNS_40661956134249
* cell instance $278 m90 *1 51.02,31.545
X$278 5 9 M2_M1_CDNS_40661956134249
* cell instance $279 r0 *1 13.79,60.905
X$279 5 14 M2_M1_CDNS_40661956134249
* cell instance $280 r0 *1 25.64,60.905
X$280 5 13 M2_M1_CDNS_40661956134249
* cell instance $281 m90 *1 39.17,60.905
X$281 5 11 M2_M1_CDNS_40661956134249
* cell instance $282 m90 *1 51.02,60.905
X$282 5 9 M2_M1_CDNS_40661956134249
* cell instance $283 r0 *1 13.79,117.185
X$283 5 14 M2_M1_CDNS_40661956134249
* cell instance $284 r0 *1 25.64,117.185
X$284 5 13 M2_M1_CDNS_40661956134249
* cell instance $285 m90 *1 39.17,117.185
X$285 5 11 M2_M1_CDNS_40661956134249
* cell instance $286 m90 *1 51.02,117.185
X$286 5 9 M2_M1_CDNS_40661956134249
* cell instance $287 r0 *1 13.79,78.065
X$287 5 14 M2_M1_CDNS_40661956134249
* cell instance $288 r0 *1 25.64,78.065
X$288 5 13 M2_M1_CDNS_40661956134249
* cell instance $289 m90 *1 39.17,78.065
X$289 5 11 M2_M1_CDNS_40661956134249
* cell instance $290 m90 *1 51.02,78.065
X$290 5 9 M2_M1_CDNS_40661956134249
* cell instance $291 r0 *1 13.79,75.625
X$291 5 14 M2_M1_CDNS_40661956134249
* cell instance $292 r0 *1 25.64,75.625
X$292 5 13 M2_M1_CDNS_40661956134249
* cell instance $293 m90 *1 39.17,75.625
X$293 5 11 M2_M1_CDNS_40661956134249
* cell instance $294 m90 *1 51.02,75.625
X$294 5 9 M2_M1_CDNS_40661956134249
* cell instance $295 r0 *1 13.79,73.185
X$295 5 14 M2_M1_CDNS_40661956134249
* cell instance $296 r0 *1 25.64,73.185
X$296 5 13 M2_M1_CDNS_40661956134249
* cell instance $297 m90 *1 39.17,73.185
X$297 5 11 M2_M1_CDNS_40661956134249
* cell instance $298 m90 *1 51.02,73.185
X$298 5 9 M2_M1_CDNS_40661956134249
* cell instance $299 r0 *1 13.79,70.745
X$299 5 14 M2_M1_CDNS_40661956134249
* cell instance $300 r0 *1 25.64,70.745
X$300 5 13 M2_M1_CDNS_40661956134249
* cell instance $301 m90 *1 39.17,70.745
X$301 5 11 M2_M1_CDNS_40661956134249
* cell instance $302 m90 *1 51.02,70.745
X$302 5 9 M2_M1_CDNS_40661956134249
* cell instance $303 r0 *1 13.79,68.305
X$303 5 14 M2_M1_CDNS_40661956134249
* cell instance $304 r0 *1 25.64,68.305
X$304 5 13 M2_M1_CDNS_40661956134249
* cell instance $305 m90 *1 39.17,68.305
X$305 5 11 M2_M1_CDNS_40661956134249
* cell instance $306 m90 *1 51.02,68.305
X$306 5 9 M2_M1_CDNS_40661956134249
* cell instance $307 r0 *1 13.79,65.865
X$307 5 14 M2_M1_CDNS_40661956134249
* cell instance $308 r0 *1 25.64,65.865
X$308 5 13 M2_M1_CDNS_40661956134249
* cell instance $309 m90 *1 39.17,65.865
X$309 5 11 M2_M1_CDNS_40661956134249
* cell instance $310 m90 *1 51.02,65.865
X$310 5 9 M2_M1_CDNS_40661956134249
* cell instance $311 r0 *1 13.79,85.385
X$311 5 14 M2_M1_CDNS_40661956134249
* cell instance $312 r0 *1 25.64,85.385
X$312 5 13 M2_M1_CDNS_40661956134249
* cell instance $313 m90 *1 39.17,85.385
X$313 5 11 M2_M1_CDNS_40661956134249
* cell instance $314 m90 *1 51.02,85.385
X$314 5 9 M2_M1_CDNS_40661956134249
* cell instance $315 r0 *1 13.79,82.945
X$315 5 14 M2_M1_CDNS_40661956134249
* cell instance $316 r0 *1 25.64,82.945
X$316 5 13 M2_M1_CDNS_40661956134249
* cell instance $317 m90 *1 39.17,82.945
X$317 5 11 M2_M1_CDNS_40661956134249
* cell instance $318 m90 *1 51.02,82.945
X$318 5 9 M2_M1_CDNS_40661956134249
* cell instance $319 r0 *1 13.79,87.825
X$319 5 14 M2_M1_CDNS_40661956134249
* cell instance $320 r0 *1 25.64,87.825
X$320 5 13 M2_M1_CDNS_40661956134249
* cell instance $321 m90 *1 39.17,87.825
X$321 5 11 M2_M1_CDNS_40661956134249
* cell instance $322 m90 *1 51.02,87.825
X$322 5 9 M2_M1_CDNS_40661956134249
* cell instance $323 r0 *1 13.79,90.265
X$323 5 14 M2_M1_CDNS_40661956134249
* cell instance $324 r0 *1 25.64,90.265
X$324 5 13 M2_M1_CDNS_40661956134249
* cell instance $325 m90 *1 39.17,90.265
X$325 5 11 M2_M1_CDNS_40661956134249
* cell instance $326 m90 *1 51.02,90.265
X$326 5 9 M2_M1_CDNS_40661956134249
* cell instance $327 r0 *1 13.79,95.225
X$327 5 14 M2_M1_CDNS_40661956134249
* cell instance $328 r0 *1 25.64,95.225
X$328 5 13 M2_M1_CDNS_40661956134249
* cell instance $329 m90 *1 39.17,95.225
X$329 5 11 M2_M1_CDNS_40661956134249
* cell instance $330 m90 *1 51.02,95.225
X$330 5 9 M2_M1_CDNS_40661956134249
* cell instance $331 r0 *1 13.79,100.105
X$331 5 14 M2_M1_CDNS_40661956134249
* cell instance $332 r0 *1 25.64,100.105
X$332 5 13 M2_M1_CDNS_40661956134249
* cell instance $333 m90 *1 39.17,100.105
X$333 5 11 M2_M1_CDNS_40661956134249
* cell instance $334 m90 *1 51.02,100.105
X$334 5 9 M2_M1_CDNS_40661956134249
* cell instance $335 r0 *1 13.79,102.545
X$335 5 14 M2_M1_CDNS_40661956134249
* cell instance $336 r0 *1 25.64,102.545
X$336 5 13 M2_M1_CDNS_40661956134249
* cell instance $337 m90 *1 39.17,102.545
X$337 5 11 M2_M1_CDNS_40661956134249
* cell instance $338 m90 *1 51.02,102.545
X$338 5 9 M2_M1_CDNS_40661956134249
* cell instance $339 r0 *1 13.79,104.985
X$339 5 14 M2_M1_CDNS_40661956134249
* cell instance $340 r0 *1 25.64,104.985
X$340 5 13 M2_M1_CDNS_40661956134249
* cell instance $341 m90 *1 39.17,104.985
X$341 5 11 M2_M1_CDNS_40661956134249
* cell instance $342 m90 *1 51.02,104.985
X$342 5 9 M2_M1_CDNS_40661956134249
* cell instance $343 r0 *1 13.79,107.425
X$343 5 14 M2_M1_CDNS_40661956134249
* cell instance $344 r0 *1 25.64,107.425
X$344 5 13 M2_M1_CDNS_40661956134249
* cell instance $345 m90 *1 39.17,107.425
X$345 5 11 M2_M1_CDNS_40661956134249
* cell instance $346 m90 *1 51.02,107.425
X$346 5 9 M2_M1_CDNS_40661956134249
* cell instance $347 r0 *1 13.79,109.865
X$347 5 14 M2_M1_CDNS_40661956134249
* cell instance $348 r0 *1 25.64,109.865
X$348 5 13 M2_M1_CDNS_40661956134249
* cell instance $349 m90 *1 39.17,109.865
X$349 5 11 M2_M1_CDNS_40661956134249
* cell instance $350 m90 *1 51.02,109.865
X$350 5 9 M2_M1_CDNS_40661956134249
* cell instance $351 r0 *1 13.79,112.305
X$351 5 14 M2_M1_CDNS_40661956134249
* cell instance $352 r0 *1 25.64,112.305
X$352 5 13 M2_M1_CDNS_40661956134249
* cell instance $353 m90 *1 39.17,112.305
X$353 5 11 M2_M1_CDNS_40661956134249
* cell instance $354 m90 *1 51.02,112.305
X$354 5 9 M2_M1_CDNS_40661956134249
* cell instance $355 r0 *1 13.79,114.745
X$355 5 14 M2_M1_CDNS_40661956134249
* cell instance $356 r0 *1 25.64,114.745
X$356 5 13 M2_M1_CDNS_40661956134249
* cell instance $357 m90 *1 39.17,114.745
X$357 5 11 M2_M1_CDNS_40661956134249
* cell instance $358 m90 *1 51.02,114.745
X$358 5 9 M2_M1_CDNS_40661956134249
* cell instance $359 r0 *1 13.79,119.625
X$359 5 14 M2_M1_CDNS_40661956134249
* cell instance $360 r0 *1 25.64,119.625
X$360 5 13 M2_M1_CDNS_40661956134249
* cell instance $361 m90 *1 39.17,119.625
X$361 5 11 M2_M1_CDNS_40661956134249
* cell instance $362 m90 *1 51.02,119.625
X$362 5 9 M2_M1_CDNS_40661956134249
* cell instance $363 r0 *1 13.79,97.665
X$363 5 14 M2_M1_CDNS_40661956134249
* cell instance $364 r0 *1 25.64,97.665
X$364 5 13 M2_M1_CDNS_40661956134249
* cell instance $365 m90 *1 39.17,97.665
X$365 5 11 M2_M1_CDNS_40661956134249
* cell instance $366 m90 *1 51.02,97.665
X$366 5 9 M2_M1_CDNS_40661956134249
* cell instance $367 r0 *1 13.79,7.145
X$367 5 14 M2_M1_CDNS_40661956134249
* cell instance $368 r0 *1 25.64,7.145
X$368 5 13 M2_M1_CDNS_40661956134249
* cell instance $369 m90 *1 39.17,7.145
X$369 5 11 M2_M1_CDNS_40661956134249
* cell instance $370 m90 *1 51.02,7.145
X$370 5 9 M2_M1_CDNS_40661956134249
* cell instance $371 r0 *1 13.79,12.025
X$371 5 14 M2_M1_CDNS_40661956134249
* cell instance $372 r0 *1 25.64,12.025
X$372 5 13 M2_M1_CDNS_40661956134249
* cell instance $373 m90 *1 39.17,12.025
X$373 5 11 M2_M1_CDNS_40661956134249
* cell instance $374 m90 *1 51.02,12.025
X$374 5 9 M2_M1_CDNS_40661956134249
* cell instance $375 r0 *1 13.79,14.465
X$375 5 14 M2_M1_CDNS_40661956134249
* cell instance $376 r0 *1 25.64,14.465
X$376 5 13 M2_M1_CDNS_40661956134249
* cell instance $377 m90 *1 39.17,14.465
X$377 5 11 M2_M1_CDNS_40661956134249
* cell instance $378 m90 *1 51.02,14.465
X$378 5 9 M2_M1_CDNS_40661956134249
* cell instance $379 r0 *1 13.79,16.905
X$379 5 14 M2_M1_CDNS_40661956134249
* cell instance $380 r0 *1 25.64,16.905
X$380 5 13 M2_M1_CDNS_40661956134249
* cell instance $381 m90 *1 39.17,16.905
X$381 5 11 M2_M1_CDNS_40661956134249
* cell instance $382 m90 *1 51.02,16.905
X$382 5 9 M2_M1_CDNS_40661956134249
* cell instance $383 r0 *1 13.79,19.345
X$383 5 14 M2_M1_CDNS_40661956134249
* cell instance $384 r0 *1 25.64,19.345
X$384 5 13 M2_M1_CDNS_40661956134249
* cell instance $385 m90 *1 39.17,19.345
X$385 5 11 M2_M1_CDNS_40661956134249
* cell instance $386 m90 *1 51.02,19.345
X$386 5 9 M2_M1_CDNS_40661956134249
* cell instance $387 r0 *1 13.79,21.785
X$387 5 14 M2_M1_CDNS_40661956134249
* cell instance $388 r0 *1 25.64,21.785
X$388 5 13 M2_M1_CDNS_40661956134249
* cell instance $389 m90 *1 39.17,21.785
X$389 5 11 M2_M1_CDNS_40661956134249
* cell instance $390 m90 *1 51.02,21.785
X$390 5 9 M2_M1_CDNS_40661956134249
* cell instance $391 r0 *1 13.79,24.225
X$391 5 14 M2_M1_CDNS_40661956134249
* cell instance $392 r0 *1 25.64,24.225
X$392 5 13 M2_M1_CDNS_40661956134249
* cell instance $393 m90 *1 39.17,24.225
X$393 5 11 M2_M1_CDNS_40661956134249
* cell instance $394 m90 *1 51.02,24.225
X$394 5 9 M2_M1_CDNS_40661956134249
* cell instance $395 r0 *1 13.79,26.665
X$395 5 14 M2_M1_CDNS_40661956134249
* cell instance $396 r0 *1 25.64,26.665
X$396 5 13 M2_M1_CDNS_40661956134249
* cell instance $397 m90 *1 39.17,26.665
X$397 5 11 M2_M1_CDNS_40661956134249
* cell instance $398 m90 *1 51.02,26.665
X$398 5 9 M2_M1_CDNS_40661956134249
* cell instance $399 r0 *1 13.79,58.465
X$399 5 14 M2_M1_CDNS_40661956134249
* cell instance $400 r0 *1 25.64,58.465
X$400 5 13 M2_M1_CDNS_40661956134249
* cell instance $401 m90 *1 39.17,58.465
X$401 5 11 M2_M1_CDNS_40661956134249
* cell instance $402 m90 *1 51.02,58.465
X$402 5 9 M2_M1_CDNS_40661956134249
* cell instance $403 r0 *1 13.79,9.585
X$403 5 14 M2_M1_CDNS_40661956134249
* cell instance $404 r0 *1 25.64,9.585
X$404 5 13 M2_M1_CDNS_40661956134249
* cell instance $405 m90 *1 39.17,9.585
X$405 5 11 M2_M1_CDNS_40661956134249
* cell instance $406 m90 *1 51.02,9.585
X$406 5 9 M2_M1_CDNS_40661956134249
* cell instance $407 r0 *1 13.79,80.505
X$407 5 14 M2_M1_CDNS_40661956134249
* cell instance $408 r0 *1 25.64,80.505
X$408 5 13 M2_M1_CDNS_40661956134249
* cell instance $409 m90 *1 39.17,80.505
X$409 5 11 M2_M1_CDNS_40661956134249
* cell instance $410 m90 *1 51.02,80.505
X$410 5 9 M2_M1_CDNS_40661956134249
* cell instance $411 r0 *1 13.79,51.145
X$411 5 14 M2_M1_CDNS_40661956134249
* cell instance $412 r0 *1 25.64,51.145
X$412 5 13 M2_M1_CDNS_40661956134249
* cell instance $413 m90 *1 39.17,51.145
X$413 5 11 M2_M1_CDNS_40661956134249
* cell instance $414 m90 *1 51.02,51.145
X$414 5 9 M2_M1_CDNS_40661956134249
* cell instance $415 r0 *1 13.79,53.585
X$415 5 14 M2_M1_CDNS_40661956134249
* cell instance $416 r0 *1 25.64,53.585
X$416 5 13 M2_M1_CDNS_40661956134249
* cell instance $417 m90 *1 39.17,53.585
X$417 5 11 M2_M1_CDNS_40661956134249
* cell instance $418 m90 *1 51.02,53.585
X$418 5 9 M2_M1_CDNS_40661956134249
* cell instance $419 r0 *1 13.79,56.025
X$419 5 14 M2_M1_CDNS_40661956134249
* cell instance $420 r0 *1 25.64,56.025
X$420 5 13 M2_M1_CDNS_40661956134249
* cell instance $421 m90 *1 39.17,56.025
X$421 5 11 M2_M1_CDNS_40661956134249
* cell instance $422 m90 *1 51.02,56.025
X$422 5 9 M2_M1_CDNS_40661956134249
* cell instance $423 r0 *1 13.79,48.705
X$423 5 14 M2_M1_CDNS_40661956134249
* cell instance $424 r0 *1 25.64,48.705
X$424 5 13 M2_M1_CDNS_40661956134249
* cell instance $425 m90 *1 39.17,48.705
X$425 5 11 M2_M1_CDNS_40661956134249
* cell instance $426 m90 *1 51.02,48.705
X$426 5 9 M2_M1_CDNS_40661956134249
* cell instance $427 r0 *1 13.79,4.135
X$427 5 14 M2_M1_CDNS_40661956134247
* cell instance $428 r0 *1 25.64,4.135
X$428 5 13 M2_M1_CDNS_40661956134247
* cell instance $429 m90 *1 39.17,4.135
X$429 5 11 M2_M1_CDNS_40661956134247
* cell instance $430 m90 *1 51.02,4.135
X$430 5 9 M2_M1_CDNS_40661956134247
* cell instance $431 r0 *1 13.79,122.635
X$431 5 14 M2_M1_CDNS_40661956134247
* cell instance $432 r0 *1 25.64,122.635
X$432 5 13 M2_M1_CDNS_40661956134247
* cell instance $433 m90 *1 39.17,122.635
X$433 5 11 M2_M1_CDNS_40661956134247
* cell instance $434 m90 *1 51.02,122.635
X$434 5 9 M2_M1_CDNS_40661956134247
* cell instance $435 r0 *1 13.79,34.025
X$435 5 14 M2_M1_CDNS_40661956134255
* cell instance $436 r0 *1 25.64,34.025
X$436 5 13 M2_M1_CDNS_40661956134255
* cell instance $437 m90 *1 39.17,34.025
X$437 5 11 M2_M1_CDNS_40661956134255
* cell instance $438 m90 *1 51.02,34.025
X$438 5 9 M2_M1_CDNS_40661956134255
* cell instance $439 r0 *1 3.885,63.385
X$439 5 6 M2_M1_CDNS_40661956134268
.ENDS nmos_clamp_20_50_4_DVSS

* cell M2_M1_CDNS_40661956134232
* pin
* pin
.SUBCKT M2_M1_CDNS_40661956134232 1 2
.ENDS M2_M1_CDNS_40661956134232

* cell M2_M1_CDNS_40661956134233
* pin
* pin
.SUBCKT M2_M1_CDNS_40661956134233 1 2
.ENDS M2_M1_CDNS_40661956134233

* cell M2_M1_CDNS_40661956134237
* pin
* pin
.SUBCKT M2_M1_CDNS_40661956134237 1 2
.ENDS M2_M1_CDNS_40661956134237

* cell M2_M1_CDNS_40661956134238
* pin
* pin
.SUBCKT M2_M1_CDNS_40661956134238 1 2
.ENDS M2_M1_CDNS_40661956134238

* cell M2_M1_CDNS_40661956134242
* pin
* pin
.SUBCKT M2_M1_CDNS_40661956134242 1 2
.ENDS M2_M1_CDNS_40661956134242

* cell M1_PSUB_CDNS_40661956134243
* pin
* pin
.SUBCKT M1_PSUB_CDNS_40661956134243 1 2
.ENDS M1_PSUB_CDNS_40661956134243

* cell M1_PSUB_CDNS_40661956134244
* pin
* pin
.SUBCKT M1_PSUB_CDNS_40661956134244 1 2
.ENDS M1_PSUB_CDNS_40661956134244

* cell M2_M1_CDNS_40661956134245
* pin
* pin
.SUBCKT M2_M1_CDNS_40661956134245 1 2
.ENDS M2_M1_CDNS_40661956134245

* cell M1_PSUB_CDNS_4066195613410
* pin
* pin
.SUBCKT M1_PSUB_CDNS_4066195613410 1 2
.ENDS M1_PSUB_CDNS_4066195613410

* cell M1_PSUB_CDNS_4066195613413
* pin
* pin
.SUBCKT M1_PSUB_CDNS_4066195613413 1 2
.ENDS M1_PSUB_CDNS_4066195613413

* cell M1_PSUB_CDNS_4066195613412
* pin
* pin
.SUBCKT M1_PSUB_CDNS_4066195613412 1 2
.ENDS M1_PSUB_CDNS_4066195613412

* cell M1_PSUB_CDNS_4066195613417
* pin
* pin
.SUBCKT M1_PSUB_CDNS_4066195613417 1 2
.ENDS M1_PSUB_CDNS_4066195613417

* cell M1_PSUB_CDNS_4066195613416
* pin
* pin
.SUBCKT M1_PSUB_CDNS_4066195613416 1 2
.ENDS M1_PSUB_CDNS_4066195613416

* cell M1_PSUB_CDNS_4066195613415
* pin
* pin
.SUBCKT M1_PSUB_CDNS_4066195613415 1 2
.ENDS M1_PSUB_CDNS_4066195613415

* cell M1_PSUB_CDNS_4066195613414
* pin
* pin
.SUBCKT M1_PSUB_CDNS_4066195613414 1 2
.ENDS M1_PSUB_CDNS_4066195613414

* cell power_via_cor_5
* pin
* pin
* pin
* pin
* pin
* pin
* pin
* pin
* pin
* pin
* pin
* pin
* pin
* pin
* pin
* pin
* pin
* pin
* pin
* pin
* pin
* pin
* pin
* pin
* pin
* pin
* pin
* pin
* pin
* pin
* pin
* pin
* pin
* pin
* pin
* pin
* pin
* pin
* pin
* pin
* pin
* pin
* pin
* pin
* pin
* pin
* pin
* pin
* pin
* pin
* pin
* pin
* pin
* pin
* pin
* pin
* pin
* pin
* pin
* pin
* pin
* pin
* pin
* pin
* pin
* pin
* pin
* pin
* pin
* pin
* pin
* pin
* pin
* pin
* pin
* pin
* pin
* pin
* pin
* pin
* pin
* pin
* pin
* pin
* pin
* pin
* pin
* pin
* pin
* pin
* pin
* pin
* pin
* pin
* pin
* pin
* pin
* pin
* pin
* pin
* pin
* pin
* pin
* pin
* pin
* pin
* pin
* pin
* pin
* pin
* pin
* pin
* pin
* pin
* pin
* pin
* pin
* pin
* pin
* pin
* pin
* pin
* pin
* pin
* pin
* pin
* pin
* pin
* pin
* pin
* pin
* pin
* pin
* pin
* pin
* pin
* pin
* pin
* pin
* pin
* pin
* pin
* pin
* pin
* pin
* pin
* pin
* pin
* pin
* pin
* pin
* pin
* pin
* pin
* pin
* pin
* pin
* pin
* pin
* pin
* pin
* pin
* pin
* pin
* pin
* pin
* pin
* pin
* pin
* pin
* pin
* pin
* pin
* pin
* pin
* pin
* pin
* pin
* pin
* pin
* pin
* pin
* pin
* pin
* pin
* pin
* pin
* pin
* pin
* pin
* pin
* pin
* pin
* pin
* pin
* pin
* pin
* pin
* pin
* pin
* pin
* pin
* pin
* pin
* pin
* pin
* pin
* pin
* pin
* pin
* pin
* pin
* pin
* pin
* pin
* pin
* pin
* pin
* pin
* pin
* pin
* pin
* pin
* pin
* pin
* pin
* pin
* pin
* pin
* pin
* pin
* pin
* pin
* pin
* pin
* pin
* pin
* pin
* pin
* pin
* pin
* pin
* pin
* pin
* pin
* pin
* pin
* pin
* pin
* pin
* pin
* pin
* pin
* pin
* pin
* pin
* pin
* pin
* pin
* pin
* pin
* pin
* pin
* pin
* pin
* pin
* pin
* pin
* pin
* pin
* pin
* pin
* pin
* pin
* pin
* pin
* pin
* pin
* pin
* pin
* pin
* pin
* pin
* pin
* pin
* pin
* pin
* pin
* pin
* pin
* pin
* pin
.SUBCKT power_via_cor_5 1 2 3 4 5 6 7 8 9 10 11 12 13 14 15 16 17 18 19 20 21
+ 22 23 24 25 26 27 28 29 30 31 32 33 34 35 36 37 38 39 40 41 42 43 44 45 46 47
+ 48 49 50 51 52 53 54 55 56 57 58 59 60 61 62 63 64 65 66 67 68 69 70 71 72 73
+ 74 75 76 77 78 79 80 81 82 83 84 85 86 87 88 89 90 91 92 93 94 95 96 97 98 99
+ 100 101 102 103 104 105 106 107 108 109 110 111 112 113 114 115 116 117 118
+ 119 120 121 122 123 124 125 126 127 128 129 130 131 132 133 134 135 136 137
+ 138 139 140 141 142 143 144 145 146 147 148 149 150 151 152 153 154 155 156
+ 157 158 159 160 161 162 163 164 165 166 167 168 169 170 171 172 173 174 175
+ 176 177 178 179 180 181 182 183 184 185 186 187 188 189 190 191 192 193 194
+ 195 196 197 198 199 200 201 202 203 204 205 206 207 208 209 210 211 212 213
+ 214 215 216 217 218 219 220 221 222 223 224 225 226 227 228 229 230 231 232
+ 233 234 235 236 237 238 239 240 241 242 243 244 245 246 247 248 249 250 251
+ 252 253 254 255 256 257 258 259 260 261 262 263 264 265 266 267 268 269 270
+ 271 272 273 274 275 276 277 278 279 280 281 282 283 284 285 286 287 288 289
+ 290 293 294
* cell instance $1 r0 *1 12.775,174.94
X$1 3 1 M3_M2_CDNS_40661956134157
* cell instance $2 r0 *1 5.915,158.77
X$2 4 2 M3_M2_CDNS_40661956134157
* cell instance $3 r0 *1 20.835,168.575
X$3 6 5 M3_M2_CDNS_40661956134158
* cell instance $4 r0 *1 19.595,169.21
X$4 9 7 M3_M2_CDNS_40661956134159
* cell instance $5 r0 *1 20.215,168.855
X$5 10 8 M3_M2_CDNS_40661956134159
* cell instance $6 r0 *1 18.975,169.42
X$6 12 11 M3_M2_CDNS_40661956134160
* cell instance $7 r0 *1 18.355,169.625
X$7 14 13 M3_M2_CDNS_40661956134161
* cell instance $8 r0 *1 17.735,169.98
X$8 16 15 M3_M2_CDNS_40661956134162
* cell instance $9 r0 *1 6.535,158.15
X$9 31 17 M3_M2_CDNS_40661956134163
* cell instance $10 r0 *1 9.635,155.05
X$10 32 18 M3_M2_CDNS_40661956134163
* cell instance $11 r0 *1 10.255,154.43
X$11 33 19 M3_M2_CDNS_40661956134163
* cell instance $12 r0 *1 13.395,174.32
X$12 34 20 M3_M2_CDNS_40661956134163
* cell instance $13 r0 *1 15.255,172.46
X$13 35 21 M3_M2_CDNS_40661956134163
* cell instance $14 r0 *1 15.875,171.84
X$14 36 22 M3_M2_CDNS_40661956134163
* cell instance $15 r0 *1 17.115,170.6
X$15 37 23 M3_M2_CDNS_40661956134163
* cell instance $16 r0 *1 7.155,157.53
X$16 38 24 M3_M2_CDNS_40661956134163
* cell instance $17 r0 *1 8.395,156.29
X$17 39 25 M3_M2_CDNS_40661956134163
* cell instance $18 r0 *1 9.015,155.67
X$18 40 26 M3_M2_CDNS_40661956134163
* cell instance $19 r0 *1 7.775,156.91
X$19 41 27 M3_M2_CDNS_40661956134163
* cell instance $20 r0 *1 14.015,173.7
X$20 42 28 M3_M2_CDNS_40661956134163
* cell instance $21 r0 *1 14.635,173.08
X$21 43 29 M3_M2_CDNS_40661956134163
* cell instance $22 r0 *1 16.495,171.22
X$22 44 30 M3_M2_CDNS_40661956134163
* cell instance $23 r0 *1 5.66,221.795
X$23 47 45 M3_M2_CDNS_40661956134164
* cell instance $24 r0 *1 5.775,142.055
X$24 48 46 M3_M2_CDNS_40661956134164
* cell instance $25 r0 *1 7.015,140.815
X$25 58 49 M3_M2_CDNS_40661956134165
* cell instance $26 r0 *1 6.395,141.435
X$26 59 50 M3_M2_CDNS_40661956134165
* cell instance $27 r0 *1 6.9,220.555
X$27 60 51 M3_M2_CDNS_40661956134165
* cell instance $28 r0 *1 9.38,218.075
X$28 61 52 M3_M2_CDNS_40661956134165
* cell instance $29 r0 *1 10,217.455
X$29 62 53 M3_M2_CDNS_40661956134165
* cell instance $30 r0 *1 8.76,218.695
X$30 63 54 M3_M2_CDNS_40661956134165
* cell instance $31 r0 *1 8.14,219.315
X$31 64 55 M3_M2_CDNS_40661956134165
* cell instance $32 r0 *1 7.52,219.935
X$32 65 56 M3_M2_CDNS_40661956134165
* cell instance $33 r0 *1 6.28,221.175
X$33 66 57 M3_M2_CDNS_40661956134165
* cell instance $34 r0 *1 57.875,71.48
X$34 84 67 M3_M2_CDNS_40661956134156
* cell instance $35 r0 *1 48.235,39.48
X$35 85 68 M3_M2_CDNS_40661956134156
* cell instance $36 r0 *1 48.235,23.48
X$36 86 69 M3_M2_CDNS_40661956134156
* cell instance $37 r0 *1 48.235,7.48
X$37 87 70 M3_M2_CDNS_40661956134156
* cell instance $38 r0 *1 57.875,87.48
X$38 88 71 M3_M2_CDNS_40661956134156
* cell instance $39 r0 *1 48.235,167.48
X$39 89 72 M3_M2_CDNS_40661956134156
* cell instance $40 r0 *1 57.875,151.48
X$40 90 73 M3_M2_CDNS_40661956134156
* cell instance $41 r0 *1 57.875,103.48
X$41 91 74 M3_M2_CDNS_40661956134156
* cell instance $42 r0 *1 26.655,87.48
X$42 92 75 M3_M2_CDNS_40661956134156
* cell instance $43 r0 *1 26.655,151.48
X$43 93 76 M3_M2_CDNS_40661956134156
* cell instance $44 r0 *1 26.655,71.48
X$44 94 77 M3_M2_CDNS_40661956134156
* cell instance $45 r0 *1 17.015,39.48
X$45 95 78 M3_M2_CDNS_40661956134156
* cell instance $46 r0 *1 17.015,23.48
X$46 96 79 M3_M2_CDNS_40661956134156
* cell instance $47 r0 *1 17.015,7.48
X$47 97 80 M3_M2_CDNS_40661956134156
* cell instance $48 r0 *1 26.655,119.48
X$48 98 81 M3_M2_CDNS_40661956134156
* cell instance $49 r0 *1 57.875,119.48
X$49 99 82 M3_M2_CDNS_40661956134156
* cell instance $50 r0 *1 26.655,103.48
X$50 100 83 M3_M2_CDNS_40661956134156
* cell instance $51 r0 *1 66.88,23.48
X$51 118 101 M3_M2_CDNS_40661956134155
* cell instance $52 r0 *1 66.88,7.48
X$52 119 102 M3_M2_CDNS_40661956134155
* cell instance $53 r0 *1 40.43,151.48
X$53 120 103 M3_M2_CDNS_40661956134155
* cell instance $54 r0 *1 40.43,71.48
X$54 121 104 M3_M2_CDNS_40661956134155
* cell instance $55 r0 *1 66.88,39.48
X$55 122 105 M3_M2_CDNS_40661956134155
* cell instance $56 r0 *1 40.43,87.48
X$56 123 106 M3_M2_CDNS_40661956134155
* cell instance $57 r0 *1 40.43,103.48
X$57 124 107 M3_M2_CDNS_40661956134155
* cell instance $58 r0 *1 40.43,119.48
X$58 125 108 M3_M2_CDNS_40661956134155
* cell instance $59 r0 *1 66.88,167.48
X$59 126 109 M3_M2_CDNS_40661956134155
* cell instance $60 r0 *1 34.46,167.48
X$60 127 110 M3_M2_CDNS_40661956134155
* cell instance $61 r0 *1 34.46,23.48
X$61 128 111 M3_M2_CDNS_40661956134155
* cell instance $62 r0 *1 34.46,7.48
X$62 129 112 M3_M2_CDNS_40661956134155
* cell instance $63 r0 *1 8.01,119.48
X$63 130 113 M3_M2_CDNS_40661956134155
* cell instance $64 r0 *1 8.01,103.48
X$64 131 114 M3_M2_CDNS_40661956134155
* cell instance $65 r0 *1 8.01,87.48
X$65 132 115 M3_M2_CDNS_40661956134155
* cell instance $66 r0 *1 8.01,71.48
X$66 133 116 M3_M2_CDNS_40661956134155
* cell instance $67 r0 *1 34.46,39.48
X$67 134 117 M3_M2_CDNS_40661956134155
* cell instance $68 r0 *1 22.49,215.95
X$68 138 135 M3_M2_CDNS_40661956134120
* cell instance $69 r0 *1 22.49,227.445
X$69 139 136 M3_M2_CDNS_40661956134120
* cell instance $70 r0 *1 22.49,204.775
X$70 140 137 M3_M2_CDNS_40661956134120
* cell instance $71 r0 *1 9.495,139.455
X$71 143 141 M3_M2_CDNS_40661956134121
* cell instance $72 r0 *1 10.115,139.445
X$72 144 142 M3_M2_CDNS_40661956134121
* cell instance $73 r0 *1 30.55,219.385
X$73 193 145 M3_M2_CDNS_40661956134122
* cell instance $74 r0 *1 26.21,223.725
X$74 194 146 M3_M2_CDNS_40661956134122
* cell instance $75 r0 *1 25.59,212.85
X$75 195 147 M3_M2_CDNS_40661956134122
* cell instance $76 r0 *1 24.35,214.09
X$76 196 148 M3_M2_CDNS_40661956134122
* cell instance $77 r0 *1 34.59,226.7
X$77 197 149 M3_M2_CDNS_40661956134122
* cell instance $78 r0 *1 33.97,227.32
X$78 198 150 M3_M2_CDNS_40661956134122
* cell instance $79 r0 *1 33.35,227.94
X$79 199 151 M3_M2_CDNS_40661956134122
* cell instance $80 r0 *1 23.11,215.33
X$80 200 152 M3_M2_CDNS_40661956134122
* cell instance $81 r0 *1 24.97,224.965
X$81 201 153 M3_M2_CDNS_40661956134122
* cell instance $82 r0 *1 26.83,223.105
X$82 202 154 M3_M2_CDNS_40661956134122
* cell instance $83 r0 *1 32.11,229.18
X$83 203 155 M3_M2_CDNS_40661956134122
* cell instance $84 r0 *1 25.59,224.345
X$84 204 156 M3_M2_CDNS_40661956134122
* cell instance $85 r0 *1 28.69,198.575
X$85 205 157 M3_M2_CDNS_40661956134122
* cell instance $86 r0 *1 29.31,197.955
X$86 206 158 M3_M2_CDNS_40661956134122
* cell instance $87 r0 *1 29.93,197.335
X$87 207 159 M3_M2_CDNS_40661956134122
* cell instance $88 r0 *1 30.55,196.715
X$88 208 160 M3_M2_CDNS_40661956134122
* cell instance $89 r0 *1 23.11,204.155
X$89 209 161 M3_M2_CDNS_40661956134122
* cell instance $90 r0 *1 23.73,203.535
X$90 210 162 M3_M2_CDNS_40661956134122
* cell instance $91 r0 *1 24.35,202.915
X$91 211 163 M3_M2_CDNS_40661956134122
* cell instance $92 r0 *1 27.45,222.485
X$92 212 164 M3_M2_CDNS_40661956134122
* cell instance $93 r0 *1 25.59,201.675
X$93 213 165 M3_M2_CDNS_40661956134122
* cell instance $94 r0 *1 26.21,201.055
X$94 214 166 M3_M2_CDNS_40661956134122
* cell instance $95 r0 *1 26.83,200.435
X$95 215 167 M3_M2_CDNS_40661956134122
* cell instance $96 r0 *1 27.45,199.815
X$96 216 168 M3_M2_CDNS_40661956134122
* cell instance $97 r0 *1 28.07,199.195
X$97 217 169 M3_M2_CDNS_40661956134122
* cell instance $98 r0 *1 28.07,210.37
X$98 218 170 M3_M2_CDNS_40661956134122
* cell instance $99 r0 *1 7.635,140.44
X$99 219 171 M3_M2_CDNS_40661956134122
* cell instance $100 r0 *1 32.73,228.56
X$100 220 172 M3_M2_CDNS_40661956134122
* cell instance $101 r0 *1 24.97,202.295
X$101 221 173 M3_M2_CDNS_40661956134122
* cell instance $102 r0 *1 29.93,208.51
X$102 222 174 M3_M2_CDNS_40661956134122
* cell instance $103 r0 *1 30.55,207.89
X$103 223 175 M3_M2_CDNS_40661956134122
* cell instance $104 r0 *1 26.83,211.61
X$104 224 176 M3_M2_CDNS_40661956134122
* cell instance $105 r0 *1 36.45,224.84
X$105 225 177 M3_M2_CDNS_40661956134122
* cell instance $106 r0 *1 27.45,210.99
X$106 226 178 M3_M2_CDNS_40661956134122
* cell instance $107 r0 *1 35.21,226.08
X$107 227 179 M3_M2_CDNS_40661956134122
* cell instance $108 r0 *1 28.69,209.75
X$108 228 180 M3_M2_CDNS_40661956134122
* cell instance $109 r0 *1 29.93,220.005
X$109 229 181 M3_M2_CDNS_40661956134122
* cell instance $110 r0 *1 29.31,220.625
X$110 230 182 M3_M2_CDNS_40661956134122
* cell instance $111 r0 *1 23.73,226.205
X$111 231 183 M3_M2_CDNS_40661956134122
* cell instance $112 r0 *1 35.83,225.46
X$112 232 184 M3_M2_CDNS_40661956134122
* cell instance $113 r0 *1 24.35,225.585
X$113 233 185 M3_M2_CDNS_40661956134122
* cell instance $114 r0 *1 26.21,212.23
X$114 234 186 M3_M2_CDNS_40661956134122
* cell instance $115 r0 *1 29.31,209.13
X$115 235 187 M3_M2_CDNS_40661956134122
* cell instance $116 r0 *1 28.07,221.865
X$116 236 188 M3_M2_CDNS_40661956134122
* cell instance $117 r0 *1 23.73,214.71
X$117 237 189 M3_M2_CDNS_40661956134122
* cell instance $118 r0 *1 23.11,226.825
X$118 238 190 M3_M2_CDNS_40661956134122
* cell instance $119 r0 *1 24.97,213.47
X$119 239 191 M3_M2_CDNS_40661956134122
* cell instance $120 r0 *1 28.69,221.245
X$120 240 192 M3_M2_CDNS_40661956134122
* cell instance $121 r0 *1 8.255,140.18
X$121 242 241 M3_M2_CDNS_40661956134123
* cell instance $122 r0 *1 8.875,139.715
X$122 244 243 M3_M2_CDNS_40661956134124
* cell instance $123 r0 *1 66.88,131.48
X$123 245 268 M3_M2_CDNS_40661956134118
* cell instance $124 r0 *1 66.88,219.48
X$124 246 269 M3_M2_CDNS_40661956134118
* cell instance $125 r0 *1 34.46,131.48
X$125 247 270 M3_M2_CDNS_40661956134118
* cell instance $126 r0 *1 40.43,51.48
X$126 248 271 M3_M2_CDNS_40661956134118
* cell instance $127 r0 *1 40.43,195.48
X$127 249 272 M3_M2_CDNS_40661956134118
* cell instance $128 r0 *1 40.43,203.48
X$128 250 273 M3_M2_CDNS_40661956134118
* cell instance $129 r0 *1 40.43,139.48
X$129 251 274 M3_M2_CDNS_40661956134118
* cell instance $130 r0 *1 40.43,211.48
X$130 252 275 M3_M2_CDNS_40661956134118
* cell instance $131 r0 *1 66.88,59.48
X$131 253 276 M3_M2_CDNS_40661956134118
* cell instance $132 r0 *1 34.46,59.48
X$132 254 277 M3_M2_CDNS_40661956134118
* cell instance $133 r0 *1 8.01,51.48
X$133 255 278 M3_M2_CDNS_40661956134118
* cell instance $134 r0 *1 17.015,59.48
X$134 256 279 M3_M2_CDNS_40661956134119
* cell instance $135 r0 *1 26.655,139.48
X$135 257 280 M3_M2_CDNS_40661956134119
* cell instance $136 r0 *1 17.015,131.48
X$136 258 281 M3_M2_CDNS_40661956134119
* cell instance $137 r0 *1 48.235,59.48
X$137 259 282 M3_M2_CDNS_40661956134119
* cell instance $138 r0 *1 26.655,51.48
X$138 260 283 M3_M2_CDNS_40661956134119
* cell instance $139 r0 *1 57.875,195.48
X$139 261 284 M3_M2_CDNS_40661956134119
* cell instance $140 r0 *1 57.875,203.48
X$140 262 285 M3_M2_CDNS_40661956134119
* cell instance $141 r0 *1 57.875,211.48
X$141 263 286 M3_M2_CDNS_40661956134119
* cell instance $142 r0 *1 48.235,219.48
X$142 264 287 M3_M2_CDNS_40661956134119
* cell instance $143 r0 *1 57.875,51.48
X$143 265 288 M3_M2_CDNS_40661956134119
* cell instance $144 r0 *1 48.235,131.48
X$144 266 289 M3_M2_CDNS_40661956134119
* cell instance $145 r0 *1 57.875,139.48
X$145 267 290 M3_M2_CDNS_40661956134119
* cell instance $146 r0 *1 73.975,179.48
X$146 293 291 M3_M2_CDNS_40661956134114
* cell instance $147 r0 *1 73.975,179.48
X$147 293 291 M2_M1_CDNS_40661956134115
* cell instance $148 r0 *1 73.975,251.48
X$148 294 292 M3_M2_CDNS_40661956134114
* cell instance $149 r0 *1 73.975,251.48
X$149 294 292 M2_M1_CDNS_40661956134115
.ENDS power_via_cor_5

* cell power_via_cor_3
* pin
* pin
* pin
* pin
* pin
* pin
* pin
* pin
* pin
* pin
* pin
* pin
* pin
* pin
* pin
* pin
* pin
* pin
* pin
* pin
* pin
* pin
* pin
* pin
* pin
* pin
* pin
* pin
* pin
* pin
* pin
* pin
* pin
* pin
* pin
* pin
* pin
* pin
* pin
* pin
* pin
* pin
* pin
* pin
* pin
* pin
* pin
* pin
* pin
* pin
* pin
* pin
* pin
* pin
* pin
* pin
* pin
* pin
* pin
* pin
* pin
* pin
* pin
* pin
* pin
* pin
* pin
* pin
* pin
* pin
* pin
* pin
* pin
* pin
* pin
* pin
* pin
* pin
* pin
* pin
* pin
* pin
* pin
* pin
* pin
* pin
* pin
* pin
* pin
* pin
* pin
* pin
* pin
* pin
* pin
* pin
.SUBCKT power_via_cor_3 1 2 3 4 5 6 7 8 9 10 11 12 13 14 15 16 17 18 19 20 21
+ 22 23 24 25 26 27 28 29 30 31 32 33 34 35 36 37 38 39 40 41 42 43 44 45 46 47
+ 48 49 50 51 52 53 54 55 56 57 58 59 60 61 62 63 64 65 66 67 68 69 70 71 72 73
+ 74 75 76 77 78 79 80 81 82 83 84 85 86 87 88 89 90 91 92 93 94 97 98
* cell instance $1 r0 *1 57.875,243.49
X$1 4 1 M3_M2_CDNS_40661956134119
* cell instance $2 r0 *1 66.88,251.45
X$2 5 2 M3_M2_CDNS_40661956134118
* cell instance $3 r0 *1 45.75,260.755
X$3 6 3 M3_M2_CDNS_40661956134112
* cell instance $4 r0 *1 40.25,254.95
X$4 8 7 M3_M2_CDNS_40661956134113
* cell instance $5 r0 *1 32.96,274.22
X$5 10 9 M3_M2_CDNS_40661956134116
* cell instance $6 r0 *1 40.25,273.035
X$6 12 11 M3_M2_CDNS_40661956134117
* cell instance $7 r0 *1 12.775,191.855
X$7 16 13 M3_M2_CDNS_40661956134120
* cell instance $8 r0 *1 22.49,193.45
X$8 17 14 M3_M2_CDNS_40661956134120
* cell instance $9 r0 *1 5.66,210.28
X$9 18 15 M3_M2_CDNS_40661956134120
* cell instance $10 r0 *1 29.31,187.57
X$10 22 19 M3_M2_CDNS_40661956134121
* cell instance $11 r0 *1 29.93,187.465
X$11 23 20 M3_M2_CDNS_40661956134121
* cell instance $12 r0 *1 30.55,187.46
X$12 24 21 M3_M2_CDNS_40661956134121
* cell instance $13 r0 *1 27.45,188.49
X$13 53 25 M3_M2_CDNS_40661956134122
* cell instance $14 r0 *1 17.735,186.895
X$14 54 26 M3_M2_CDNS_40661956134122
* cell instance $15 r0 *1 18.975,185.655
X$15 55 27 M3_M2_CDNS_40661956134122
* cell instance $16 r0 *1 19.595,185.035
X$16 56 28 M3_M2_CDNS_40661956134122
* cell instance $17 r0 *1 18.355,186.275
X$17 57 29 M3_M2_CDNS_40661956134122
* cell instance $18 r0 *1 10,205.94
X$18 58 30 M3_M2_CDNS_40661956134122
* cell instance $19 r0 *1 9.38,206.56
X$19 59 31 M3_M2_CDNS_40661956134122
* cell instance $20 r0 *1 8.76,207.18
X$20 60 32 M3_M2_CDNS_40661956134122
* cell instance $21 r0 *1 8.14,207.8
X$21 61 33 M3_M2_CDNS_40661956134122
* cell instance $22 r0 *1 7.52,208.42
X$22 62 34 M3_M2_CDNS_40661956134122
* cell instance $23 r0 *1 6.9,209.04
X$23 63 35 M3_M2_CDNS_40661956134122
* cell instance $24 r0 *1 6.28,209.66
X$24 64 36 M3_M2_CDNS_40661956134122
* cell instance $25 r0 *1 26.21,189.73
X$25 65 37 M3_M2_CDNS_40661956134122
* cell instance $26 r0 *1 26.83,189.11
X$26 66 38 M3_M2_CDNS_40661956134122
* cell instance $27 r0 *1 15.255,189.375
X$27 67 39 M3_M2_CDNS_40661956134122
* cell instance $28 r0 *1 15.875,188.755
X$28 68 40 M3_M2_CDNS_40661956134122
* cell instance $29 r0 *1 16.495,188.135
X$29 69 41 M3_M2_CDNS_40661956134122
* cell instance $30 r0 *1 23.11,192.83
X$30 70 42 M3_M2_CDNS_40661956134122
* cell instance $31 r0 *1 17.115,187.515
X$31 71 43 M3_M2_CDNS_40661956134122
* cell instance $32 r0 *1 20.215,184.415
X$32 72 44 M3_M2_CDNS_40661956134122
* cell instance $33 r0 *1 20.835,183.795
X$33 73 45 M3_M2_CDNS_40661956134122
* cell instance $34 r0 *1 23.73,192.21
X$34 74 46 M3_M2_CDNS_40661956134122
* cell instance $35 r0 *1 24.35,191.59
X$35 75 47 M3_M2_CDNS_40661956134122
* cell instance $36 r0 *1 24.97,190.97
X$36 76 48 M3_M2_CDNS_40661956134122
* cell instance $37 r0 *1 25.59,190.35
X$37 77 49 M3_M2_CDNS_40661956134122
* cell instance $38 r0 *1 14.015,190.615
X$38 78 50 M3_M2_CDNS_40661956134122
* cell instance $39 r0 *1 13.395,191.235
X$39 79 51 M3_M2_CDNS_40661956134122
* cell instance $40 r0 *1 14.635,189.995
X$40 80 52 M3_M2_CDNS_40661956134122
* cell instance $41 r0 *1 28.07,188.15
X$41 82 81 M3_M2_CDNS_40661956134123
* cell instance $42 r0 *1 28.69,187.815
X$42 84 83 M3_M2_CDNS_40661956134124
* cell instance $43 r0 *1 66.88,179.48
X$43 85 90 M3_M2_CDNS_40661956134118
* cell instance $44 r0 *1 40.43,187.48
X$44 86 91 M3_M2_CDNS_40661956134118
* cell instance $45 r0 *1 34.46,179.48
X$45 87 92 M3_M2_CDNS_40661956134118
* cell instance $46 r0 *1 57.875,187.48
X$46 88 93 M3_M2_CDNS_40661956134119
* cell instance $47 r0 *1 48.235,179.48
X$47 89 94 M3_M2_CDNS_40661956134119
* cell instance $48 r0 *1 73.975,179.48
X$48 97 95 M2_M1_CDNS_40661956134115
* cell instance $49 r0 *1 73.975,179.48
X$49 97 95 M3_M2_CDNS_40661956134114
* cell instance $50 r0 *1 73.975,251.48
X$50 98 96 M2_M1_CDNS_40661956134115
* cell instance $51 r0 *1 73.975,251.48
X$51 98 96 M3_M2_CDNS_40661956134114
.ENDS power_via_cor_3

* cell top_routing_cor
* pin DVDD
* pin DVSS
* pin VDD
* pin VSS
.SUBCKT top_routing_cor 1 2 3 4
* net 1 DVDD
* net 2 DVSS
* net 3 VDD
* net 4 VSS
.ENDS top_routing_cor

* cell comp018green_esd_clamp_v5p0_2
* pin
* pin
* pin gf180mcu_gnd
* pin
* pin
* pin
* pin
* pin
* pin
* pin
* pin
.SUBCKT comp018green_esd_clamp_v5p0_2 1 4 10 11 12 13 14 15 16 17 18
* net 10 gf180mcu_gnd
* cell instance $1 r0 *1 20.645,130.03
X$1 1 5 2 10 nmos_6p0_CDNS_406619561347
* cell instance $2 r0 *1 33.275,130.03
X$2 20 1 6 1 6 1 6 1 7 7 7 7 7 7 nmos_6p0_CDNS_406619561346
* cell instance $3 r0 *1 25.955,130.03
X$3 20 1 7 1 7 1 7 1 5 5 5 5 5 5 nmos_6p0_CDNS_406619561346
* cell instance $4 m0 *1 -1.78,232.535
X$4 4 2 1 10 comp018green_esd_rc_v5p0
* cell instance $5 r0 *1 0.215,128.085
X$5 1 18 17 15 16 13 14 12 11 1 4 top_route_1
* cell instance $6 m0 *1 11.49,132.61
X$6 1 3 M1_PSUB_CDNS_40661956134125
* cell instance $7 m0 *1 53.32,132.61
X$7 1 3 M1_PSUB_CDNS_40661956134125
* cell instance $8 r0 *1 0,0
X$8 6 4 1 18 17 22 16 15 14 13 12 21 11 10 nmos_clamp_20_50_4
* cell instance $9 r0 *1 15.505,137.795
X$9 2 M1_POLY2_CDNS_40661956134127
* cell instance $10 r0 *1 20.71,135.54
X$10 2 M1_POLY2_CDNS_40661956134128
* cell instance $11 r0 *1 13.325,138.945
X$11 19 5 4 5 4 4 2 2 2 2 9 4 pmos_6p0_CDNS_406619561344
* cell instance $12 r0 *1 11.49,141.595
X$12 4 8 9 4 M1_NWELL_CDNS_40661956134133
* cell instance $13 r0 *1 53.32,141.595
X$13 4 8 9 4 M1_NWELL_CDNS_40661956134133
* cell instance $14 r0 *1 22.725,138.945
X$14 4 6 4 6 4 6 4 6 4 6 4 6 4 6 4 6 4 6 4 6 4 6 4 6 4 7 7 7 7 7 7 7 7 7 7 7 7
+ 7 7 7 7 7 7 7 7 7 7 7 7 9 4 pmos_6p0_CDNS_406619561342
* cell instance $15 r0 *1 18.205,138.945
X$15 19 7 4 4 7 5 5 5 9 4 pmos_6p0_CDNS_406619561343
* cell instance $16 r0 *1 32.405,145.185
X$16 4 8 9 4 M1_NWELL_CDNS_40661956134129
* cell instance $17 r0 *1 19.775,137.795
X$17 5 M1_POLY2_CDNS_40661956134130
* cell instance $18 r0 *1 29.355,136.18
X$18 5 M1_POLY2_CDNS_40661956134131
* cell instance $19 r0 *1 6.565,127.585
X$19 6 22 M2_M1_CDNS_40661956134126
* cell instance $20 r0 *1 58.245,127.585
X$20 6 21 M2_M1_CDNS_40661956134126
* cell instance $21 r0 *1 37.105,137.795
X$21 7 M1_POLY2_CDNS_40661956134132
* cell instance $22 r0 *1 36.675,136.18
X$22 7 M1_POLY2_CDNS_40661956134131
* device instance $1 r0 *1 13.675,141.445 pmos_6p0
M$1 5 2 4 4 pmos_6p0 L=0.7U W=5U AS=2.2P AD=1.3P PS=10.88U PD=5.52U
* device instance $2 r0 *1 14.895,141.445 pmos_6p0
M$2 4 2 5 4 pmos_6p0 L=0.7U W=5U AS=1.3P AD=1.3P PS=5.52U PD=5.52U
* device instance $3 r0 *1 16.115,141.445 pmos_6p0
M$3 5 2 4 4 pmos_6p0 L=0.7U W=5U AS=1.3P AD=1.3P PS=5.52U PD=5.52U
* device instance $4 r0 *1 17.335,141.445 pmos_6p0
M$4 4 2 5 4 pmos_6p0 L=0.7U W=5U AS=1.3P AD=1.3P PS=5.52U PD=5.52U
* device instance $5 r0 *1 18.555,141.445 pmos_6p0
M$5 7 5 4 4 pmos_6p0 L=0.7U W=5U AS=1.3P AD=1.3P PS=5.52U PD=5.52U
* device instance $6 r0 *1 19.775,141.445 pmos_6p0
M$6 4 5 7 4 pmos_6p0 L=0.7U W=5U AS=1.3P AD=1.3P PS=5.52U PD=5.52U
* device instance $7 r0 *1 20.995,141.445 pmos_6p0
M$7 7 5 4 4 pmos_6p0 L=0.7U W=5U AS=1.3P AD=2.2P PS=5.52U PD=10.88U
* device instance $8 r0 *1 23.075,141.445 pmos_6p0
M$8 6 7 4 4 pmos_6p0 L=0.7U W=5U AS=2.2P AD=1.3P PS=10.88U PD=5.52U
* device instance $9 r0 *1 24.295,141.445 pmos_6p0
M$9 4 7 6 4 pmos_6p0 L=0.7U W=5U AS=1.3P AD=1.3P PS=5.52U PD=5.52U
* device instance $10 r0 *1 25.515,141.445 pmos_6p0
M$10 6 7 4 4 pmos_6p0 L=0.7U W=5U AS=1.3P AD=1.3P PS=5.52U PD=5.52U
* device instance $11 r0 *1 26.735,141.445 pmos_6p0
M$11 4 7 6 4 pmos_6p0 L=0.7U W=5U AS=1.3P AD=1.3P PS=5.52U PD=5.52U
* device instance $12 r0 *1 27.955,141.445 pmos_6p0
M$12 6 7 4 4 pmos_6p0 L=0.7U W=5U AS=1.3P AD=1.3P PS=5.52U PD=5.52U
* device instance $13 r0 *1 29.175,141.445 pmos_6p0
M$13 4 7 6 4 pmos_6p0 L=0.7U W=5U AS=1.3P AD=1.3P PS=5.52U PD=5.52U
* device instance $14 r0 *1 30.395,141.445 pmos_6p0
M$14 6 7 4 4 pmos_6p0 L=0.7U W=5U AS=1.3P AD=1.3P PS=5.52U PD=5.52U
* device instance $15 r0 *1 31.615,141.445 pmos_6p0
M$15 4 7 6 4 pmos_6p0 L=0.7U W=5U AS=1.3P AD=1.3P PS=5.52U PD=5.52U
* device instance $16 r0 *1 32.835,141.445 pmos_6p0
M$16 6 7 4 4 pmos_6p0 L=0.7U W=5U AS=1.3P AD=1.3P PS=5.52U PD=5.52U
* device instance $17 r0 *1 34.055,141.445 pmos_6p0
M$17 4 7 6 4 pmos_6p0 L=0.7U W=5U AS=1.3P AD=1.3P PS=5.52U PD=5.52U
* device instance $18 r0 *1 35.275,141.445 pmos_6p0
M$18 6 7 4 4 pmos_6p0 L=0.7U W=5U AS=1.3P AD=1.3P PS=5.52U PD=5.52U
* device instance $19 r0 *1 36.495,141.445 pmos_6p0
M$19 4 7 6 4 pmos_6p0 L=0.7U W=5U AS=1.3P AD=1.3P PS=5.52U PD=5.52U
* device instance $20 r0 *1 37.715,141.445 pmos_6p0
M$20 6 7 4 4 pmos_6p0 L=0.7U W=5U AS=1.3P AD=1.3P PS=5.52U PD=5.52U
* device instance $21 r0 *1 38.935,141.445 pmos_6p0
M$21 4 7 6 4 pmos_6p0 L=0.7U W=5U AS=1.3P AD=1.3P PS=5.52U PD=5.52U
* device instance $22 r0 *1 40.155,141.445 pmos_6p0
M$22 6 7 4 4 pmos_6p0 L=0.7U W=5U AS=1.3P AD=1.3P PS=5.52U PD=5.52U
* device instance $23 r0 *1 41.375,141.445 pmos_6p0
M$23 4 7 6 4 pmos_6p0 L=0.7U W=5U AS=1.3P AD=1.3P PS=5.52U PD=5.52U
* device instance $24 r0 *1 42.595,141.445 pmos_6p0
M$24 6 7 4 4 pmos_6p0 L=0.7U W=5U AS=1.3P AD=1.3P PS=5.52U PD=5.52U
* device instance $25 r0 *1 43.815,141.445 pmos_6p0
M$25 4 7 6 4 pmos_6p0 L=0.7U W=5U AS=1.3P AD=1.3P PS=5.52U PD=5.52U
* device instance $26 r0 *1 45.035,141.445 pmos_6p0
M$26 6 7 4 4 pmos_6p0 L=0.7U W=5U AS=1.3P AD=1.3P PS=5.52U PD=5.52U
* device instance $27 r0 *1 46.255,141.445 pmos_6p0
M$27 4 7 6 4 pmos_6p0 L=0.7U W=5U AS=1.3P AD=1.3P PS=5.52U PD=5.52U
* device instance $28 r0 *1 47.475,141.445 pmos_6p0
M$28 6 7 4 4 pmos_6p0 L=0.7U W=5U AS=1.3P AD=1.3P PS=5.52U PD=5.52U
* device instance $29 r0 *1 48.695,141.445 pmos_6p0
M$29 4 7 6 4 pmos_6p0 L=0.7U W=5U AS=1.3P AD=1.3P PS=5.52U PD=5.52U
* device instance $30 r0 *1 49.915,141.445 pmos_6p0
M$30 6 7 4 4 pmos_6p0 L=0.7U W=5U AS=1.3P AD=1.3P PS=5.52U PD=5.52U
* device instance $31 r0 *1 51.135,141.445 pmos_6p0
M$31 4 7 6 4 pmos_6p0 L=0.7U W=5U AS=1.3P AD=2.2P PS=5.52U PD=10.88U
* device instance $32 r0 *1 26.305,132.53 nmos_6p0
M$32 7 5 1 10 nmos_6p0 L=0.7U W=5U AS=2.2P AD=1.3P PS=10.88U PD=5.52U
* device instance $33 r0 *1 27.525,132.53 nmos_6p0
M$33 1 5 7 10 nmos_6p0 L=0.7U W=5U AS=1.3P AD=1.3P PS=5.52U PD=5.52U
* device instance $34 r0 *1 28.745,132.53 nmos_6p0
M$34 7 5 1 10 nmos_6p0 L=0.7U W=5U AS=1.3P AD=1.3P PS=5.52U PD=5.52U
* device instance $35 r0 *1 29.965,132.53 nmos_6p0
M$35 1 5 7 10 nmos_6p0 L=0.7U W=5U AS=1.3P AD=1.3P PS=5.52U PD=5.52U
* device instance $36 r0 *1 31.185,132.53 nmos_6p0
M$36 7 5 1 10 nmos_6p0 L=0.7U W=5U AS=1.3P AD=1.3P PS=5.52U PD=5.52U
* device instance $37 r0 *1 32.405,132.53 nmos_6p0
M$37 1 5 7 10 nmos_6p0 L=0.7U W=5U AS=1.3P AD=1.3P PS=5.52U PD=5.52U
* device instance $38 r0 *1 33.625,132.53 nmos_6p0
M$38 6 7 1 10 nmos_6p0 L=0.7U W=5U AS=1.3P AD=1.3P PS=5.52U PD=5.52U
* device instance $39 r0 *1 34.845,132.53 nmos_6p0
M$39 1 7 6 10 nmos_6p0 L=0.7U W=5U AS=1.3P AD=1.3P PS=5.52U PD=5.52U
* device instance $40 r0 *1 36.065,132.53 nmos_6p0
M$40 6 7 1 10 nmos_6p0 L=0.7U W=5U AS=1.3P AD=1.3P PS=5.52U PD=5.52U
* device instance $41 r0 *1 37.285,132.53 nmos_6p0
M$41 1 7 6 10 nmos_6p0 L=0.7U W=5U AS=1.3P AD=1.3P PS=5.52U PD=5.52U
* device instance $42 r0 *1 38.505,132.53 nmos_6p0
M$42 6 7 1 10 nmos_6p0 L=0.7U W=5U AS=1.3P AD=1.3P PS=5.52U PD=5.52U
* device instance $43 r0 *1 39.725,132.53 nmos_6p0
M$43 1 7 6 10 nmos_6p0 L=0.7U W=5U AS=1.3P AD=2.2P PS=5.52U PD=10.88U
.ENDS comp018green_esd_clamp_v5p0_2

* cell comp018green_esd_clamp_v5p0_1
* pin
* pin
* pin gf180mcu_gnd
* pin
* pin
* pin
* pin
* pin
* pin
* pin
* pin
.SUBCKT comp018green_esd_clamp_v5p0_1 1 4 10 11 12 13 14 15 16 17 18
* net 10 gf180mcu_gnd
* cell instance $1 r0 *1 20.645,130.03
X$1 1 5 2 10 nmos_6p0_CDNS_406619561347
* cell instance $2 m0 *1 53.32,132.61
X$2 1 3 M1_PSUB_CDNS_40661956134125
* cell instance $3 r0 *1 0.215,128.085
X$3 15 16 12 11 1 4 1 18 17 13 14 top_route
* cell instance $4 r0 *1 0,0
X$4 6 4 1 18 17 22 16 15 14 13 12 21 11 10 nmos_clamp_20_50_4
* cell instance $5 m0 *1 11.49,132.61
X$5 1 3 M1_PSUB_CDNS_40661956134125
* cell instance $6 m0 *1 -1.78,232.535
X$6 4 2 1 10 comp018green_esd_rc_v5p0_1
* cell instance $7 r0 *1 33.275,130.03
X$7 20 1 6 1 6 1 6 1 7 7 7 7 7 7 nmos_6p0_CDNS_406619561346
* cell instance $8 r0 *1 25.955,130.03
X$8 20 1 7 1 7 1 7 1 5 5 5 5 5 5 nmos_6p0_CDNS_406619561346
* cell instance $9 r0 *1 20.71,135.54
X$9 2 M1_POLY2_CDNS_40661956134128
* cell instance $10 r0 *1 15.505,137.795
X$10 2 M1_POLY2_CDNS_40661956134127
* cell instance $11 r0 *1 13.325,138.945
X$11 19 5 4 5 4 4 2 2 2 2 9 4 pmos_6p0_CDNS_406619561344
* cell instance $12 r0 *1 11.49,141.595
X$12 4 8 9 4 M1_NWELL_CDNS_40661956134133
* cell instance $13 r0 *1 53.32,141.595
X$13 4 8 9 4 M1_NWELL_CDNS_40661956134133
* cell instance $14 r0 *1 32.405,145.185
X$14 4 8 9 4 M1_NWELL_CDNS_40661956134129
* cell instance $15 r0 *1 22.725,138.945
X$15 4 6 4 6 4 6 4 6 4 6 4 6 4 6 4 6 4 6 4 6 4 6 4 6 4 7 7 7 7 7 7 7 7 7 7 7 7
+ 7 7 7 7 7 7 7 7 7 7 7 7 9 4 pmos_6p0_CDNS_406619561342
* cell instance $16 r0 *1 18.205,138.945
X$16 19 7 4 4 7 5 5 5 9 4 pmos_6p0_CDNS_406619561343
* cell instance $17 r0 *1 29.355,136.18
X$17 5 M1_POLY2_CDNS_40661956134131
* cell instance $18 r0 *1 19.775,137.795
X$18 5 M1_POLY2_CDNS_40661956134130
* cell instance $19 r0 *1 6.565,127.585
X$19 6 22 M2_M1_CDNS_40661956134126
* cell instance $20 r0 *1 58.245,127.585
X$20 6 21 M2_M1_CDNS_40661956134126
* cell instance $21 r0 *1 36.675,136.18
X$21 7 M1_POLY2_CDNS_40661956134131
* cell instance $22 r0 *1 37.105,137.795
X$22 7 M1_POLY2_CDNS_40661956134132
* device instance $1 r0 *1 13.675,141.445 pmos_6p0
M$1 5 2 4 4 pmos_6p0 L=0.7U W=5U AS=2.2P AD=1.3P PS=10.88U PD=5.52U
* device instance $2 r0 *1 14.895,141.445 pmos_6p0
M$2 4 2 5 4 pmos_6p0 L=0.7U W=5U AS=1.3P AD=1.3P PS=5.52U PD=5.52U
* device instance $3 r0 *1 16.115,141.445 pmos_6p0
M$3 5 2 4 4 pmos_6p0 L=0.7U W=5U AS=1.3P AD=1.3P PS=5.52U PD=5.52U
* device instance $4 r0 *1 17.335,141.445 pmos_6p0
M$4 4 2 5 4 pmos_6p0 L=0.7U W=5U AS=1.3P AD=1.3P PS=5.52U PD=5.52U
* device instance $5 r0 *1 18.555,141.445 pmos_6p0
M$5 7 5 4 4 pmos_6p0 L=0.7U W=5U AS=1.3P AD=1.3P PS=5.52U PD=5.52U
* device instance $6 r0 *1 19.775,141.445 pmos_6p0
M$6 4 5 7 4 pmos_6p0 L=0.7U W=5U AS=1.3P AD=1.3P PS=5.52U PD=5.52U
* device instance $7 r0 *1 20.995,141.445 pmos_6p0
M$7 7 5 4 4 pmos_6p0 L=0.7U W=5U AS=1.3P AD=2.2P PS=5.52U PD=10.88U
* device instance $8 r0 *1 23.075,141.445 pmos_6p0
M$8 6 7 4 4 pmos_6p0 L=0.7U W=5U AS=2.2P AD=1.3P PS=10.88U PD=5.52U
* device instance $9 r0 *1 24.295,141.445 pmos_6p0
M$9 4 7 6 4 pmos_6p0 L=0.7U W=5U AS=1.3P AD=1.3P PS=5.52U PD=5.52U
* device instance $10 r0 *1 25.515,141.445 pmos_6p0
M$10 6 7 4 4 pmos_6p0 L=0.7U W=5U AS=1.3P AD=1.3P PS=5.52U PD=5.52U
* device instance $11 r0 *1 26.735,141.445 pmos_6p0
M$11 4 7 6 4 pmos_6p0 L=0.7U W=5U AS=1.3P AD=1.3P PS=5.52U PD=5.52U
* device instance $12 r0 *1 27.955,141.445 pmos_6p0
M$12 6 7 4 4 pmos_6p0 L=0.7U W=5U AS=1.3P AD=1.3P PS=5.52U PD=5.52U
* device instance $13 r0 *1 29.175,141.445 pmos_6p0
M$13 4 7 6 4 pmos_6p0 L=0.7U W=5U AS=1.3P AD=1.3P PS=5.52U PD=5.52U
* device instance $14 r0 *1 30.395,141.445 pmos_6p0
M$14 6 7 4 4 pmos_6p0 L=0.7U W=5U AS=1.3P AD=1.3P PS=5.52U PD=5.52U
* device instance $15 r0 *1 31.615,141.445 pmos_6p0
M$15 4 7 6 4 pmos_6p0 L=0.7U W=5U AS=1.3P AD=1.3P PS=5.52U PD=5.52U
* device instance $16 r0 *1 32.835,141.445 pmos_6p0
M$16 6 7 4 4 pmos_6p0 L=0.7U W=5U AS=1.3P AD=1.3P PS=5.52U PD=5.52U
* device instance $17 r0 *1 34.055,141.445 pmos_6p0
M$17 4 7 6 4 pmos_6p0 L=0.7U W=5U AS=1.3P AD=1.3P PS=5.52U PD=5.52U
* device instance $18 r0 *1 35.275,141.445 pmos_6p0
M$18 6 7 4 4 pmos_6p0 L=0.7U W=5U AS=1.3P AD=1.3P PS=5.52U PD=5.52U
* device instance $19 r0 *1 36.495,141.445 pmos_6p0
M$19 4 7 6 4 pmos_6p0 L=0.7U W=5U AS=1.3P AD=1.3P PS=5.52U PD=5.52U
* device instance $20 r0 *1 37.715,141.445 pmos_6p0
M$20 6 7 4 4 pmos_6p0 L=0.7U W=5U AS=1.3P AD=1.3P PS=5.52U PD=5.52U
* device instance $21 r0 *1 38.935,141.445 pmos_6p0
M$21 4 7 6 4 pmos_6p0 L=0.7U W=5U AS=1.3P AD=1.3P PS=5.52U PD=5.52U
* device instance $22 r0 *1 40.155,141.445 pmos_6p0
M$22 6 7 4 4 pmos_6p0 L=0.7U W=5U AS=1.3P AD=1.3P PS=5.52U PD=5.52U
* device instance $23 r0 *1 41.375,141.445 pmos_6p0
M$23 4 7 6 4 pmos_6p0 L=0.7U W=5U AS=1.3P AD=1.3P PS=5.52U PD=5.52U
* device instance $24 r0 *1 42.595,141.445 pmos_6p0
M$24 6 7 4 4 pmos_6p0 L=0.7U W=5U AS=1.3P AD=1.3P PS=5.52U PD=5.52U
* device instance $25 r0 *1 43.815,141.445 pmos_6p0
M$25 4 7 6 4 pmos_6p0 L=0.7U W=5U AS=1.3P AD=1.3P PS=5.52U PD=5.52U
* device instance $26 r0 *1 45.035,141.445 pmos_6p0
M$26 6 7 4 4 pmos_6p0 L=0.7U W=5U AS=1.3P AD=1.3P PS=5.52U PD=5.52U
* device instance $27 r0 *1 46.255,141.445 pmos_6p0
M$27 4 7 6 4 pmos_6p0 L=0.7U W=5U AS=1.3P AD=1.3P PS=5.52U PD=5.52U
* device instance $28 r0 *1 47.475,141.445 pmos_6p0
M$28 6 7 4 4 pmos_6p0 L=0.7U W=5U AS=1.3P AD=1.3P PS=5.52U PD=5.52U
* device instance $29 r0 *1 48.695,141.445 pmos_6p0
M$29 4 7 6 4 pmos_6p0 L=0.7U W=5U AS=1.3P AD=1.3P PS=5.52U PD=5.52U
* device instance $30 r0 *1 49.915,141.445 pmos_6p0
M$30 6 7 4 4 pmos_6p0 L=0.7U W=5U AS=1.3P AD=1.3P PS=5.52U PD=5.52U
* device instance $31 r0 *1 51.135,141.445 pmos_6p0
M$31 4 7 6 4 pmos_6p0 L=0.7U W=5U AS=1.3P AD=2.2P PS=5.52U PD=10.88U
* device instance $32 r0 *1 26.305,132.53 nmos_6p0
M$32 7 5 1 10 nmos_6p0 L=0.7U W=5U AS=2.2P AD=1.3P PS=10.88U PD=5.52U
* device instance $33 r0 *1 27.525,132.53 nmos_6p0
M$33 1 5 7 10 nmos_6p0 L=0.7U W=5U AS=1.3P AD=1.3P PS=5.52U PD=5.52U
* device instance $34 r0 *1 28.745,132.53 nmos_6p0
M$34 7 5 1 10 nmos_6p0 L=0.7U W=5U AS=1.3P AD=1.3P PS=5.52U PD=5.52U
* device instance $35 r0 *1 29.965,132.53 nmos_6p0
M$35 1 5 7 10 nmos_6p0 L=0.7U W=5U AS=1.3P AD=1.3P PS=5.52U PD=5.52U
* device instance $36 r0 *1 31.185,132.53 nmos_6p0
M$36 7 5 1 10 nmos_6p0 L=0.7U W=5U AS=1.3P AD=1.3P PS=5.52U PD=5.52U
* device instance $37 r0 *1 32.405,132.53 nmos_6p0
M$37 1 5 7 10 nmos_6p0 L=0.7U W=5U AS=1.3P AD=1.3P PS=5.52U PD=5.52U
* device instance $38 r0 *1 33.625,132.53 nmos_6p0
M$38 6 7 1 10 nmos_6p0 L=0.7U W=5U AS=1.3P AD=1.3P PS=5.52U PD=5.52U
* device instance $39 r0 *1 34.845,132.53 nmos_6p0
M$39 1 7 6 10 nmos_6p0 L=0.7U W=5U AS=1.3P AD=1.3P PS=5.52U PD=5.52U
* device instance $40 r0 *1 36.065,132.53 nmos_6p0
M$40 6 7 1 10 nmos_6p0 L=0.7U W=5U AS=1.3P AD=1.3P PS=5.52U PD=5.52U
* device instance $41 r0 *1 37.285,132.53 nmos_6p0
M$41 1 7 6 10 nmos_6p0 L=0.7U W=5U AS=1.3P AD=1.3P PS=5.52U PD=5.52U
* device instance $42 r0 *1 38.505,132.53 nmos_6p0
M$42 6 7 1 10 nmos_6p0 L=0.7U W=5U AS=1.3P AD=1.3P PS=5.52U PD=5.52U
* device instance $43 r0 *1 39.725,132.53 nmos_6p0
M$43 1 7 6 10 nmos_6p0 L=0.7U W=5U AS=1.3P AD=2.2P PS=5.52U PD=10.88U
.ENDS comp018green_esd_clamp_v5p0_1

* cell M1_PSUB_CDNS_4066195613418
* pin
.SUBCKT M1_PSUB_CDNS_4066195613418 1
.ENDS M1_PSUB_CDNS_4066195613418

* cell M3_M2_CDNS_40661956134108
* pin
* pin
.SUBCKT M3_M2_CDNS_40661956134108 1 2
.ENDS M3_M2_CDNS_40661956134108

* cell M3_M2_CDNS_4066195613491
* pin
* pin
.SUBCKT M3_M2_CDNS_4066195613491 1 2
.ENDS M3_M2_CDNS_4066195613491

* cell M2_M1_CDNS_4066195613492
* pin
* pin
.SUBCKT M2_M1_CDNS_4066195613492 1 2
.ENDS M2_M1_CDNS_4066195613492

* cell M2_M1_CDNS_4066195613470
* pin
* pin
.SUBCKT M2_M1_CDNS_4066195613470 1 2
.ENDS M2_M1_CDNS_4066195613470

* cell M3_M2_CDNS_4066195613493
* pin
* pin
.SUBCKT M3_M2_CDNS_4066195613493 1 2
.ENDS M3_M2_CDNS_4066195613493

* cell M2_M1_CDNS_4066195613494
* pin
* pin
.SUBCKT M2_M1_CDNS_4066195613494 1 2
.ENDS M2_M1_CDNS_4066195613494

* cell M2_M1_CDNS_40661956134109
* pin
* pin
.SUBCKT M2_M1_CDNS_40661956134109 1 2
.ENDS M2_M1_CDNS_40661956134109

* cell M2_M1_CDNS_40661956134110
* pin
* pin
.SUBCKT M2_M1_CDNS_40661956134110 1 2
.ENDS M2_M1_CDNS_40661956134110

* cell M3_M2_CDNS_40661956134111
* pin
* pin
.SUBCKT M3_M2_CDNS_40661956134111 1 2
.ENDS M3_M2_CDNS_40661956134111

* cell M2_M1_CDNS_40661956134104
* pin
* pin
.SUBCKT M2_M1_CDNS_40661956134104 1 2
.ENDS M2_M1_CDNS_40661956134104

* cell M3_M2_CDNS_40661956134105
* pin
* pin
.SUBCKT M3_M2_CDNS_40661956134105 1 2
.ENDS M3_M2_CDNS_40661956134105

* cell M3_M2_CDNS_40661956134106
* pin
* pin
.SUBCKT M3_M2_CDNS_40661956134106 1 2
.ENDS M3_M2_CDNS_40661956134106

* cell M2_M1_CDNS_40661956134107
* pin
* pin
.SUBCKT M2_M1_CDNS_40661956134107 1 2
.ENDS M2_M1_CDNS_40661956134107

* cell M1_PSUB_CDNS_4066195613455
* pin
.SUBCKT M1_PSUB_CDNS_4066195613455 1
.ENDS M1_PSUB_CDNS_4066195613455

* cell M1_PSUB_CDNS_4066195613458
* pin
* pin
.SUBCKT M1_PSUB_CDNS_4066195613458 1 2
.ENDS M1_PSUB_CDNS_4066195613458

* cell M1_PSUB_CDNS_4066195613448
* pin
* pin
.SUBCKT M1_PSUB_CDNS_4066195613448 1 2
.ENDS M1_PSUB_CDNS_4066195613448

* cell M2_M1_CDNS_4066195613471
* pin
* pin
.SUBCKT M2_M1_CDNS_4066195613471 1 2
.ENDS M2_M1_CDNS_4066195613471

* cell M1_PSUB_CDNS_4066195613450
* pin
* pin
.SUBCKT M1_PSUB_CDNS_4066195613450 1 2
.ENDS M1_PSUB_CDNS_4066195613450

* cell M3_M2_CDNS_4066195613472
* pin
* pin
.SUBCKT M3_M2_CDNS_4066195613472 1 2
.ENDS M3_M2_CDNS_4066195613472

* cell M1_PSUB_CDNS_4066195613456
* pin
* pin
.SUBCKT M1_PSUB_CDNS_4066195613456 1 2
.ENDS M1_PSUB_CDNS_4066195613456

* cell M2_M1_CDNS_4066195613478
* pin
* pin
.SUBCKT M2_M1_CDNS_4066195613478 1 2
.ENDS M2_M1_CDNS_4066195613478

* cell M3_M2_CDNS_4066195613479
* pin
* pin
.SUBCKT M3_M2_CDNS_4066195613479 1 2
.ENDS M3_M2_CDNS_4066195613479

* cell M3_M2_CDNS_4066195613473
* pin
* pin
.SUBCKT M3_M2_CDNS_4066195613473 1 2
.ENDS M3_M2_CDNS_4066195613473

* cell M3_M2_CDNS_4066195613488
* pin
* pin
.SUBCKT M3_M2_CDNS_4066195613488 1 2
.ENDS M3_M2_CDNS_4066195613488

* cell M2_M1_CDNS_4066195613486
* pin
* pin
.SUBCKT M2_M1_CDNS_4066195613486 1 2
.ENDS M2_M1_CDNS_4066195613486

* cell M2_M1_CDNS_40661956134102
* pin
* pin
.SUBCKT M2_M1_CDNS_40661956134102 1 2
.ENDS M2_M1_CDNS_40661956134102

* cell M3_M2_CDNS_40661956134103
* pin
* pin
.SUBCKT M3_M2_CDNS_40661956134103 1 2
.ENDS M3_M2_CDNS_40661956134103

* cell M1_PSUB_CDNS_4066195613451
* pin
* pin
.SUBCKT M1_PSUB_CDNS_4066195613451 1 2
.ENDS M1_PSUB_CDNS_4066195613451

* cell M3_M2_CDNS_4066195613495
* pin
* pin
.SUBCKT M3_M2_CDNS_4066195613495 1 2
.ENDS M3_M2_CDNS_4066195613495

* cell M2_M1_CDNS_4066195613496
* pin
* pin
.SUBCKT M2_M1_CDNS_4066195613496 1 2
.ENDS M2_M1_CDNS_4066195613496

* cell M3_M2_CDNS_4066195613497
* pin
* pin
.SUBCKT M3_M2_CDNS_4066195613497 1 2
.ENDS M3_M2_CDNS_4066195613497

* cell M2_M1_CDNS_4066195613498
* pin
* pin
.SUBCKT M2_M1_CDNS_4066195613498 1 2
.ENDS M2_M1_CDNS_4066195613498

* cell M3_M2_CDNS_4066195613462
* pin
* pin
.SUBCKT M3_M2_CDNS_4066195613462 1 2
.ENDS M3_M2_CDNS_4066195613462

* cell M2_M1_CDNS_4066195613463
* pin
* pin
.SUBCKT M2_M1_CDNS_4066195613463 1 2
.ENDS M2_M1_CDNS_4066195613463

* cell M3_M2_CDNS_40661956134101
* pin
* pin
.SUBCKT M3_M2_CDNS_40661956134101 1 2
.ENDS M3_M2_CDNS_40661956134101

* cell M2_M1_CDNS_4066195613487
* pin
* pin
.SUBCKT M2_M1_CDNS_4066195613487 1 2
.ENDS M2_M1_CDNS_4066195613487

* cell M1_PSUB_CDNS_4066195613434
* pin
* pin
.SUBCKT M1_PSUB_CDNS_4066195613434 1 2
.ENDS M1_PSUB_CDNS_4066195613434

* cell M2_M1_CDNS_4066195613460
* pin
* pin
.SUBCKT M2_M1_CDNS_4066195613460 1 2
.ENDS M2_M1_CDNS_4066195613460

* cell M3_M2_CDNS_4066195613461
* pin
* pin
.SUBCKT M3_M2_CDNS_4066195613461 1 2
.ENDS M3_M2_CDNS_4066195613461

* cell M2_M1_CDNS_4066195613466
* pin
* pin
.SUBCKT M2_M1_CDNS_4066195613466 1 2
.ENDS M2_M1_CDNS_4066195613466

* cell M2_M1_CDNS_4066195613421
* pin
* pin
.SUBCKT M2_M1_CDNS_4066195613421 1 2
.ENDS M2_M1_CDNS_4066195613421

* cell M2_M1_CDNS_4066195613483
* pin
.SUBCKT M2_M1_CDNS_4066195613483 1
.ENDS M2_M1_CDNS_4066195613483

* cell M3_M2_CDNS_4066195613482
* pin
* pin
.SUBCKT M3_M2_CDNS_4066195613482 1 2
.ENDS M3_M2_CDNS_4066195613482

* cell M1_PSUB_CDNS_4066195613431
* pin
* pin
.SUBCKT M1_PSUB_CDNS_4066195613431 1 2
.ENDS M1_PSUB_CDNS_4066195613431

* cell M3_M2_CDNS_4066195613454
* pin
* pin
.SUBCKT M3_M2_CDNS_4066195613454 1 2
.ENDS M3_M2_CDNS_4066195613454

* cell M2_M1_CDNS_4066195613459
* pin
* pin
.SUBCKT M2_M1_CDNS_4066195613459 1 2
.ENDS M2_M1_CDNS_4066195613459

* cell M2_M1_CDNS_4066195613464
* pin
* pin
.SUBCKT M2_M1_CDNS_4066195613464 1 2
.ENDS M2_M1_CDNS_4066195613464

* cell M3_M2_CDNS_4066195613465
* pin
* pin
.SUBCKT M3_M2_CDNS_4066195613465 1 2
.ENDS M3_M2_CDNS_4066195613465

* cell M2_M1_CDNS_4066195613469
* pin
* pin
.SUBCKT M2_M1_CDNS_4066195613469 1 2
.ENDS M2_M1_CDNS_4066195613469

* cell M3_M2_CDNS_4066195613474
* pin
* pin
.SUBCKT M3_M2_CDNS_4066195613474 1 2
.ENDS M3_M2_CDNS_4066195613474

* cell M2_M1_CDNS_4066195613475
* pin
* pin
.SUBCKT M2_M1_CDNS_4066195613475 1 2
.ENDS M2_M1_CDNS_4066195613475

* cell M3_M2_CDNS_4066195613476
* pin
* pin
.SUBCKT M3_M2_CDNS_4066195613476 1 2
.ENDS M3_M2_CDNS_4066195613476

* cell M3_M2_CDNS_4066195613477
* pin
* pin
.SUBCKT M3_M2_CDNS_4066195613477 1 2
.ENDS M3_M2_CDNS_4066195613477

* cell M2_M1_CDNS_4066195613484
* pin
* pin
.SUBCKT M2_M1_CDNS_4066195613484 1 2
.ENDS M2_M1_CDNS_4066195613484

* cell M3_M2_CDNS_4066195613485
* pin
* pin
.SUBCKT M3_M2_CDNS_4066195613485 1 2
.ENDS M3_M2_CDNS_4066195613485

* cell M2_M1_CDNS_4066195613419
* pin
* pin
.SUBCKT M2_M1_CDNS_4066195613419 1 2
.ENDS M2_M1_CDNS_4066195613419

* cell M2_M1_CDNS_4066195613420
* pin
* pin
.SUBCKT M2_M1_CDNS_4066195613420 1 2
.ENDS M2_M1_CDNS_4066195613420

* cell M3_M2_CDNS_4066195613422
* pin
* pin
.SUBCKT M3_M2_CDNS_4066195613422 1 2
.ENDS M3_M2_CDNS_4066195613422

* cell M3_M2_CDNS_4066195613423
* pin
* pin
.SUBCKT M3_M2_CDNS_4066195613423 1 2
.ENDS M3_M2_CDNS_4066195613423

* cell M3_M2_CDNS_4066195613424
* pin
* pin
.SUBCKT M3_M2_CDNS_4066195613424 1 2
.ENDS M3_M2_CDNS_4066195613424

* cell M2_M1_CDNS_4066195613425
* pin
* pin
.SUBCKT M2_M1_CDNS_4066195613425 1 2
.ENDS M2_M1_CDNS_4066195613425

* cell M3_M2_CDNS_4066195613426
* pin
* pin
.SUBCKT M3_M2_CDNS_4066195613426 1 2
.ENDS M3_M2_CDNS_4066195613426

* cell M2_M1_CDNS_4066195613428
* pin
* pin
.SUBCKT M2_M1_CDNS_4066195613428 1 2
.ENDS M2_M1_CDNS_4066195613428

* cell M3_M2_CDNS_4066195613499
* pin
* pin
.SUBCKT M3_M2_CDNS_4066195613499 1 2
.ENDS M3_M2_CDNS_4066195613499

* cell M3_M2_CDNS_4066195613430
* pin
* pin
.SUBCKT M3_M2_CDNS_4066195613430 1 2
.ENDS M3_M2_CDNS_4066195613430

* cell M2_M1_CDNS_4066195613432
* pin
* pin
.SUBCKT M2_M1_CDNS_4066195613432 1 2
.ENDS M2_M1_CDNS_4066195613432

* cell M2_M1_CDNS_4066195613457
* pin
* pin
.SUBCKT M2_M1_CDNS_4066195613457 1 2
.ENDS M2_M1_CDNS_4066195613457

* cell M2_M1_CDNS_40661956134100
* pin
* pin
.SUBCKT M2_M1_CDNS_40661956134100 1 2
.ENDS M2_M1_CDNS_40661956134100

* cell M1_PSUB_CDNS_4066195613429
* pin
* pin
.SUBCKT M1_PSUB_CDNS_4066195613429 1 2
.ENDS M1_PSUB_CDNS_4066195613429

* cell M1_PSUB_CDNS_4066195613433
* pin
* pin
.SUBCKT M1_PSUB_CDNS_4066195613433 1 2
.ENDS M1_PSUB_CDNS_4066195613433

* cell M1_PSUB_CDNS_4066195613435
* pin
* pin
.SUBCKT M1_PSUB_CDNS_4066195613435 1 2
.ENDS M1_PSUB_CDNS_4066195613435

* cell M1_PSUB_CDNS_4066195613436
* pin
* pin
.SUBCKT M1_PSUB_CDNS_4066195613436 1 2
.ENDS M1_PSUB_CDNS_4066195613436

* cell M1_PSUB_CDNS_4066195613437
* pin
* pin
.SUBCKT M1_PSUB_CDNS_4066195613437 1 2
.ENDS M1_PSUB_CDNS_4066195613437

* cell M1_PSUB_CDNS_4066195613438
* pin
* pin
.SUBCKT M1_PSUB_CDNS_4066195613438 1 2
.ENDS M1_PSUB_CDNS_4066195613438

* cell M1_PSUB_CDNS_4066195613439
* pin
* pin
.SUBCKT M1_PSUB_CDNS_4066195613439 1 2
.ENDS M1_PSUB_CDNS_4066195613439

* cell M1_PSUB_CDNS_4066195613440
* pin
* pin
.SUBCKT M1_PSUB_CDNS_4066195613440 1 2
.ENDS M1_PSUB_CDNS_4066195613440

* cell M1_PSUB_CDNS_4066195613441
* pin
* pin
.SUBCKT M1_PSUB_CDNS_4066195613441 1 2
.ENDS M1_PSUB_CDNS_4066195613441

* cell M1_PSUB_CDNS_4066195613442
* pin
* pin
.SUBCKT M1_PSUB_CDNS_4066195613442 1 2
.ENDS M1_PSUB_CDNS_4066195613442

* cell M1_PSUB_CDNS_4066195613443
* pin
* pin
.SUBCKT M1_PSUB_CDNS_4066195613443 1 2
.ENDS M1_PSUB_CDNS_4066195613443

* cell M1_PSUB_CDNS_4066195613444
* pin
* pin
.SUBCKT M1_PSUB_CDNS_4066195613444 1 2
.ENDS M1_PSUB_CDNS_4066195613444

* cell M1_PSUB_CDNS_4066195613445
* pin
* pin
.SUBCKT M1_PSUB_CDNS_4066195613445 1 2
.ENDS M1_PSUB_CDNS_4066195613445

* cell M1_PSUB_CDNS_4066195613446
* pin
* pin
.SUBCKT M1_PSUB_CDNS_4066195613446 1 2
.ENDS M1_PSUB_CDNS_4066195613446

* cell M1_PSUB_CDNS_4066195613447
* pin
* pin
.SUBCKT M1_PSUB_CDNS_4066195613447 1 2
.ENDS M1_PSUB_CDNS_4066195613447

* cell M1_PSUB_CDNS_4066195613449
* pin
* pin
.SUBCKT M1_PSUB_CDNS_4066195613449 1 2
.ENDS M1_PSUB_CDNS_4066195613449

* cell M1_PSUB_CDNS_4066195613452
* pin
* pin
.SUBCKT M1_PSUB_CDNS_4066195613452 1 2
.ENDS M1_PSUB_CDNS_4066195613452

* cell M1_PSUB_CDNS_4066195613453
* pin
* pin
.SUBCKT M1_PSUB_CDNS_4066195613453 1 2
.ENDS M1_PSUB_CDNS_4066195613453

* cell M2_M1_CDNS_4066195613467
* pin
* pin
.SUBCKT M2_M1_CDNS_4066195613467 1 2
.ENDS M2_M1_CDNS_4066195613467

* cell M2_M1_CDNS_4066195613468
* pin
* pin
.SUBCKT M2_M1_CDNS_4066195613468 1 2
.ENDS M2_M1_CDNS_4066195613468

* cell M2_M1_CDNS_4066195613480
* pin
* pin
.SUBCKT M2_M1_CDNS_4066195613480 1 2
.ENDS M2_M1_CDNS_4066195613480

* cell M3_M2_CDNS_4066195613481
* pin
* pin
.SUBCKT M3_M2_CDNS_4066195613481 1 2
.ENDS M3_M2_CDNS_4066195613481

* cell M3_M2_CDNS_4066195613489
* pin
* pin
.SUBCKT M3_M2_CDNS_4066195613489 1 2
.ENDS M3_M2_CDNS_4066195613489

* cell M2_M1_CDNS_4066195613490
* pin
* pin
.SUBCKT M2_M1_CDNS_4066195613490 1 2
.ENDS M2_M1_CDNS_4066195613490

* cell M3_M2_CDNS_4066195613427
* pin
* pin
.SUBCKT M3_M2_CDNS_4066195613427 1 2
.ENDS M3_M2_CDNS_4066195613427

* cell M2_M1_CDNS_40661956134513
* pin
* pin
.SUBCKT M2_M1_CDNS_40661956134513 1 2
.ENDS M2_M1_CDNS_40661956134513

* cell M2_M1_CDNS_40661956134509
* pin
* pin
.SUBCKT M2_M1_CDNS_40661956134509 1 2
.ENDS M2_M1_CDNS_40661956134509

* cell M2_M1_CDNS_40661956134511
* pin
* pin
.SUBCKT M2_M1_CDNS_40661956134511 1 2
.ENDS M2_M1_CDNS_40661956134511

* cell M1_NWELL_CDNS_40661956134321
* pin
* pin
* pin
* pin
.SUBCKT M1_NWELL_CDNS_40661956134321 1 2 3 4
.ENDS M1_NWELL_CDNS_40661956134321

* cell M1_NWELL_CDNS_40661956134503
* pin
* pin
* pin
* pin
.SUBCKT M1_NWELL_CDNS_40661956134503 1 2 3 4
.ENDS M1_NWELL_CDNS_40661956134503

* cell M1_PSUB_CDNS_40661956134512
* pin
* pin
.SUBCKT M1_PSUB_CDNS_40661956134512 1 2
.ENDS M1_PSUB_CDNS_40661956134512

* cell M2_M1_CDNS_40661956134517
* pin
* pin
.SUBCKT M2_M1_CDNS_40661956134517 1 2
.ENDS M2_M1_CDNS_40661956134517

* cell M2_M1_CDNS_40661956134488
* pin
* pin
.SUBCKT M2_M1_CDNS_40661956134488 1 2
.ENDS M2_M1_CDNS_40661956134488

* cell M2_M1_CDNS_40661956134489
* pin
* pin
.SUBCKT M2_M1_CDNS_40661956134489 1 2
.ENDS M2_M1_CDNS_40661956134489

* cell M2_M1_CDNS_40661956134496
* pin
* pin
.SUBCKT M2_M1_CDNS_40661956134496 1 2
.ENDS M2_M1_CDNS_40661956134496

* cell M2_M1_CDNS_40661956134516
* pin
* pin
.SUBCKT M2_M1_CDNS_40661956134516 1 2
.ENDS M2_M1_CDNS_40661956134516

* cell M1_PSUB_CDNS_40661956134505
* pin
* pin
.SUBCKT M1_PSUB_CDNS_40661956134505 1 2
.ENDS M1_PSUB_CDNS_40661956134505

* cell M1_NWELL_CDNS_40661956134515
* pin
* pin
* pin
* pin
.SUBCKT M1_NWELL_CDNS_40661956134515 1 2 3 4
.ENDS M1_NWELL_CDNS_40661956134515

* cell M1_PSUB_CDNS_40661956134507
* pin
* pin
.SUBCKT M1_PSUB_CDNS_40661956134507 1 2
.ENDS M1_PSUB_CDNS_40661956134507

* cell np_6p0_CDNS_4066195613453
* pin
.SUBCKT np_6p0_CDNS_4066195613453 1
.ENDS np_6p0_CDNS_4066195613453

* cell pn_6p0_CDNS_4066195613452
* pin
* pin
* pin
.SUBCKT pn_6p0_CDNS_4066195613452 1 3 4
.ENDS pn_6p0_CDNS_4066195613452

* cell M1_PSUB_CDNS_40661956134514
* pin
* pin
.SUBCKT M1_PSUB_CDNS_40661956134514 1 2
.ENDS M1_PSUB_CDNS_40661956134514

* cell M1_PSUB_CDNS_40661956134508
* pin
* pin
.SUBCKT M1_PSUB_CDNS_40661956134508 1 2
.ENDS M1_PSUB_CDNS_40661956134508

* cell M1_PSUB_CDNS_40661956134506
* pin
* pin
.SUBCKT M1_PSUB_CDNS_40661956134506 1 2
.ENDS M1_PSUB_CDNS_40661956134506

* cell M1_PSUB_CDNS_40661956134504
* pin
* pin
.SUBCKT M1_PSUB_CDNS_40661956134504 1 2
.ENDS M1_PSUB_CDNS_40661956134504

* cell M1_NWELL_CDNS_40661956134510
* pin
* pin
* pin
* pin
.SUBCKT M1_NWELL_CDNS_40661956134510 1 2 3 4
.ENDS M1_NWELL_CDNS_40661956134510

* cell M1_NWELL_CDNS_40661956134502
* pin
* pin
* pin
* pin
.SUBCKT M1_NWELL_CDNS_40661956134502 1 2 3 4
.ENDS M1_NWELL_CDNS_40661956134502

* cell M1_NWELL_CDNS_40661956134501
* pin
* pin
* pin
* pin
.SUBCKT M1_NWELL_CDNS_40661956134501 1 2 3 4
.ENDS M1_NWELL_CDNS_40661956134501

* cell M1_NWELL_CDNS_40661956134500
* pin
* pin
* pin
* pin
.SUBCKT M1_NWELL_CDNS_40661956134500 1 2 3 4
.ENDS M1_NWELL_CDNS_40661956134500

* cell M1_PSUB_CDNS_40661956134192
* pin
* pin
.SUBCKT M1_PSUB_CDNS_40661956134192 1 2
.ENDS M1_PSUB_CDNS_40661956134192

* cell M1_PSUB_CDNS_40661956134176
* pin
* pin
.SUBCKT M1_PSUB_CDNS_40661956134176 1 2
.ENDS M1_PSUB_CDNS_40661956134176

* cell M3_M2_CDNS_40661956134157
* pin
* pin
.SUBCKT M3_M2_CDNS_40661956134157 1 2
.ENDS M3_M2_CDNS_40661956134157

* cell M3_M2_CDNS_40661956134158
* pin
* pin
.SUBCKT M3_M2_CDNS_40661956134158 1 2
.ENDS M3_M2_CDNS_40661956134158

* cell M3_M2_CDNS_40661956134159
* pin
* pin
.SUBCKT M3_M2_CDNS_40661956134159 1 2
.ENDS M3_M2_CDNS_40661956134159

* cell M3_M2_CDNS_40661956134160
* pin
* pin
.SUBCKT M3_M2_CDNS_40661956134160 1 2
.ENDS M3_M2_CDNS_40661956134160

* cell M3_M2_CDNS_40661956134161
* pin
* pin
.SUBCKT M3_M2_CDNS_40661956134161 1 2
.ENDS M3_M2_CDNS_40661956134161

* cell M3_M2_CDNS_40661956134162
* pin
* pin
.SUBCKT M3_M2_CDNS_40661956134162 1 2
.ENDS M3_M2_CDNS_40661956134162

* cell M3_M2_CDNS_40661956134163
* pin
* pin
.SUBCKT M3_M2_CDNS_40661956134163 1 2
.ENDS M3_M2_CDNS_40661956134163

* cell M3_M2_CDNS_40661956134164
* pin
* pin
.SUBCKT M3_M2_CDNS_40661956134164 1 2
.ENDS M3_M2_CDNS_40661956134164

* cell M3_M2_CDNS_40661956134165
* pin
* pin
.SUBCKT M3_M2_CDNS_40661956134165 1 2
.ENDS M3_M2_CDNS_40661956134165

* cell M3_M2_CDNS_40661956134155
* pin
* pin
.SUBCKT M3_M2_CDNS_40661956134155 1 2
.ENDS M3_M2_CDNS_40661956134155

* cell M3_M2_CDNS_40661956134112
* pin
* pin
.SUBCKT M3_M2_CDNS_40661956134112 1 2
.ENDS M3_M2_CDNS_40661956134112

* cell M3_M2_CDNS_40661956134113
* pin
* pin
.SUBCKT M3_M2_CDNS_40661956134113 1 2
.ENDS M3_M2_CDNS_40661956134113

* cell M3_M2_CDNS_40661956134116
* pin
* pin
.SUBCKT M3_M2_CDNS_40661956134116 1 2
.ENDS M3_M2_CDNS_40661956134116

* cell M3_M2_CDNS_40661956134117
* pin
* pin
.SUBCKT M3_M2_CDNS_40661956134117 1 2
.ENDS M3_M2_CDNS_40661956134117

* cell M3_M2_CDNS_40661956134118
* pin
* pin
.SUBCKT M3_M2_CDNS_40661956134118 1 2
.ENDS M3_M2_CDNS_40661956134118

* cell M3_M2_CDNS_40661956134120
* pin
* pin
.SUBCKT M3_M2_CDNS_40661956134120 1 2
.ENDS M3_M2_CDNS_40661956134120

* cell M3_M2_CDNS_40661956134121
* pin
* pin
.SUBCKT M3_M2_CDNS_40661956134121 1 2
.ENDS M3_M2_CDNS_40661956134121

* cell M3_M2_CDNS_40661956134122
* pin
* pin
.SUBCKT M3_M2_CDNS_40661956134122 1 2
.ENDS M3_M2_CDNS_40661956134122

* cell M3_M2_CDNS_40661956134123
* pin
* pin
.SUBCKT M3_M2_CDNS_40661956134123 1 2
.ENDS M3_M2_CDNS_40661956134123

* cell M3_M2_CDNS_40661956134124
* pin
* pin
.SUBCKT M3_M2_CDNS_40661956134124 1 2
.ENDS M3_M2_CDNS_40661956134124

* cell M2_M1_CDNS_40661956134248
* pin
* pin
.SUBCKT M2_M1_CDNS_40661956134248 1 2
.ENDS M2_M1_CDNS_40661956134248

* cell M2_M1_CDNS_40661956134246
* pin
* pin
.SUBCKT M2_M1_CDNS_40661956134246 1 2
.ENDS M2_M1_CDNS_40661956134246

* cell M3_M2_CDNS_40661956134156
* pin
* pin
.SUBCKT M3_M2_CDNS_40661956134156 1 2
.ENDS M3_M2_CDNS_40661956134156

* cell M3_M2_CDNS_40661956134119
* pin
* pin
.SUBCKT M3_M2_CDNS_40661956134119 1 2
.ENDS M3_M2_CDNS_40661956134119

* cell M2_M1_CDNS_40661956134247
* pin
* pin
.SUBCKT M2_M1_CDNS_40661956134247 1 2
.ENDS M2_M1_CDNS_40661956134247

* cell M2_M1_CDNS_40661956134249
* pin
* pin
.SUBCKT M2_M1_CDNS_40661956134249 1 2
.ENDS M2_M1_CDNS_40661956134249

* cell M2_M1_CDNS_40661956134206
* pin
* pin
.SUBCKT M2_M1_CDNS_40661956134206 1 2
.ENDS M2_M1_CDNS_40661956134206

* cell M2_M1_CDNS_40661956134268
* pin
* pin
.SUBCKT M2_M1_CDNS_40661956134268 1 2
.ENDS M2_M1_CDNS_40661956134268

* cell M2_M1_CDNS_40661956134217
* pin
* pin
.SUBCKT M2_M1_CDNS_40661956134217 1 2
.ENDS M2_M1_CDNS_40661956134217

* cell M2_M1_CDNS_40661956134218
* pin
* pin
.SUBCKT M2_M1_CDNS_40661956134218 1 2
.ENDS M2_M1_CDNS_40661956134218

* cell M2_M1_CDNS_40661956134255
* pin
* pin
.SUBCKT M2_M1_CDNS_40661956134255 1 2
.ENDS M2_M1_CDNS_40661956134255

* cell top_route_1
* pin
* pin
* pin
* pin
* pin
* pin
* pin
* pin
* pin
* pin
* pin
.SUBCKT top_route_1 1 2 3 4 5 6 7 8 9 10 11
* cell instance $1 r0 *1 43.43,1.03
X$1 1 7 M2_M1_CDNS_40661956134152
* cell instance $2 r0 *1 61.625,1.03
X$2 1 9 M2_M1_CDNS_40661956134147
* cell instance $3 r0 *1 42.98,50.225
X$3 1 7 M2_M1_CDNS_40661956134150
* cell instance $4 r0 *1 42.98,19.77
X$4 1 7 M2_M1_CDNS_40661956134143
* cell instance $5 r0 *1 42.98,80.19
X$5 1 7 M2_M1_CDNS_40661956134143
* cell instance $6 r0 *1 3.04,17.43
X$6 11 2 M2_M1_CDNS_40661956134149
* cell instance $7 r0 *1 3.035,82.645
X$7 11 2 M2_M1_CDNS_40661956134166
* cell instance $8 r0 *1 11.76,50.225
X$8 10 3 M2_M1_CDNS_40661956134150
* cell instance $9 r0 *1 11.76,1.03
X$9 10 3 M2_M1_CDNS_40661956134143
* cell instance $10 r0 *1 11.76,80.19
X$10 10 3 M2_M1_CDNS_40661956134143
* cell instance $11 r0 *1 11.76,19.77
X$11 10 3 M2_M1_CDNS_40661956134143
* cell instance $12 r0 *1 21.4,17.43
X$12 11 4 M2_M1_CDNS_40661956134143
* cell instance $13 r0 *1 29.205,50.225
X$13 10 5 M2_M1_CDNS_40661956134151
* cell instance $14 r0 *1 29.205,80.19
X$14 10 5 M2_M1_CDNS_40661956134147
* cell instance $15 r0 *1 29.205,1.03
X$15 10 5 M2_M1_CDNS_40661956134147
* cell instance $16 r0 *1 29.205,19.77
X$16 10 5 M2_M1_CDNS_40661956134147
* cell instance $17 r0 *1 35.175,17.43
X$17 11 6 M2_M1_CDNS_40661956134147
* cell instance $18 r0 *1 52.62,17.43
X$18 11 8 M2_M1_CDNS_40661956134143
.ENDS top_route_1

* cell comp018green_esd_rc_v5p0
* pin VPLUS
* pin VRC
* pin VMINUS
* pin gf180mcu_gnd
.SUBCKT comp018green_esd_rc_v5p0 1 15 16 18
* net 1 VPLUS
* net 15 VRC
* net 16 VMINUS
* net 18 gf180mcu_gnd
* cell instance $1 m135 *1 34.185,3.095
X$1 1 10 1 11 M1_NWELL_CDNS_40661956134153
* cell instance $2 m0 *1 0.385,12.445
X$2 1 11 10 1 M1_NWELL_CDNS_40661956134154
* cell instance $3 m0 *1 1.765,5.145
X$3 4 1 18 ppolyf_u_CDNS_406619561345
* cell instance $4 m0 *1 67.985,12.445
X$4 1 11 10 1 M1_NWELL_CDNS_40661956134154
* cell instance $5 m90 *1 66.64,8.545
X$5 2 5 18 ppolyf_u_CDNS_406619561345
* cell instance $6 r0 *1 1.765,9.945
X$6 8 2 18 ppolyf_u_CDNS_406619561345
* cell instance $7 m90 *1 66.64,5.745
X$7 3 4 18 ppolyf_u_CDNS_406619561345
* cell instance $8 r0 *1 1.765,7.145
X$8 5 3 18 ppolyf_u_CDNS_406619561345
* cell instance $9 m90 *1 66.64,14.145
X$9 6 9 18 ppolyf_u_CDNS_406619561345
* cell instance $10 r0 *1 1.765,15.545
X$10 12 6 18 ppolyf_u_CDNS_406619561345
* cell instance $11 m90 *1 66.64,11.345
X$11 7 8 18 ppolyf_u_CDNS_406619561345
* cell instance $12 r0 *1 1.765,12.745
X$12 9 7 18 ppolyf_u_CDNS_406619561345
* cell instance $13 m90 *1 66.64,16.945
X$13 14 12 18 ppolyf_u_CDNS_406619561345
* cell instance $14 r0 *1 1.765,18.345
X$14 13 14 18 ppolyf_u_CDNS_406619561345
* cell instance $15 m90 *1 66.64,19.745
X$15 15 13 18 ppolyf_u_CDNS_406619561345
* cell instance $16 r0 *1 10.9,56.755
X$16 16 15 nmoscap_6p0_CDNS_406619561340
* cell instance $17 m0 *1 23.08,51.695
X$17 16 15 nmoscap_6p0_CDNS_406619561340
* cell instance $18 m0 *1 10.9,51.695
X$18 16 15 nmoscap_6p0_CDNS_406619561340
* cell instance $19 m0 *1 47.44,51.695
X$19 16 15 nmoscap_6p0_CDNS_406619561340
* cell instance $20 m0 *1 35.26,51.695
X$20 16 15 nmoscap_6p0_CDNS_406619561340
* cell instance $21 r0 *1 47.44,56.755
X$21 16 15 nmoscap_6p0_CDNS_406619561340
* cell instance $22 r0 *1 35.26,56.755
X$22 16 15 nmoscap_6p0_CDNS_406619561340
* cell instance $23 r0 *1 23.08,56.755
X$23 16 15 nmoscap_6p0_CDNS_406619561340
* cell instance $24 r0 *1 60.035,54.47
X$24 16 17 M1_PSUB_CDNS_406619561349
* cell instance $25 r90 *1 34.185,54.225
X$25 16 17 M1_PSUB_CDNS_4066195613411
* cell instance $26 r90 *1 34.185,84.68
X$26 16 17 M1_PSUB_CDNS_4066195613411
* cell instance $27 r90 *1 34.185,24.26
X$27 16 17 M1_PSUB_CDNS_4066195613411
.ENDS comp018green_esd_rc_v5p0

* cell top_route
* pin
* pin
* pin
* pin
* pin
* pin
* pin
* pin
* pin
* pin
* pin
.SUBCKT top_route 1 2 3 4 5 6 7 8 9 10 11
* cell instance $1 r0 *1 21.4,17.43
X$1 6 1 M2_M1_CDNS_40661956134143
* cell instance $2 r0 *1 29.205,1.03
X$2 7 2 M2_M1_CDNS_40661956134147
* cell instance $3 r0 *1 29.205,19.77
X$3 7 2 M2_M1_CDNS_40661956134147
* cell instance $4 r0 *1 29.205,80.19
X$4 7 2 M2_M1_CDNS_40661956134147
* cell instance $5 r0 *1 29.205,50.225
X$5 7 2 M2_M1_CDNS_40661956134151
* cell instance $6 r0 *1 52.62,17.43
X$6 6 3 M2_M1_CDNS_40661956134143
* cell instance $7 r0 *1 61.625,1.03
X$7 5 4 M2_M1_CDNS_40661956134147
* cell instance $8 r0 *1 42.98,50.225
X$8 5 11 M2_M1_CDNS_40661956134150
* cell instance $9 r0 *1 42.98,19.77
X$9 5 11 M2_M1_CDNS_40661956134143
* cell instance $10 r0 *1 42.98,80.19
X$10 5 11 M2_M1_CDNS_40661956134143
* cell instance $11 r0 *1 43.43,1.03
X$11 5 11 M2_M1_CDNS_40661956134152
* cell instance $12 r0 *1 3.04,17.43
X$12 6 8 M2_M1_CDNS_40661956134149
* cell instance $13 r0 *1 2.755,83.74
X$13 6 8 M2_M1_CDNS_40661956134147
* cell instance $14 r0 *1 35.175,17.43
X$14 6 10 M2_M1_CDNS_40661956134147
* cell instance $15 r0 *1 11.76,50.225
X$15 7 9 M2_M1_CDNS_40661956134150
* cell instance $16 r0 *1 11.76,1.03
X$16 7 9 M2_M1_CDNS_40661956134143
* cell instance $17 r0 *1 11.76,19.77
X$17 7 9 M2_M1_CDNS_40661956134143
* cell instance $18 r0 *1 11.76,80.19
X$18 7 9 M2_M1_CDNS_40661956134143
.ENDS top_route

* cell comp018green_esd_rc_v5p0_1
* pin VPLUS
* pin VRC
* pin VMINUS
* pin gf180mcu_gnd
.SUBCKT comp018green_esd_rc_v5p0_1 1 4 10 18
* net 1 VPLUS
* net 4 VRC
* net 10 VMINUS
* net 18 gf180mcu_gnd
* cell instance $1 r90 *1 -16.47,21.625
X$1 12 1 18 ppolyf_u_CDNS_406619561345
* cell instance $2 r90 *1 -9.17,87.845
X$2 1 3 2 1 M1_NWELL_CDNS_40661956134154
* cell instance $3 r90 *1 -9.17,20.245
X$3 1 3 2 1 M1_NWELL_CDNS_40661956134154
* cell instance $4 r180 *1 -18.52,54.045
X$4 1 2 1 3 M1_NWELL_CDNS_40661956134153
* cell instance $5 m0 *1 23.08,51.695
X$5 10 4 nmoscap_6p0_CDNS_406619561340
* cell instance $6 m0 *1 10.9,51.695
X$6 10 4 nmoscap_6p0_CDNS_406619561340
* cell instance $7 m0 *1 47.44,51.695
X$7 10 4 nmoscap_6p0_CDNS_406619561340
* cell instance $8 m0 *1 35.26,51.695
X$8 10 4 nmoscap_6p0_CDNS_406619561340
* cell instance $9 r0 *1 47.44,56.755
X$9 10 4 nmoscap_6p0_CDNS_406619561340
* cell instance $10 r0 *1 35.26,56.755
X$10 10 4 nmoscap_6p0_CDNS_406619561340
* cell instance $11 r0 *1 23.08,56.755
X$11 10 4 nmoscap_6p0_CDNS_406619561340
* cell instance $12 r0 *1 10.9,56.755
X$12 10 4 nmoscap_6p0_CDNS_406619561340
* cell instance $13 r270 *1 -1.87,86.5
X$13 4 17 18 ppolyf_u_CDNS_406619561345
* cell instance $14 r270 *1 -4.67,86.5
X$14 5 15 18 ppolyf_u_CDNS_406619561345
* cell instance $15 m45 *1 -3.27,21.625
X$15 17 5 18 ppolyf_u_CDNS_406619561345
* cell instance $16 r270 *1 -7.47,86.5
X$16 6 16 18 ppolyf_u_CDNS_406619561345
* cell instance $17 m45 *1 -6.07,21.625
X$17 15 6 18 ppolyf_u_CDNS_406619561345
* cell instance $18 r270 *1 -10.27,86.5
X$18 7 13 18 ppolyf_u_CDNS_406619561345
* cell instance $19 m45 *1 -8.87,21.625
X$19 16 7 18 ppolyf_u_CDNS_406619561345
* cell instance $20 r270 *1 -13.07,86.5
X$20 8 14 18 ppolyf_u_CDNS_406619561345
* cell instance $21 m45 *1 -11.67,21.625
X$21 13 8 18 ppolyf_u_CDNS_406619561345
* cell instance $22 r270 *1 -15.87,86.5
X$22 9 12 18 ppolyf_u_CDNS_406619561345
* cell instance $23 m45 *1 -14.47,21.625
X$23 14 9 18 ppolyf_u_CDNS_406619561345
* cell instance $24 r90 *1 34.185,84.68
X$24 10 11 M1_PSUB_CDNS_4066195613411
* cell instance $25 r90 *1 34.185,24.26
X$25 10 11 M1_PSUB_CDNS_4066195613411
* cell instance $26 r90 *1 34.185,54.225
X$26 10 11 M1_PSUB_CDNS_4066195613411
* cell instance $27 r0 *1 60.035,54.47
X$27 10 11 M1_PSUB_CDNS_406619561349
.ENDS comp018green_esd_rc_v5p0_1

* cell nmos_clamp_20_50_4
* pin
* pin
* pin
* pin
* pin
* pin
* pin
* pin
* pin
* pin
* pin
* pin
* pin
* pin gf180mcu_gnd
.SUBCKT nmos_clamp_20_50_4 1 3 5 6 7 8 9 10 11 12 13 14 15 16
* net 16 gf180mcu_gnd
* cell instance $1 r90 *1 57.405,7.405
X$1 3 5 3 5 3 5 3 5 3 5 3 5 3 5 3 5 3 5 3 5 3 1 1 1 1 1 1 1 1 1 1 1 1 1 1 1 1 1
+ 1 1 1 16 nmos_6p0_CDNS_406619561341
* cell instance $2 r90 *1 57.405,36.765
X$2 3 5 3 5 3 5 3 5 3 5 3 5 3 5 3 5 3 5 3 5 3 1 1 1 1 1 1 1 1 1 1 1 1 1 1 1 1 1
+ 1 1 1 16 nmos_6p0_CDNS_406619561341
* cell instance $3 r90 *1 57.405,66.125
X$3 3 5 3 5 3 5 3 5 3 5 3 5 3 5 3 5 3 5 3 5 3 1 1 1 1 1 1 1 1 1 1 1 1 1 1 1 1 1
+ 1 1 1 16 nmos_6p0_CDNS_406619561341
* cell instance $4 r90 *1 57.405,95.485
X$4 3 5 3 5 3 5 3 5 3 5 3 5 3 5 3 5 3 5 3 5 3 1 1 1 1 1 1 1 1 1 1 1 1 1 1 1 1 1
+ 1 1 1 16 nmos_6p0_CDNS_406619561341
* cell instance $5 r0 *1 6.645,19.345
X$5 1 M1_POLY2_CDNS_40661956134136
* cell instance $6 r0 *1 6.565,19.345
X$6 1 8 M2_M1_CDNS_40661956134141
* cell instance $7 r0 *1 58.245,107.425
X$7 1 14 M2_M1_CDNS_40661956134141
* cell instance $8 m90 *1 58.165,107.425
X$8 1 M1_POLY2_CDNS_40661956134136
* cell instance $9 r0 *1 58.245,78.065
X$9 1 14 M2_M1_CDNS_40661956134141
* cell instance $10 m90 *1 58.165,78.065
X$10 1 M1_POLY2_CDNS_40661956134136
* cell instance $11 r0 *1 58.245,19.345
X$11 1 14 M2_M1_CDNS_40661956134141
* cell instance $12 m90 *1 58.165,19.345
X$12 1 M1_POLY2_CDNS_40661956134136
* cell instance $13 r0 *1 58.245,48.705
X$13 1 14 M2_M1_CDNS_40661956134141
* cell instance $14 m90 *1 58.165,48.705
X$14 1 M1_POLY2_CDNS_40661956134136
* cell instance $15 r0 *1 6.645,107.425
X$15 1 M1_POLY2_CDNS_40661956134136
* cell instance $16 r0 *1 6.565,107.425
X$16 1 8 M2_M1_CDNS_40661956134141
* cell instance $17 r0 *1 6.645,48.705
X$17 1 M1_POLY2_CDNS_40661956134136
* cell instance $18 r0 *1 6.565,48.705
X$18 1 8 M2_M1_CDNS_40661956134141
* cell instance $19 r0 *1 6.645,78.065
X$19 1 M1_POLY2_CDNS_40661956134136
* cell instance $20 r0 *1 6.565,78.065
X$20 1 8 M2_M1_CDNS_40661956134141
* cell instance $21 r0 *1 1.135,63.385
X$21 3 2 3 17 M1_NWELL_CDNS_40661956134135
* cell instance $22 r0 *1 32.405,1.135
X$22 3 17 3 2 M1_NWELL_CDNS_40661956134139
* cell instance $23 r0 *1 32.405,125.635
X$23 3 17 3 2 M1_NWELL_CDNS_40661956134139
* cell instance $24 r0 *1 63.675,63.385
X$24 3 2 3 17 M1_NWELL_CDNS_40661956134135
* cell instance $25 r0 *1 21.615,7.145
X$25 3 10 M2_M1_CDNS_40661956134140
* cell instance $26 r0 *1 35.39,7.145
X$26 3 12 M2_M1_CDNS_40661956134142
* cell instance $27 r0 *1 52.835,7.145
X$27 3 13 M2_M1_CDNS_40661956134140
* cell instance $28 r0 *1 21.615,80.505
X$28 3 10 M2_M1_CDNS_40661956134140
* cell instance $29 r0 *1 35.39,80.505
X$29 3 12 M2_M1_CDNS_40661956134142
* cell instance $30 r0 *1 52.835,80.505
X$30 3 13 M2_M1_CDNS_40661956134140
* cell instance $31 r0 *1 21.615,68.305
X$31 3 10 M2_M1_CDNS_40661956134140
* cell instance $32 r0 *1 35.39,68.305
X$32 3 12 M2_M1_CDNS_40661956134142
* cell instance $33 r0 *1 52.835,68.305
X$33 3 13 M2_M1_CDNS_40661956134140
* cell instance $34 r0 *1 21.615,95.225
X$34 3 10 M2_M1_CDNS_40661956134140
* cell instance $35 r0 *1 35.39,95.225
X$35 3 12 M2_M1_CDNS_40661956134142
* cell instance $36 r0 *1 52.835,95.225
X$36 3 13 M2_M1_CDNS_40661956134140
* cell instance $37 r0 *1 21.615,65.865
X$37 3 10 M2_M1_CDNS_40661956134140
* cell instance $38 r0 *1 35.39,65.865
X$38 3 12 M2_M1_CDNS_40661956134142
* cell instance $39 r0 *1 52.835,65.865
X$39 3 13 M2_M1_CDNS_40661956134140
* cell instance $40 r0 *1 21.615,70.745
X$40 3 10 M2_M1_CDNS_40661956134140
* cell instance $41 r0 *1 35.39,70.745
X$41 3 12 M2_M1_CDNS_40661956134142
* cell instance $42 r0 *1 52.835,70.745
X$42 3 13 M2_M1_CDNS_40661956134140
* cell instance $43 r0 *1 21.615,73.185
X$43 3 10 M2_M1_CDNS_40661956134140
* cell instance $44 r0 *1 35.39,73.185
X$44 3 12 M2_M1_CDNS_40661956134142
* cell instance $45 r0 *1 52.835,73.185
X$45 3 13 M2_M1_CDNS_40661956134140
* cell instance $46 r0 *1 21.615,78.065
X$46 3 10 M2_M1_CDNS_40661956134140
* cell instance $47 r0 *1 35.39,78.065
X$47 3 12 M2_M1_CDNS_40661956134142
* cell instance $48 r0 *1 52.835,78.065
X$48 3 13 M2_M1_CDNS_40661956134140
* cell instance $49 r0 *1 21.615,75.625
X$49 3 10 M2_M1_CDNS_40661956134140
* cell instance $50 r0 *1 35.39,75.625
X$50 3 12 M2_M1_CDNS_40661956134142
* cell instance $51 r0 *1 52.835,75.625
X$51 3 13 M2_M1_CDNS_40661956134140
* cell instance $52 r0 *1 21.615,119.625
X$52 3 10 M2_M1_CDNS_40661956134140
* cell instance $53 r0 *1 35.39,119.625
X$53 3 12 M2_M1_CDNS_40661956134142
* cell instance $54 r0 *1 52.835,119.625
X$54 3 13 M2_M1_CDNS_40661956134140
* cell instance $55 r0 *1 21.615,117.185
X$55 3 10 M2_M1_CDNS_40661956134140
* cell instance $56 r0 *1 35.39,117.185
X$56 3 12 M2_M1_CDNS_40661956134142
* cell instance $57 r0 *1 52.835,117.185
X$57 3 13 M2_M1_CDNS_40661956134140
* cell instance $58 r0 *1 21.615,114.745
X$58 3 10 M2_M1_CDNS_40661956134140
* cell instance $59 r0 *1 35.39,114.745
X$59 3 12 M2_M1_CDNS_40661956134142
* cell instance $60 r0 *1 52.835,114.745
X$60 3 13 M2_M1_CDNS_40661956134140
* cell instance $61 r0 *1 21.615,112.305
X$61 3 10 M2_M1_CDNS_40661956134140
* cell instance $62 r0 *1 35.39,112.305
X$62 3 12 M2_M1_CDNS_40661956134142
* cell instance $63 r0 *1 52.835,112.305
X$63 3 13 M2_M1_CDNS_40661956134140
* cell instance $64 r0 *1 21.615,26.665
X$64 3 10 M2_M1_CDNS_40661956134140
* cell instance $65 r0 *1 35.39,26.665
X$65 3 12 M2_M1_CDNS_40661956134142
* cell instance $66 r0 *1 52.835,26.665
X$66 3 13 M2_M1_CDNS_40661956134140
* cell instance $67 r0 *1 21.615,24.225
X$67 3 10 M2_M1_CDNS_40661956134140
* cell instance $68 r0 *1 35.39,24.225
X$68 3 12 M2_M1_CDNS_40661956134142
* cell instance $69 r0 *1 52.835,24.225
X$69 3 13 M2_M1_CDNS_40661956134140
* cell instance $70 r0 *1 21.615,21.785
X$70 3 10 M2_M1_CDNS_40661956134140
* cell instance $71 r0 *1 35.39,21.785
X$71 3 12 M2_M1_CDNS_40661956134142
* cell instance $72 r0 *1 52.835,21.785
X$72 3 13 M2_M1_CDNS_40661956134140
* cell instance $73 r0 *1 21.615,19.345
X$73 3 10 M2_M1_CDNS_40661956134140
* cell instance $74 r0 *1 35.39,19.345
X$74 3 12 M2_M1_CDNS_40661956134142
* cell instance $75 r0 *1 52.835,19.345
X$75 3 13 M2_M1_CDNS_40661956134140
* cell instance $76 r0 *1 21.615,16.905
X$76 3 10 M2_M1_CDNS_40661956134140
* cell instance $77 r0 *1 35.39,16.905
X$77 3 12 M2_M1_CDNS_40661956134142
* cell instance $78 r0 *1 52.835,16.905
X$78 3 13 M2_M1_CDNS_40661956134140
* cell instance $79 r0 *1 21.615,14.465
X$79 3 10 M2_M1_CDNS_40661956134140
* cell instance $80 r0 *1 35.39,14.465
X$80 3 12 M2_M1_CDNS_40661956134142
* cell instance $81 r0 *1 52.835,14.465
X$81 3 13 M2_M1_CDNS_40661956134140
* cell instance $82 r0 *1 21.615,12.025
X$82 3 10 M2_M1_CDNS_40661956134140
* cell instance $83 r0 *1 35.39,12.025
X$83 3 12 M2_M1_CDNS_40661956134142
* cell instance $84 r0 *1 52.835,12.025
X$84 3 13 M2_M1_CDNS_40661956134140
* cell instance $85 r0 *1 21.615,9.585
X$85 3 10 M2_M1_CDNS_40661956134140
* cell instance $86 r0 *1 35.39,9.585
X$86 3 12 M2_M1_CDNS_40661956134142
* cell instance $87 r0 *1 52.835,9.585
X$87 3 13 M2_M1_CDNS_40661956134140
* cell instance $88 r0 *1 21.615,29.105
X$88 3 10 M2_M1_CDNS_40661956134140
* cell instance $89 r0 *1 35.39,29.105
X$89 3 12 M2_M1_CDNS_40661956134142
* cell instance $90 r0 *1 52.835,29.105
X$90 3 13 M2_M1_CDNS_40661956134140
* cell instance $91 r0 *1 21.615,31.545
X$91 3 10 M2_M1_CDNS_40661956134140
* cell instance $92 r0 *1 35.39,31.545
X$92 3 12 M2_M1_CDNS_40661956134142
* cell instance $93 r0 *1 52.835,31.545
X$93 3 13 M2_M1_CDNS_40661956134140
* cell instance $94 r0 *1 21.615,109.865
X$94 3 10 M2_M1_CDNS_40661956134140
* cell instance $95 r0 *1 35.39,109.865
X$95 3 12 M2_M1_CDNS_40661956134142
* cell instance $96 r0 *1 52.835,109.865
X$96 3 13 M2_M1_CDNS_40661956134140
* cell instance $97 r0 *1 21.615,107.425
X$97 3 10 M2_M1_CDNS_40661956134140
* cell instance $98 r0 *1 35.39,107.425
X$98 3 12 M2_M1_CDNS_40661956134142
* cell instance $99 r0 *1 52.835,107.425
X$99 3 13 M2_M1_CDNS_40661956134140
* cell instance $100 r0 *1 21.615,102.545
X$100 3 10 M2_M1_CDNS_40661956134140
* cell instance $101 r0 *1 35.39,102.545
X$101 3 12 M2_M1_CDNS_40661956134142
* cell instance $102 r0 *1 52.835,102.545
X$102 3 13 M2_M1_CDNS_40661956134140
* cell instance $103 r0 *1 21.615,100.105
X$103 3 10 M2_M1_CDNS_40661956134140
* cell instance $104 r0 *1 35.39,100.105
X$104 3 12 M2_M1_CDNS_40661956134142
* cell instance $105 r0 *1 52.835,100.105
X$105 3 13 M2_M1_CDNS_40661956134140
* cell instance $106 r0 *1 21.615,97.665
X$106 3 10 M2_M1_CDNS_40661956134140
* cell instance $107 r0 *1 35.39,97.665
X$107 3 12 M2_M1_CDNS_40661956134142
* cell instance $108 r0 *1 52.835,97.665
X$108 3 13 M2_M1_CDNS_40661956134140
* cell instance $109 r0 *1 21.615,90.265
X$109 3 10 M2_M1_CDNS_40661956134140
* cell instance $110 r0 *1 35.39,90.265
X$110 3 12 M2_M1_CDNS_40661956134142
* cell instance $111 r0 *1 52.835,90.265
X$111 3 13 M2_M1_CDNS_40661956134140
* cell instance $112 r0 *1 21.615,87.825
X$112 3 10 M2_M1_CDNS_40661956134140
* cell instance $113 r0 *1 35.39,87.825
X$113 3 12 M2_M1_CDNS_40661956134142
* cell instance $114 r0 *1 52.835,87.825
X$114 3 13 M2_M1_CDNS_40661956134140
* cell instance $115 r0 *1 21.615,85.385
X$115 3 10 M2_M1_CDNS_40661956134140
* cell instance $116 r0 *1 35.39,85.385
X$116 3 12 M2_M1_CDNS_40661956134142
* cell instance $117 r0 *1 52.835,85.385
X$117 3 13 M2_M1_CDNS_40661956134140
* cell instance $118 r0 *1 21.615,104.985
X$118 3 10 M2_M1_CDNS_40661956134140
* cell instance $119 r0 *1 35.39,104.985
X$119 3 12 M2_M1_CDNS_40661956134142
* cell instance $120 r0 *1 52.835,104.985
X$120 3 13 M2_M1_CDNS_40661956134140
* cell instance $121 r0 *1 21.615,82.945
X$121 3 10 M2_M1_CDNS_40661956134140
* cell instance $122 r0 *1 35.39,82.945
X$122 3 12 M2_M1_CDNS_40661956134142
* cell instance $123 r0 *1 52.835,82.945
X$123 3 13 M2_M1_CDNS_40661956134140
* cell instance $124 r0 *1 21.615,58.465
X$124 3 10 M2_M1_CDNS_40661956134140
* cell instance $125 r0 *1 35.39,58.465
X$125 3 12 M2_M1_CDNS_40661956134142
* cell instance $126 r0 *1 52.835,58.465
X$126 3 13 M2_M1_CDNS_40661956134140
* cell instance $127 r0 *1 21.615,56.025
X$127 3 10 M2_M1_CDNS_40661956134140
* cell instance $128 r0 *1 35.39,56.025
X$128 3 12 M2_M1_CDNS_40661956134142
* cell instance $129 r0 *1 52.835,56.025
X$129 3 13 M2_M1_CDNS_40661956134140
* cell instance $130 r0 *1 21.615,53.585
X$130 3 10 M2_M1_CDNS_40661956134140
* cell instance $131 r0 *1 35.39,53.585
X$131 3 12 M2_M1_CDNS_40661956134142
* cell instance $132 r0 *1 52.835,53.585
X$132 3 13 M2_M1_CDNS_40661956134140
* cell instance $133 r0 *1 21.615,51.145
X$133 3 10 M2_M1_CDNS_40661956134140
* cell instance $134 r0 *1 35.39,51.145
X$134 3 12 M2_M1_CDNS_40661956134142
* cell instance $135 r0 *1 52.835,51.145
X$135 3 13 M2_M1_CDNS_40661956134140
* cell instance $136 r0 *1 21.615,48.705
X$136 3 10 M2_M1_CDNS_40661956134140
* cell instance $137 r0 *1 35.39,48.705
X$137 3 12 M2_M1_CDNS_40661956134142
* cell instance $138 r0 *1 52.835,48.705
X$138 3 13 M2_M1_CDNS_40661956134140
* cell instance $139 r0 *1 21.615,46.265
X$139 3 10 M2_M1_CDNS_40661956134140
* cell instance $140 r0 *1 35.39,46.265
X$140 3 12 M2_M1_CDNS_40661956134142
* cell instance $141 r0 *1 52.835,46.265
X$141 3 13 M2_M1_CDNS_40661956134140
* cell instance $142 r0 *1 21.615,43.825
X$142 3 10 M2_M1_CDNS_40661956134140
* cell instance $143 r0 *1 35.39,43.825
X$143 3 12 M2_M1_CDNS_40661956134142
* cell instance $144 r0 *1 52.835,43.825
X$144 3 13 M2_M1_CDNS_40661956134140
* cell instance $145 r0 *1 21.615,41.385
X$145 3 10 M2_M1_CDNS_40661956134140
* cell instance $146 r0 *1 35.39,41.385
X$146 3 12 M2_M1_CDNS_40661956134142
* cell instance $147 r0 *1 52.835,41.385
X$147 3 13 M2_M1_CDNS_40661956134140
* cell instance $148 r0 *1 21.615,38.945
X$148 3 10 M2_M1_CDNS_40661956134140
* cell instance $149 r0 *1 35.39,38.945
X$149 3 12 M2_M1_CDNS_40661956134142
* cell instance $150 r0 *1 52.835,38.945
X$150 3 13 M2_M1_CDNS_40661956134140
* cell instance $151 r0 *1 21.615,36.505
X$151 3 10 M2_M1_CDNS_40661956134140
* cell instance $152 r0 *1 35.39,36.505
X$152 3 12 M2_M1_CDNS_40661956134142
* cell instance $153 r0 *1 52.835,36.505
X$153 3 13 M2_M1_CDNS_40661956134140
* cell instance $154 r0 *1 21.615,60.905
X$154 3 10 M2_M1_CDNS_40661956134140
* cell instance $155 r0 *1 35.39,60.905
X$155 3 12 M2_M1_CDNS_40661956134142
* cell instance $156 r0 *1 52.835,60.905
X$156 3 13 M2_M1_CDNS_40661956134140
* cell instance $157 r0 *1 2.97,1.135
X$157 3 6 M2_M1_CDNS_40661956134145
* cell instance $158 r0 *1 21.615,1.135
X$158 3 10 M2_M1_CDNS_40661956134144
* cell instance $159 r0 *1 35.39,1.135
X$159 3 12 M2_M1_CDNS_40661956134145
* cell instance $160 r0 *1 52.835,1.135
X$160 3 13 M2_M1_CDNS_40661956134144
* cell instance $161 r0 *1 1.135,63.385
X$161 3 6 M2_M1_CDNS_40661956134148
* cell instance $162 r0 *1 2.97,125.635
X$162 3 6 M2_M1_CDNS_40661956134145
* cell instance $163 r0 *1 21.615,125.635
X$163 3 10 M2_M1_CDNS_40661956134144
* cell instance $164 r0 *1 35.39,125.635
X$164 3 12 M2_M1_CDNS_40661956134145
* cell instance $165 r0 *1 52.835,125.635
X$165 3 13 M2_M1_CDNS_40661956134144
* cell instance $166 r0 *1 3.885,63.385
X$166 5 4 M1_PSUB_CDNS_40661956134137
* cell instance $167 r0 *1 32.405,4.135
X$167 5 4 M1_PSUB_CDNS_40661956134138
* cell instance $168 r0 *1 32.405,34.025
X$168 5 4 M1_PSUB_CDNS_40661956134134
* cell instance $169 r0 *1 32.405,92.745
X$169 5 4 M1_PSUB_CDNS_40661956134134
* cell instance $170 r0 *1 32.405,63.385
X$170 5 4 M1_PSUB_CDNS_40661956134134
* cell instance $171 r0 *1 32.405,122.635
X$171 5 4 M1_PSUB_CDNS_40661956134138
* cell instance $172 r0 *1 60.925,63.385
X$172 5 4 M1_PSUB_CDNS_40661956134137
* cell instance $173 r0 *1 60.925,63.385
X$173 5 15 M2_M1_CDNS_40661956134146
* cell instance $174 r0 *1 11.975,69.525
X$174 5 7 M2_M1_CDNS_40661956134140
* cell instance $175 r0 *1 29.42,69.525
X$175 5 9 M2_M1_CDNS_40661956134142
* cell instance $176 r0 *1 43.195,69.525
X$176 5 11 M2_M1_CDNS_40661956134140
* cell instance $177 r0 *1 11.975,81.725
X$177 5 7 M2_M1_CDNS_40661956134140
* cell instance $178 r0 *1 29.42,81.725
X$178 5 9 M2_M1_CDNS_40661956134142
* cell instance $179 r0 *1 43.195,81.725
X$179 5 11 M2_M1_CDNS_40661956134140
* cell instance $180 r0 *1 11.975,71.965
X$180 5 7 M2_M1_CDNS_40661956134140
* cell instance $181 r0 *1 29.42,71.965
X$181 5 9 M2_M1_CDNS_40661956134142
* cell instance $182 r0 *1 43.195,71.965
X$182 5 11 M2_M1_CDNS_40661956134140
* cell instance $183 r0 *1 11.975,76.845
X$183 5 7 M2_M1_CDNS_40661956134140
* cell instance $184 r0 *1 29.42,76.845
X$184 5 9 M2_M1_CDNS_40661956134142
* cell instance $185 r0 *1 43.195,76.845
X$185 5 11 M2_M1_CDNS_40661956134140
* cell instance $186 r0 *1 11.975,74.405
X$186 5 7 M2_M1_CDNS_40661956134140
* cell instance $187 r0 *1 29.42,74.405
X$187 5 9 M2_M1_CDNS_40661956134142
* cell instance $188 r0 *1 43.195,74.405
X$188 5 11 M2_M1_CDNS_40661956134140
* cell instance $189 r0 *1 11.975,79.285
X$189 5 7 M2_M1_CDNS_40661956134140
* cell instance $190 r0 *1 29.42,79.285
X$190 5 9 M2_M1_CDNS_40661956134142
* cell instance $191 r0 *1 43.195,79.285
X$191 5 11 M2_M1_CDNS_40661956134140
* cell instance $192 r0 *1 11.975,67.085
X$192 5 7 M2_M1_CDNS_40661956134140
* cell instance $193 r0 *1 29.42,67.085
X$193 5 9 M2_M1_CDNS_40661956134142
* cell instance $194 r0 *1 43.195,67.085
X$194 5 11 M2_M1_CDNS_40661956134140
* cell instance $195 r0 *1 11.975,118.405
X$195 5 7 M2_M1_CDNS_40661956134140
* cell instance $196 r0 *1 29.42,118.405
X$196 5 9 M2_M1_CDNS_40661956134142
* cell instance $197 r0 *1 43.195,118.405
X$197 5 11 M2_M1_CDNS_40661956134140
* cell instance $198 r0 *1 11.975,115.965
X$198 5 7 M2_M1_CDNS_40661956134140
* cell instance $199 r0 *1 29.42,115.965
X$199 5 9 M2_M1_CDNS_40661956134142
* cell instance $200 r0 *1 43.195,115.965
X$200 5 11 M2_M1_CDNS_40661956134140
* cell instance $201 r0 *1 11.975,113.525
X$201 5 7 M2_M1_CDNS_40661956134140
* cell instance $202 r0 *1 29.42,113.525
X$202 5 9 M2_M1_CDNS_40661956134142
* cell instance $203 r0 *1 43.195,113.525
X$203 5 11 M2_M1_CDNS_40661956134140
* cell instance $204 r0 *1 11.975,111.085
X$204 5 7 M2_M1_CDNS_40661956134140
* cell instance $205 r0 *1 29.42,111.085
X$205 5 9 M2_M1_CDNS_40661956134142
* cell instance $206 r0 *1 43.195,111.085
X$206 5 11 M2_M1_CDNS_40661956134140
* cell instance $207 r0 *1 11.975,30.325
X$207 5 7 M2_M1_CDNS_40661956134140
* cell instance $208 r0 *1 29.42,30.325
X$208 5 9 M2_M1_CDNS_40661956134142
* cell instance $209 r0 *1 43.195,30.325
X$209 5 11 M2_M1_CDNS_40661956134140
* cell instance $210 r0 *1 11.975,23.005
X$210 5 7 M2_M1_CDNS_40661956134140
* cell instance $211 r0 *1 29.42,23.005
X$211 5 9 M2_M1_CDNS_40661956134142
* cell instance $212 r0 *1 43.195,23.005
X$212 5 11 M2_M1_CDNS_40661956134140
* cell instance $213 r0 *1 11.975,20.565
X$213 5 7 M2_M1_CDNS_40661956134140
* cell instance $214 r0 *1 29.42,20.565
X$214 5 9 M2_M1_CDNS_40661956134142
* cell instance $215 r0 *1 43.195,20.565
X$215 5 11 M2_M1_CDNS_40661956134140
* cell instance $216 r0 *1 11.975,18.125
X$216 5 7 M2_M1_CDNS_40661956134140
* cell instance $217 r0 *1 29.42,18.125
X$217 5 9 M2_M1_CDNS_40661956134142
* cell instance $218 r0 *1 43.195,18.125
X$218 5 11 M2_M1_CDNS_40661956134140
* cell instance $219 r0 *1 11.975,15.685
X$219 5 7 M2_M1_CDNS_40661956134140
* cell instance $220 r0 *1 29.42,15.685
X$220 5 9 M2_M1_CDNS_40661956134142
* cell instance $221 r0 *1 43.195,15.685
X$221 5 11 M2_M1_CDNS_40661956134140
* cell instance $222 r0 *1 11.975,13.245
X$222 5 7 M2_M1_CDNS_40661956134140
* cell instance $223 r0 *1 29.42,13.245
X$223 5 9 M2_M1_CDNS_40661956134142
* cell instance $224 r0 *1 43.195,13.245
X$224 5 11 M2_M1_CDNS_40661956134140
* cell instance $225 r0 *1 11.975,10.805
X$225 5 7 M2_M1_CDNS_40661956134140
* cell instance $226 r0 *1 29.42,10.805
X$226 5 9 M2_M1_CDNS_40661956134142
* cell instance $227 r0 *1 43.195,10.805
X$227 5 11 M2_M1_CDNS_40661956134140
* cell instance $228 r0 *1 11.975,8.365
X$228 5 7 M2_M1_CDNS_40661956134140
* cell instance $229 r0 *1 29.42,8.365
X$229 5 9 M2_M1_CDNS_40661956134142
* cell instance $230 r0 *1 43.195,8.365
X$230 5 11 M2_M1_CDNS_40661956134140
* cell instance $231 r0 *1 11.975,96.445
X$231 5 7 M2_M1_CDNS_40661956134140
* cell instance $232 r0 *1 29.42,96.445
X$232 5 9 M2_M1_CDNS_40661956134142
* cell instance $233 r0 *1 43.195,96.445
X$233 5 11 M2_M1_CDNS_40661956134140
* cell instance $234 r0 *1 11.975,106.205
X$234 5 7 M2_M1_CDNS_40661956134140
* cell instance $235 r0 *1 29.42,106.205
X$235 5 9 M2_M1_CDNS_40661956134142
* cell instance $236 r0 *1 43.195,106.205
X$236 5 11 M2_M1_CDNS_40661956134140
* cell instance $237 r0 *1 11.975,25.445
X$237 5 7 M2_M1_CDNS_40661956134140
* cell instance $238 r0 *1 29.42,25.445
X$238 5 9 M2_M1_CDNS_40661956134142
* cell instance $239 r0 *1 43.195,25.445
X$239 5 11 M2_M1_CDNS_40661956134140
* cell instance $240 r0 *1 11.975,101.325
X$240 5 7 M2_M1_CDNS_40661956134140
* cell instance $241 r0 *1 29.42,101.325
X$241 5 9 M2_M1_CDNS_40661956134142
* cell instance $242 r0 *1 43.195,101.325
X$242 5 11 M2_M1_CDNS_40661956134140
* cell instance $243 r0 *1 11.975,98.885
X$243 5 7 M2_M1_CDNS_40661956134140
* cell instance $244 r0 *1 29.42,98.885
X$244 5 9 M2_M1_CDNS_40661956134142
* cell instance $245 r0 *1 43.195,98.885
X$245 5 11 M2_M1_CDNS_40661956134140
* cell instance $246 r0 *1 11.975,108.645
X$246 5 7 M2_M1_CDNS_40661956134140
* cell instance $247 r0 *1 29.42,108.645
X$247 5 9 M2_M1_CDNS_40661956134142
* cell instance $248 r0 *1 43.195,108.645
X$248 5 11 M2_M1_CDNS_40661956134140
* cell instance $249 r0 *1 11.975,89.045
X$249 5 7 M2_M1_CDNS_40661956134140
* cell instance $250 r0 *1 29.42,89.045
X$250 5 9 M2_M1_CDNS_40661956134142
* cell instance $251 r0 *1 43.195,89.045
X$251 5 11 M2_M1_CDNS_40661956134140
* cell instance $252 r0 *1 11.975,86.605
X$252 5 7 M2_M1_CDNS_40661956134140
* cell instance $253 r0 *1 29.42,86.605
X$253 5 9 M2_M1_CDNS_40661956134142
* cell instance $254 r0 *1 43.195,86.605
X$254 5 11 M2_M1_CDNS_40661956134140
* cell instance $255 r0 *1 11.975,84.165
X$255 5 7 M2_M1_CDNS_40661956134140
* cell instance $256 r0 *1 29.42,84.165
X$256 5 9 M2_M1_CDNS_40661956134142
* cell instance $257 r0 *1 43.195,84.165
X$257 5 11 M2_M1_CDNS_40661956134140
* cell instance $258 r0 *1 11.975,103.765
X$258 5 7 M2_M1_CDNS_40661956134140
* cell instance $259 r0 *1 29.42,103.765
X$259 5 9 M2_M1_CDNS_40661956134142
* cell instance $260 r0 *1 43.195,103.765
X$260 5 11 M2_M1_CDNS_40661956134140
* cell instance $261 r0 *1 11.975,59.685
X$261 5 7 M2_M1_CDNS_40661956134140
* cell instance $262 r0 *1 29.42,59.685
X$262 5 9 M2_M1_CDNS_40661956134142
* cell instance $263 r0 *1 43.195,59.685
X$263 5 11 M2_M1_CDNS_40661956134140
* cell instance $264 r0 *1 11.975,57.245
X$264 5 7 M2_M1_CDNS_40661956134140
* cell instance $265 r0 *1 29.42,57.245
X$265 5 9 M2_M1_CDNS_40661956134142
* cell instance $266 r0 *1 43.195,57.245
X$266 5 11 M2_M1_CDNS_40661956134140
* cell instance $267 r0 *1 11.975,54.805
X$267 5 7 M2_M1_CDNS_40661956134140
* cell instance $268 r0 *1 29.42,54.805
X$268 5 9 M2_M1_CDNS_40661956134142
* cell instance $269 r0 *1 43.195,54.805
X$269 5 11 M2_M1_CDNS_40661956134140
* cell instance $270 r0 *1 11.975,52.365
X$270 5 7 M2_M1_CDNS_40661956134140
* cell instance $271 r0 *1 29.42,52.365
X$271 5 9 M2_M1_CDNS_40661956134142
* cell instance $272 r0 *1 43.195,52.365
X$272 5 11 M2_M1_CDNS_40661956134140
* cell instance $273 r0 *1 11.975,47.485
X$273 5 7 M2_M1_CDNS_40661956134140
* cell instance $274 r0 *1 29.42,47.485
X$274 5 9 M2_M1_CDNS_40661956134142
* cell instance $275 r0 *1 43.195,47.485
X$275 5 11 M2_M1_CDNS_40661956134140
* cell instance $276 r0 *1 11.975,45.045
X$276 5 7 M2_M1_CDNS_40661956134140
* cell instance $277 r0 *1 29.42,45.045
X$277 5 9 M2_M1_CDNS_40661956134142
* cell instance $278 r0 *1 43.195,45.045
X$278 5 11 M2_M1_CDNS_40661956134140
* cell instance $279 r0 *1 11.975,27.885
X$279 5 7 M2_M1_CDNS_40661956134140
* cell instance $280 r0 *1 29.42,27.885
X$280 5 9 M2_M1_CDNS_40661956134142
* cell instance $281 r0 *1 43.195,27.885
X$281 5 11 M2_M1_CDNS_40661956134140
* cell instance $282 r0 *1 11.975,42.605
X$282 5 7 M2_M1_CDNS_40661956134140
* cell instance $283 r0 *1 29.42,42.605
X$283 5 9 M2_M1_CDNS_40661956134142
* cell instance $284 r0 *1 43.195,42.605
X$284 5 11 M2_M1_CDNS_40661956134140
* cell instance $285 r0 *1 11.975,40.165
X$285 5 7 M2_M1_CDNS_40661956134140
* cell instance $286 r0 *1 29.42,40.165
X$286 5 9 M2_M1_CDNS_40661956134142
* cell instance $287 r0 *1 43.195,40.165
X$287 5 11 M2_M1_CDNS_40661956134140
* cell instance $288 r0 *1 11.975,37.725
X$288 5 7 M2_M1_CDNS_40661956134140
* cell instance $289 r0 *1 29.42,37.725
X$289 5 9 M2_M1_CDNS_40661956134142
* cell instance $290 r0 *1 43.195,37.725
X$290 5 11 M2_M1_CDNS_40661956134140
* cell instance $291 r0 *1 11.975,49.925
X$291 5 7 M2_M1_CDNS_40661956134140
* cell instance $292 r0 *1 29.42,49.925
X$292 5 9 M2_M1_CDNS_40661956134142
* cell instance $293 r0 *1 43.195,49.925
X$293 5 11 M2_M1_CDNS_40661956134140
* cell instance $294 r0 *1 11.975,4.135
X$294 5 7 M2_M1_CDNS_40661956134144
* cell instance $295 r0 *1 29.42,4.135
X$295 5 9 M2_M1_CDNS_40661956134145
* cell instance $296 r0 *1 43.195,4.135
X$296 5 11 M2_M1_CDNS_40661956134144
* cell instance $297 r0 *1 11.975,122.635
X$297 5 7 M2_M1_CDNS_40661956134144
* cell instance $298 r0 *1 29.42,122.635
X$298 5 9 M2_M1_CDNS_40661956134145
* cell instance $299 r0 *1 43.195,122.635
X$299 5 11 M2_M1_CDNS_40661956134144
* cell instance $300 r0 *1 11.975,63.385
X$300 5 7 M2_M1_CDNS_40661956134143
* cell instance $301 r0 *1 29.42,63.385
X$301 5 9 M2_M1_CDNS_40661956134147
* cell instance $302 r0 *1 43.195,63.385
X$302 5 11 M2_M1_CDNS_40661956134143
* cell instance $303 r0 *1 11.975,34.025
X$303 5 7 M2_M1_CDNS_40661956134143
* cell instance $304 r0 *1 29.42,34.025
X$304 5 9 M2_M1_CDNS_40661956134147
* cell instance $305 r0 *1 43.195,34.025
X$305 5 11 M2_M1_CDNS_40661956134143
* cell instance $306 r0 *1 11.975,92.745
X$306 5 7 M2_M1_CDNS_40661956134143
* cell instance $307 r0 *1 29.42,92.745
X$307 5 9 M2_M1_CDNS_40661956134147
* cell instance $308 r0 *1 43.195,92.745
X$308 5 11 M2_M1_CDNS_40661956134143
.ENDS nmos_clamp_20_50_4

* cell M1_PSUB_CDNS_40661956134125
* pin
* pin
.SUBCKT M1_PSUB_CDNS_40661956134125 1 2
.ENDS M1_PSUB_CDNS_40661956134125

* cell M2_M1_CDNS_40661956134126
* pin
* pin
.SUBCKT M2_M1_CDNS_40661956134126 1 2
.ENDS M2_M1_CDNS_40661956134126

* cell M1_POLY2_CDNS_40661956134127
* pin
.SUBCKT M1_POLY2_CDNS_40661956134127 1
.ENDS M1_POLY2_CDNS_40661956134127

* cell M1_POLY2_CDNS_40661956134128
* pin
.SUBCKT M1_POLY2_CDNS_40661956134128 1
.ENDS M1_POLY2_CDNS_40661956134128

* cell M1_NWELL_CDNS_40661956134129
* pin
* pin
* pin
* pin
.SUBCKT M1_NWELL_CDNS_40661956134129 1 2 3 4
.ENDS M1_NWELL_CDNS_40661956134129

* cell M1_POLY2_CDNS_40661956134130
* pin
.SUBCKT M1_POLY2_CDNS_40661956134130 1
.ENDS M1_POLY2_CDNS_40661956134130

* cell M1_POLY2_CDNS_40661956134131
* pin
.SUBCKT M1_POLY2_CDNS_40661956134131 1
.ENDS M1_POLY2_CDNS_40661956134131

* cell M1_POLY2_CDNS_40661956134132
* pin
.SUBCKT M1_POLY2_CDNS_40661956134132 1
.ENDS M1_POLY2_CDNS_40661956134132

* cell pmos_6p0_CDNS_406619561342
* pin
* pin
* pin
* pin
* pin
* pin
* pin
* pin
* pin
* pin
* pin
* pin
* pin
* pin
* pin
* pin
* pin
* pin
* pin
* pin
* pin
* pin
* pin
* pin
* pin
* pin
* pin
* pin
* pin
* pin
* pin
* pin
* pin
* pin
* pin
* pin
* pin
* pin
* pin
* pin
* pin
* pin
* pin
* pin
* pin
* pin
* pin
* pin
* pin
* pin
* pin
.SUBCKT pmos_6p0_CDNS_406619561342 2 3 4 5 6 7 8 9 10 11 12 13 14 15 16 17 18
+ 19 20 21 22 23 24 25 26 27 28 29 30 31 32 33 34 35 36 37 38 39 40 41 42 43 44
+ 45 46 47 48 49 50 51 52
.ENDS pmos_6p0_CDNS_406619561342

* cell pmos_6p0_CDNS_406619561343
* pin
* pin
* pin
* pin
* pin
* pin
* pin
* pin
* pin
* pin
.SUBCKT pmos_6p0_CDNS_406619561343 1 2 3 4 5 6 7 8 9 10
.ENDS pmos_6p0_CDNS_406619561343

* cell pmos_6p0_CDNS_406619561344
* pin
* pin
* pin
* pin
* pin
* pin
* pin
* pin
* pin
* pin
* pin
* pin
.SUBCKT pmos_6p0_CDNS_406619561344 1 2 3 4 5 6 7 8 9 10 11 12
.ENDS pmos_6p0_CDNS_406619561344

* cell nmos_6p0_CDNS_406619561346
* pin
* pin
* pin
* pin
* pin
* pin
* pin
* pin
* pin
* pin
* pin
* pin
* pin
* pin
.SUBCKT nmos_6p0_CDNS_406619561346 1 2 3 4 5 6 7 8 9 10 11 12 13 14
.ENDS nmos_6p0_CDNS_406619561346

* cell nmos_6p0_CDNS_406619561347
* pin
* pin
* pin
* pin gf180mcu_gnd
.SUBCKT nmos_6p0_CDNS_406619561347 2 3 4 5
* net 5 gf180mcu_gnd
* device instance $1 r0 *1 0.35,2.5 nmos_6p0
M$1 3 4 2 5 nmos_6p0 L=0.7U W=5U AS=2.2P AD=2.2P PS=10.88U PD=10.88U
.ENDS nmos_6p0_CDNS_406619561347

* cell M1_NWELL_CDNS_40661956134133
* pin
* pin
* pin
* pin
.SUBCKT M1_NWELL_CDNS_40661956134133 1 2 3 4
.ENDS M1_NWELL_CDNS_40661956134133

* cell M3_M2_CDNS_40661956134114
* pin
* pin
.SUBCKT M3_M2_CDNS_40661956134114 1 2
.ENDS M3_M2_CDNS_40661956134114

* cell M2_M1_CDNS_40661956134115
* pin
* pin
.SUBCKT M2_M1_CDNS_40661956134115 1 2
.ENDS M2_M1_CDNS_40661956134115

* cell M2_M1_CDNS_40661956134250
* pin
* pin
.SUBCKT M2_M1_CDNS_40661956134250 1 2
.ENDS M2_M1_CDNS_40661956134250

* cell M2_M1_CDNS_40661956134207
* pin
* pin
.SUBCKT M2_M1_CDNS_40661956134207 1 2
.ENDS M2_M1_CDNS_40661956134207

* cell M2_M1_CDNS_40661956134166
* pin
* pin
.SUBCKT M2_M1_CDNS_40661956134166 1 2
.ENDS M2_M1_CDNS_40661956134166

* cell M2_M1_CDNS_40661956134149
* pin
* pin
.SUBCKT M2_M1_CDNS_40661956134149 1 2
.ENDS M2_M1_CDNS_40661956134149

* cell M2_M1_CDNS_40661956134150
* pin
* pin
.SUBCKT M2_M1_CDNS_40661956134150 1 2
.ENDS M2_M1_CDNS_40661956134150

* cell M2_M1_CDNS_40661956134151
* pin
* pin
.SUBCKT M2_M1_CDNS_40661956134151 1 2
.ENDS M2_M1_CDNS_40661956134151

* cell M2_M1_CDNS_40661956134152
* pin
* pin
.SUBCKT M2_M1_CDNS_40661956134152 1 2
.ENDS M2_M1_CDNS_40661956134152

* cell ppolyf_u_CDNS_406619561345
* pin
* pin
* pin gf180mcu_gnd
.SUBCKT ppolyf_u_CDNS_406619561345 1 2 3
* net 3 gf180mcu_gnd
* device instance $1 r0 *1 32.437,0.4 ppolyf_u
R$1 2 1 3 27936.5625 ppolyf_u L=63.855U W=0.8U
.ENDS ppolyf_u_CDNS_406619561345

* cell nmoscap_6p0_CDNS_406619561340
* pin
* pin
.SUBCKT nmoscap_6p0_CDNS_406619561340 1 2
* device instance $1 r0 *1 5,12.5 nmoscap_6p0
C$1 2 1 5.75e-13 nmoscap_6p0 A=250P P=70U
.ENDS nmoscap_6p0_CDNS_406619561340

* cell M1_PSUB_CDNS_4066195613411
* pin
* pin
.SUBCKT M1_PSUB_CDNS_4066195613411 1 2
.ENDS M1_PSUB_CDNS_4066195613411

* cell M1_PSUB_CDNS_406619561349
* pin
* pin
.SUBCKT M1_PSUB_CDNS_406619561349 1 2
.ENDS M1_PSUB_CDNS_406619561349

* cell M1_NWELL_CDNS_40661956134154
* pin
* pin
* pin
* pin
.SUBCKT M1_NWELL_CDNS_40661956134154 1 2 3 4
.ENDS M1_NWELL_CDNS_40661956134154

* cell M1_NWELL_CDNS_40661956134153
* pin
* pin
* pin
* pin
.SUBCKT M1_NWELL_CDNS_40661956134153 1 2 3 4
.ENDS M1_NWELL_CDNS_40661956134153

* cell M2_M1_CDNS_40661956134142
* pin
* pin
.SUBCKT M2_M1_CDNS_40661956134142 1 2
.ENDS M2_M1_CDNS_40661956134142

* cell M2_M1_CDNS_40661956134144
* pin
* pin
.SUBCKT M2_M1_CDNS_40661956134144 1 2
.ENDS M2_M1_CDNS_40661956134144

* cell M2_M1_CDNS_40661956134141
* pin
* pin
.SUBCKT M2_M1_CDNS_40661956134141 1 2
.ENDS M2_M1_CDNS_40661956134141

* cell M1_POLY2_CDNS_40661956134136
* pin
.SUBCKT M1_POLY2_CDNS_40661956134136 1
.ENDS M1_POLY2_CDNS_40661956134136

* cell M2_M1_CDNS_40661956134145
* pin
* pin
.SUBCKT M2_M1_CDNS_40661956134145 1 2
.ENDS M2_M1_CDNS_40661956134145

* cell M2_M1_CDNS_40661956134140
* pin
* pin
.SUBCKT M2_M1_CDNS_40661956134140 1 2
.ENDS M2_M1_CDNS_40661956134140

* cell M2_M1_CDNS_40661956134146
* pin
* pin
.SUBCKT M2_M1_CDNS_40661956134146 1 2
.ENDS M2_M1_CDNS_40661956134146

* cell M2_M1_CDNS_40661956134148
* pin
* pin
.SUBCKT M2_M1_CDNS_40661956134148 1 2
.ENDS M2_M1_CDNS_40661956134148

* cell M2_M1_CDNS_40661956134143
* pin
* pin
.SUBCKT M2_M1_CDNS_40661956134143 1 2
.ENDS M2_M1_CDNS_40661956134143

* cell M2_M1_CDNS_40661956134147
* pin
* pin
.SUBCKT M2_M1_CDNS_40661956134147 1 2
.ENDS M2_M1_CDNS_40661956134147

* cell nmos_6p0_CDNS_406619561341
* pin
* pin
* pin
* pin
* pin
* pin
* pin
* pin
* pin
* pin
* pin
* pin
* pin
* pin
* pin
* pin
* pin
* pin
* pin
* pin
* pin
* pin
* pin
* pin
* pin
* pin
* pin
* pin
* pin
* pin
* pin
* pin
* pin
* pin
* pin
* pin
* pin
* pin
* pin
* pin
* pin
* pin gf180mcu_gnd
.SUBCKT nmos_6p0_CDNS_406619561341 2 3 4 5 6 7 8 9 10 11 12 13 14 15 16 17 18
+ 19 20 21 22 23 24 25 26 27 28 29 30 31 32 33 34 35 36 37 38 39 40 41 42 43
* net 43 gf180mcu_gnd
* device instance $1 r0 *1 0.35,25 nmos_6p0
M$1 3 23 2 43 nmos_6p0 L=0.7U W=50U AS=22P AD=13P PS=100.88U PD=50.52U
* device instance $2 r0 *1 1.57,25 nmos_6p0
M$2 4 24 3 43 nmos_6p0 L=0.7U W=50U AS=13P AD=13P PS=50.52U PD=50.52U
* device instance $3 r0 *1 2.79,25 nmos_6p0
M$3 5 25 4 43 nmos_6p0 L=0.7U W=50U AS=13P AD=13P PS=50.52U PD=50.52U
* device instance $4 r0 *1 4.01,25 nmos_6p0
M$4 6 26 5 43 nmos_6p0 L=0.7U W=50U AS=13P AD=13P PS=50.52U PD=50.52U
* device instance $5 r0 *1 5.23,25 nmos_6p0
M$5 7 27 6 43 nmos_6p0 L=0.7U W=50U AS=13P AD=13P PS=50.52U PD=50.52U
* device instance $6 r0 *1 6.45,25 nmos_6p0
M$6 8 28 7 43 nmos_6p0 L=0.7U W=50U AS=13P AD=13P PS=50.52U PD=50.52U
* device instance $7 r0 *1 7.67,25 nmos_6p0
M$7 9 29 8 43 nmos_6p0 L=0.7U W=50U AS=13P AD=13P PS=50.52U PD=50.52U
* device instance $8 r0 *1 8.89,25 nmos_6p0
M$8 10 30 9 43 nmos_6p0 L=0.7U W=50U AS=13P AD=13P PS=50.52U PD=50.52U
* device instance $9 r0 *1 10.11,25 nmos_6p0
M$9 11 31 10 43 nmos_6p0 L=0.7U W=50U AS=13P AD=13P PS=50.52U PD=50.52U
* device instance $10 r0 *1 11.33,25 nmos_6p0
M$10 12 32 11 43 nmos_6p0 L=0.7U W=50U AS=13P AD=13P PS=50.52U PD=50.52U
* device instance $11 r0 *1 12.55,25 nmos_6p0
M$11 13 33 12 43 nmos_6p0 L=0.7U W=50U AS=13P AD=13P PS=50.52U PD=50.52U
* device instance $12 r0 *1 13.77,25 nmos_6p0
M$12 14 34 13 43 nmos_6p0 L=0.7U W=50U AS=13P AD=13P PS=50.52U PD=50.52U
* device instance $13 r0 *1 14.99,25 nmos_6p0
M$13 15 35 14 43 nmos_6p0 L=0.7U W=50U AS=13P AD=13P PS=50.52U PD=50.52U
* device instance $14 r0 *1 16.21,25 nmos_6p0
M$14 16 36 15 43 nmos_6p0 L=0.7U W=50U AS=13P AD=13P PS=50.52U PD=50.52U
* device instance $15 r0 *1 17.43,25 nmos_6p0
M$15 17 37 16 43 nmos_6p0 L=0.7U W=50U AS=13P AD=13P PS=50.52U PD=50.52U
* device instance $16 r0 *1 18.65,25 nmos_6p0
M$16 18 38 17 43 nmos_6p0 L=0.7U W=50U AS=13P AD=13P PS=50.52U PD=50.52U
* device instance $17 r0 *1 19.87,25 nmos_6p0
M$17 19 39 18 43 nmos_6p0 L=0.7U W=50U AS=13P AD=13P PS=50.52U PD=50.52U
* device instance $18 r0 *1 21.09,25 nmos_6p0
M$18 20 40 19 43 nmos_6p0 L=0.7U W=50U AS=13P AD=13P PS=50.52U PD=50.52U
* device instance $19 r0 *1 22.31,25 nmos_6p0
M$19 21 41 20 43 nmos_6p0 L=0.7U W=50U AS=13P AD=13P PS=50.52U PD=50.52U
* device instance $20 r0 *1 23.53,25 nmos_6p0
M$20 22 42 21 43 nmos_6p0 L=0.7U W=50U AS=13P AD=22P PS=50.52U PD=100.88U
.ENDS nmos_6p0_CDNS_406619561341

* cell M1_PSUB_CDNS_40661956134138
* pin
* pin
.SUBCKT M1_PSUB_CDNS_40661956134138 1 2
.ENDS M1_PSUB_CDNS_40661956134138

* cell M1_PSUB_CDNS_40661956134137
* pin
* pin
.SUBCKT M1_PSUB_CDNS_40661956134137 1 2
.ENDS M1_PSUB_CDNS_40661956134137

* cell M1_PSUB_CDNS_40661956134134
* pin
* pin
.SUBCKT M1_PSUB_CDNS_40661956134134 1 2
.ENDS M1_PSUB_CDNS_40661956134134

* cell M1_NWELL_CDNS_40661956134139
* pin
* pin
* pin
* pin
.SUBCKT M1_NWELL_CDNS_40661956134139 1 2 3 4
.ENDS M1_NWELL_CDNS_40661956134139

* cell M1_NWELL_CDNS_40661956134135
* pin
* pin
* pin
* pin
.SUBCKT M1_NWELL_CDNS_40661956134135 1 2 3 4
.ENDS M1_NWELL_CDNS_40661956134135
