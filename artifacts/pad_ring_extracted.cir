* cell PAD_RING_TOP
.SUBCKT PAD_RING_TOP
* net 2 gf180mcu_gnd
* cell instance $1 r0 *1 355.16,0
X$1 452 412 55 1 53 1 53 gf180mcu_fd_io__fill10
* cell instance $2 r0 *1 365.16,0
X$2 452 55 413 1 53 1 53 gf180mcu_fd_io__fill10
* cell instance $3 r0 *1 375.16,0
X$3 452 413 414 1 53 1 53 gf180mcu_fd_io__fill10
* cell instance $4 r0 *1 385.16,0
X$4 452 414 415 1 53 1 53 gf180mcu_fd_io__fill10
* cell instance $5 r0 *1 395.16,0
X$5 452 415 416 1 53 1 53 gf180mcu_fd_io__fill10
* cell instance $6 r0 *1 405.16,0
X$6 452 416 417 1 53 1 53 gf180mcu_fd_io__fill10
* cell instance $7 r0 *1 415.16,0
X$7 452 417 410 1 53 1 53 gf180mcu_fd_io__fill10
* cell instance $8 r0 *1 425.16,0
X$8 452 410 401 1 53 1 53 gf180mcu_fd_io__fill10
* cell instance $9 r0 *1 435.16,0
X$9 452 401 273 1 53 1 53 gf180mcu_fd_io__fill10
* cell instance $10 r0 *1 445.16,0
X$10 1 53 1 53 452 273 273 gf180mcu_fd_io__fill1
* cell instance $11 r0 *1 446.16,0
X$11 1 53 1 53 452 273 273 gf180mcu_fd_io__fill1
* cell instance $12 r0 *1 447.16,0
X$12 1 53 1 53 452 273 273 gf180mcu_fd_io__fill1
* cell instance $13 r0 *1 448.16,0
X$13 1 53 1 53 452 273 273 gf180mcu_fd_io__fill1
* cell instance $14 r0 *1 449.16,0
X$14 1 53 1 53 452 273 273 1 1 1 gf180mcu_fd_io__fillnc
* cell instance $15 r0 *1 449.26,0
X$15 1 53 1 53 452 273 273 1 1 1 gf180mcu_fd_io__fillnc
* cell instance $16 r0 *1 449.36,0
X$16 1 53 1 53 452 273 273 1 1 1 gf180mcu_fd_io__fillnc
* cell instance $17 r0 *1 449.46,0
X$17 1 53 1 53 452 273 273 1 1 1 gf180mcu_fd_io__fillnc
* cell instance $18 r0 *1 449.56,0
X$18 1 53 1 53 452 273 273 1 1 1 gf180mcu_fd_io__fillnc
* cell instance $19 r0 *1 449.66,0
X$19 1 53 1 53 452 273 273 1 1 1 gf180mcu_fd_io__fillnc
* cell instance $20 r0 *1 449.76,0
X$20 1 53 1 53 403 403 273 273 452 gf180mcu_fd_io__asig_5p0
* cell instance $21 r0 *1 524.76,0
X$21 452 403 404 1 53 1 53 gf180mcu_fd_io__fill10
* cell instance $22 r0 *1 534.76,0
X$22 452 404 405 1 53 1 53 gf180mcu_fd_io__fill10
* cell instance $23 r0 *1 544.76,0
X$23 452 405 406 1 53 1 53 gf180mcu_fd_io__fill10
* cell instance $24 r0 *1 554.76,0
X$24 452 406 407 1 53 1 53 gf180mcu_fd_io__fill10
* cell instance $25 r0 *1 564.76,0
X$25 452 407 408 1 53 1 53 gf180mcu_fd_io__fill10
* cell instance $26 r0 *1 574.76,0
X$26 452 408 409 1 53 1 53 gf180mcu_fd_io__fill10
* cell instance $27 r0 *1 584.76,0
X$27 452 409 418 1 53 1 53 gf180mcu_fd_io__fill10
* cell instance $28 r0 *1 594.76,0
X$28 452 418 411 1 53 1 53 gf180mcu_fd_io__fill10
* cell instance $29 r0 *1 604.76,0
X$29 452 411 47 1 53 1 53 gf180mcu_fd_io__fill10
* cell instance $30 r0 *1 614.76,0
X$30 1 53 1 53 452 47 47 gf180mcu_fd_io__fill1
* cell instance $31 r0 *1 615.76,0
X$31 1 53 1 53 452 47 47 gf180mcu_fd_io__fill1
* cell instance $32 r0 *1 616.76,0
X$32 1 53 1 53 452 47 47 gf180mcu_fd_io__fill1
* cell instance $33 r0 *1 617.76,0
X$33 1 53 1 53 452 47 47 gf180mcu_fd_io__fill1
* cell instance $34 r0 *1 618.76,0
X$34 1 53 1 53 452 47 47 1 1 1 gf180mcu_fd_io__fillnc
* cell instance $35 r0 *1 618.86,0
X$35 1 53 1 53 452 47 47 1 1 1 gf180mcu_fd_io__fillnc
* cell instance $36 r0 *1 618.96,0
X$36 1 53 1 53 452 47 47 1 1 1 gf180mcu_fd_io__fillnc
* cell instance $37 r0 *1 619.06,0
X$37 1 53 1 53 452 47 47 1 1 1 gf180mcu_fd_io__fillnc
* cell instance $38 r0 *1 619.16,0
X$38 1 53 1 53 452 47 47 1 1 1 gf180mcu_fd_io__fillnc
* cell instance $39 r0 *1 619.26,0
X$39 1 53 1 53 452 47 47 1 1 1 gf180mcu_fd_io__fillnc
* cell instance $40 r0 *1 619.36,0
X$40 1 53 1 53 396 396 47 47 452 gf180mcu_fd_io__asig_5p0
* cell instance $41 r0 *1 694.36,0
X$41 452 396 395 1 53 1 53 gf180mcu_fd_io__fill10
* cell instance $42 r0 *1 704.36,0
X$42 452 395 394 1 53 1 53 gf180mcu_fd_io__fill10
* cell instance $43 r0 *1 714.36,0
X$43 452 394 393 1 53 1 53 gf180mcu_fd_io__fill10
* cell instance $44 r0 *1 724.36,0
X$44 452 393 392 1 53 1 53 gf180mcu_fd_io__fill10
* cell instance $45 r0 *1 734.36,0
X$45 452 392 391 1 53 1 53 gf180mcu_fd_io__fill10
* cell instance $46 r0 *1 744.36,0
X$46 452 391 390 1 53 1 53 gf180mcu_fd_io__fill10
* cell instance $47 r0 *1 754.36,0
X$47 452 390 389 1 53 1 53 gf180mcu_fd_io__fill10
* cell instance $48 r0 *1 764.36,0
X$48 452 389 388 1 53 1 53 gf180mcu_fd_io__fill10
* cell instance $49 r0 *1 774.36,0
X$49 452 388 48 1 53 1 53 gf180mcu_fd_io__fill10
* cell instance $50 r0 *1 784.36,0
X$50 1 53 1 53 452 48 48 gf180mcu_fd_io__fill1
* cell instance $51 r0 *1 785.36,0
X$51 1 53 1 53 452 48 48 gf180mcu_fd_io__fill1
* cell instance $52 r0 *1 786.36,0
X$52 1 53 1 53 452 48 48 gf180mcu_fd_io__fill1
* cell instance $53 r0 *1 787.36,0
X$53 1 53 1 53 452 48 48 gf180mcu_fd_io__fill1
* cell instance $54 r0 *1 788.36,0
X$54 1 53 1 53 452 48 48 1 1 1 gf180mcu_fd_io__fillnc
* cell instance $55 r0 *1 788.46,0
X$55 1 53 1 53 452 48 48 1 1 1 gf180mcu_fd_io__fillnc
* cell instance $56 r0 *1 788.56,0
X$56 1 53 1 53 452 48 48 1 1 1 gf180mcu_fd_io__fillnc
* cell instance $57 r0 *1 788.66,0
X$57 1 53 1 53 452 48 48 1 1 1 gf180mcu_fd_io__fillnc
* cell instance $58 r0 *1 788.76,0
X$58 1 53 1 53 452 48 48 1 1 1 gf180mcu_fd_io__fillnc
* cell instance $59 r0 *1 788.86,0
X$59 1 53 1 53 452 48 48 1 1 1 gf180mcu_fd_io__fillnc
* cell instance $60 r0 *1 788.96,0
X$60 1 53 1 53 387 387 48 48 452 gf180mcu_fd_io__asig_5p0
* cell instance $61 r0 *1 863.96,0
X$61 452 387 434 1 53 1 53 gf180mcu_fd_io__fill10
* cell instance $62 r0 *1 873.96,0
X$62 452 434 435 1 53 1 53 gf180mcu_fd_io__fill10
* cell instance $63 r0 *1 883.96,0
X$63 452 435 436 1 53 1 53 gf180mcu_fd_io__fill10
* cell instance $64 r0 *1 893.96,0
X$64 452 436 437 1 53 1 53 gf180mcu_fd_io__fill10
* cell instance $65 r0 *1 903.96,0
X$65 452 437 438 1 53 1 53 gf180mcu_fd_io__fill10
* cell instance $66 r0 *1 913.96,0
X$66 452 438 439 1 53 1 53 gf180mcu_fd_io__fill10
* cell instance $67 r0 *1 923.96,0
X$67 452 439 440 1 53 1 53 gf180mcu_fd_io__fill10
* cell instance $68 r0 *1 933.96,0
X$68 452 440 441 1 53 1 53 gf180mcu_fd_io__fill10
* cell instance $69 r0 *1 943.96,0
X$69 452 441 45 1 53 1 53 gf180mcu_fd_io__fill10
* cell instance $70 r0 *1 953.96,0
X$70 1 53 1 53 452 45 45 gf180mcu_fd_io__fill1
* cell instance $71 r0 *1 954.96,0
X$71 1 53 1 53 452 45 45 gf180mcu_fd_io__fill1
* cell instance $72 r0 *1 955.96,0
X$72 1 53 1 53 452 45 45 gf180mcu_fd_io__fill1
* cell instance $73 r0 *1 956.96,0
X$73 1 53 1 53 452 45 45 gf180mcu_fd_io__fill1
* cell instance $74 r0 *1 957.96,0
X$74 1 53 1 53 452 45 45 1 1 1 gf180mcu_fd_io__fillnc
* cell instance $75 r0 *1 958.06,0
X$75 1 53 1 53 452 45 45 1 1 1 gf180mcu_fd_io__fillnc
* cell instance $76 r0 *1 958.16,0
X$76 1 53 1 53 452 45 45 1 1 1 gf180mcu_fd_io__fillnc
* cell instance $77 r0 *1 958.26,0
X$77 1 53 1 53 452 45 45 1 1 1 gf180mcu_fd_io__fillnc
* cell instance $78 r0 *1 958.36,0
X$78 1 53 1 53 452 45 45 1 1 1 gf180mcu_fd_io__fillnc
* cell instance $79 r0 *1 958.46,0
X$79 1 53 1 53 452 45 45 1 1 1 gf180mcu_fd_io__fillnc
* cell instance $80 r0 *1 958.56,0
X$80 1 53 1 53 451 451 45 45 452 gf180mcu_fd_io__asig_5p0
* cell instance $81 r0 *1 1033.56,0
X$81 452 451 443 1 53 1 53 gf180mcu_fd_io__fill10
* cell instance $82 r0 *1 1043.56,0
X$82 452 443 444 1 53 1 53 gf180mcu_fd_io__fill10
* cell instance $83 r0 *1 1053.56,0
X$83 452 444 445 1 53 1 53 gf180mcu_fd_io__fill10
* cell instance $84 r0 *1 1063.56,0
X$84 452 445 446 1 53 1 53 gf180mcu_fd_io__fill10
* cell instance $85 r0 *1 1073.56,0
X$85 452 446 447 1 53 1 53 gf180mcu_fd_io__fill10
* cell instance $86 r0 *1 1083.56,0
X$86 452 447 448 1 53 1 53 gf180mcu_fd_io__fill10
* cell instance $87 r0 *1 1093.56,0
X$87 452 448 449 1 53 1 53 gf180mcu_fd_io__fill10
* cell instance $88 r0 *1 1103.56,0
X$88 452 449 450 1 53 1 53 gf180mcu_fd_io__fill10
* cell instance $89 r0 *1 1113.56,0
X$89 452 450 44 1 53 1 53 gf180mcu_fd_io__fill10
* cell instance $90 r0 *1 1123.56,0
X$90 1 53 1 53 452 44 44 gf180mcu_fd_io__fill1
* cell instance $91 r0 *1 1124.56,0
X$91 1 53 1 53 452 44 44 gf180mcu_fd_io__fill1
* cell instance $92 r0 *1 1125.56,0
X$92 1 53 1 53 452 44 44 gf180mcu_fd_io__fill1
* cell instance $93 r0 *1 1126.56,0
X$93 1 53 1 53 452 44 44 gf180mcu_fd_io__fill1
* cell instance $94 r0 *1 1127.56,0
X$94 1 53 1 53 452 44 44 1 1 1 gf180mcu_fd_io__fillnc
* cell instance $95 r0 *1 1127.66,0
X$95 1 53 1 53 452 44 44 1 1 1 gf180mcu_fd_io__fillnc
* cell instance $96 r0 *1 1127.76,0
X$96 1 53 1 53 452 44 44 1 1 1 gf180mcu_fd_io__fillnc
* cell instance $97 r0 *1 1127.86,0
X$97 1 53 1 53 452 44 44 1 1 1 gf180mcu_fd_io__fillnc
* cell instance $98 r0 *1 1127.96,0
X$98 1 53 1 53 452 44 44 1 1 1 gf180mcu_fd_io__fillnc
* cell instance $99 r0 *1 1128.06,0
X$99 1 53 1 53 452 44 44 1 1 1 gf180mcu_fd_io__fillnc
* cell instance $100 r0 *1 1128.16,0
X$100 53 1 1 2 400 400 44 44 452 gf180mcu_fd_io__dvdd
* cell instance $101 r0 *1 1203.16,0
X$101 452 400 399 1 53 1 53 gf180mcu_fd_io__fill10
* cell instance $102 r0 *1 1213.16,0
X$102 452 399 398 1 53 1 53 gf180mcu_fd_io__fill10
* cell instance $103 r0 *1 1223.16,0
X$103 452 398 397 1 53 1 53 gf180mcu_fd_io__fill10
* cell instance $104 r0 *1 1233.16,0
X$104 452 397 402 1 53 1 53 gf180mcu_fd_io__fill10
* cell instance $105 r0 *1 1243.16,0
X$105 452 402 385 1 53 1 53 gf180mcu_fd_io__fill10
* cell instance $106 r0 *1 1253.16,0
X$106 452 385 442 1 53 1 53 gf180mcu_fd_io__fill10
* cell instance $107 r0 *1 1263.16,0
X$107 452 442 433 1 53 1 53 gf180mcu_fd_io__fill10
* cell instance $108 r0 *1 1273.16,0
X$108 452 433 432 1 53 1 53 gf180mcu_fd_io__fill10
* cell instance $109 r0 *1 1283.16,0
X$109 452 432 42 1 53 1 53 gf180mcu_fd_io__fill10
* cell instance $110 r0 *1 1293.16,0
X$110 1 53 1 53 452 42 42 gf180mcu_fd_io__fill1
* cell instance $111 r0 *1 1294.16,0
X$111 1 53 1 53 452 42 42 gf180mcu_fd_io__fill1
* cell instance $112 r0 *1 1295.16,0
X$112 1 53 1 53 452 42 42 gf180mcu_fd_io__fill1
* cell instance $113 r0 *1 1296.16,0
X$113 1 53 1 53 452 42 42 gf180mcu_fd_io__fill1
* cell instance $114 r0 *1 1297.16,0
X$114 1 53 1 53 452 42 42 1 1 1 gf180mcu_fd_io__fillnc
* cell instance $115 r0 *1 1297.26,0
X$115 1 53 1 53 452 42 42 1 1 1 gf180mcu_fd_io__fillnc
* cell instance $116 r0 *1 1297.36,0
X$116 1 53 1 53 452 42 42 1 1 1 gf180mcu_fd_io__fillnc
* cell instance $117 r0 *1 1297.46,0
X$117 1 53 1 53 452 42 42 1 1 1 gf180mcu_fd_io__fillnc
* cell instance $118 r0 *1 1297.56,0
X$118 1 53 1 53 452 42 42 1 1 1 gf180mcu_fd_io__fillnc
* cell instance $119 r0 *1 0,0
X$119 6 5 4 1 2 3 gf180mcu_fd_io__cor
* cell instance $120 r0 *1 1297.66,0
X$120 1 53 53 2 431 431 42 42 452 gf180mcu_fd_io__dvss
* cell instance $121 r0 *1 1372.66,0
X$121 452 431 430 1 53 1 53 gf180mcu_fd_io__fill10
* cell instance $122 r0 *1 1382.66,0
X$122 452 430 429 1 53 1 53 gf180mcu_fd_io__fill10
* cell instance $123 r0 *1 1392.66,0
X$123 452 429 428 1 53 1 53 gf180mcu_fd_io__fill10
* cell instance $124 r0 *1 1402.66,0
X$124 452 428 427 1 53 1 53 gf180mcu_fd_io__fill10
* cell instance $125 r0 *1 1412.66,0
X$125 452 427 426 1 53 1 53 gf180mcu_fd_io__fill10
* cell instance $126 r0 *1 1422.66,0
X$126 452 426 425 1 53 1 53 gf180mcu_fd_io__fill10
* cell instance $127 r0 *1 1432.66,0
X$127 452 425 424 1 53 1 53 gf180mcu_fd_io__fill10
* cell instance $128 r0 *1 1442.66,0
X$128 452 424 423 1 53 1 53 gf180mcu_fd_io__fill10
* cell instance $129 r0 *1 1452.66,0
X$129 452 423 49 1 53 1 53 gf180mcu_fd_io__fill10
* cell instance $130 r0 *1 1462.66,0
X$130 1 53 1 53 452 49 49 gf180mcu_fd_io__fill1
* cell instance $131 r0 *1 1463.66,0
X$131 1 53 1 53 452 49 49 gf180mcu_fd_io__fill1
* cell instance $132 r0 *1 1464.66,0
X$132 1 53 1 53 452 49 49 gf180mcu_fd_io__fill1
* cell instance $133 r0 *1 1465.66,0
X$133 1 53 1 53 452 49 49 gf180mcu_fd_io__fill1
* cell instance $134 r0 *1 1466.66,0
X$134 1 53 1 53 452 49 49 1 1 1 gf180mcu_fd_io__fillnc
* cell instance $135 r0 *1 1466.76,0
X$135 1 53 1 53 452 49 49 1 1 1 gf180mcu_fd_io__fillnc
* cell instance $136 r0 *1 1466.86,0
X$136 1 53 1 53 452 49 49 1 1 1 gf180mcu_fd_io__fillnc
* cell instance $137 r0 *1 1466.96,0
X$137 1 53 1 53 452 49 49 1 1 1 gf180mcu_fd_io__fillnc
* cell instance $138 r0 *1 1467.06,0
X$138 1 53 1 53 452 49 49 1 1 1 gf180mcu_fd_io__fillnc
* cell instance $139 r0 *1 1467.16,0
X$139 1 53 1 53 422 422 49 49 452 gf180mcu_fd_io__asig_5p0
* cell instance $140 r0 *1 1542.16,0
X$140 452 422 421 1 53 1 53 gf180mcu_fd_io__fill10
* cell instance $141 r0 *1 1552.16,0
X$141 452 421 420 1 53 1 53 gf180mcu_fd_io__fill10
* cell instance $142 r0 *1 1562.16,0
X$142 452 420 419 1 53 1 53 gf180mcu_fd_io__fill10
* cell instance $143 r0 *1 1572.16,0
X$143 452 419 360 1 53 1 53 gf180mcu_fd_io__fill10
* cell instance $144 r0 *1 1582.16,0
X$144 452 360 358 1 53 1 53 gf180mcu_fd_io__fill10
* cell instance $145 r0 *1 1592.16,0
X$145 452 358 354 1 53 1 53 gf180mcu_fd_io__fill10
* cell instance $146 r0 *1 1602.16,0
X$146 452 354 355 1 53 1 53 gf180mcu_fd_io__fill10
* cell instance $147 r0 *1 1612.16,0
X$147 452 355 356 1 53 1 53 gf180mcu_fd_io__fill10
* cell instance $148 r0 *1 1622.16,0
X$148 452 356 41 1 53 1 53 gf180mcu_fd_io__fill10
* cell instance $149 r0 *1 1632.16,0
X$149 1 53 1 53 452 41 41 gf180mcu_fd_io__fill1
* cell instance $150 r0 *1 1633.16,0
X$150 1 53 1 53 452 41 41 gf180mcu_fd_io__fill1
* cell instance $151 r0 *1 1634.16,0
X$151 1 53 1 53 452 41 41 gf180mcu_fd_io__fill1
* cell instance $152 r0 *1 1635.16,0
X$152 1 53 1 53 452 41 41 gf180mcu_fd_io__fill1
* cell instance $153 r0 *1 1636.16,0
X$153 1 53 1 53 452 41 41 1 1 1 gf180mcu_fd_io__fillnc
* cell instance $154 r0 *1 1636.26,0
X$154 1 53 1 53 452 41 41 1 1 1 gf180mcu_fd_io__fillnc
* cell instance $155 r0 *1 1636.36,0
X$155 1 53 1 53 452 41 41 1 1 1 gf180mcu_fd_io__fillnc
* cell instance $156 r0 *1 1636.46,0
X$156 1 53 1 53 452 41 41 1 1 1 gf180mcu_fd_io__fillnc
* cell instance $157 r0 *1 1636.56,0
X$157 1 53 1 53 452 41 41 1 1 1 gf180mcu_fd_io__fillnc
* cell instance $158 r0 *1 1636.66,0
X$158 1 53 1 53 357 357 41 41 452 gf180mcu_fd_io__asig_5p0
* cell instance $159 r0 *1 1711.66,0
X$159 452 357 359 1 53 1 53 gf180mcu_fd_io__fill10
* cell instance $160 r0 *1 1721.66,0
X$160 452 359 362 1 53 1 53 gf180mcu_fd_io__fill10
* cell instance $161 r0 *1 1731.66,0
X$161 452 362 363 1 53 1 53 gf180mcu_fd_io__fill10
* cell instance $162 r0 *1 1741.66,0
X$162 452 363 364 1 53 1 53 gf180mcu_fd_io__fill10
* cell instance $163 r0 *1 1751.66,0
X$163 452 364 382 1 53 1 53 gf180mcu_fd_io__fill10
* cell instance $164 r0 *1 1761.66,0
X$164 452 382 383 1 53 1 53 gf180mcu_fd_io__fill10
* cell instance $165 r0 *1 1771.66,0
X$165 452 383 375 1 53 1 53 gf180mcu_fd_io__fill10
* cell instance $166 r0 *1 1781.66,0
X$166 452 375 384 1 53 1 53 gf180mcu_fd_io__fill10
* cell instance $167 r0 *1 1791.66,0
X$167 452 384 43 1 53 1 53 gf180mcu_fd_io__fill10
* cell instance $168 r0 *1 1801.66,0
X$168 1 53 1 53 452 43 43 gf180mcu_fd_io__fill1
* cell instance $169 r0 *1 1802.66,0
X$169 1 53 1 53 452 43 43 gf180mcu_fd_io__fill1
* cell instance $170 r0 *1 1803.66,0
X$170 1 53 1 53 452 43 43 gf180mcu_fd_io__fill1
* cell instance $171 r0 *1 1804.66,0
X$171 1 53 1 53 452 43 43 gf180mcu_fd_io__fill1
* cell instance $172 r0 *1 1805.66,0
X$172 1 53 1 53 452 43 43 1 1 1 gf180mcu_fd_io__fillnc
* cell instance $173 r0 *1 1805.76,0
X$173 1 53 1 53 452 43 43 1 1 1 gf180mcu_fd_io__fillnc
* cell instance $174 r0 *1 1805.86,0
X$174 1 53 1 53 452 43 43 1 1 1 gf180mcu_fd_io__fillnc
* cell instance $175 r0 *1 1805.96,0
X$175 1 53 1 53 452 43 43 1 1 1 gf180mcu_fd_io__fillnc
* cell instance $176 r0 *1 1806.06,0
X$176 1 53 1 53 452 43 43 1 1 1 gf180mcu_fd_io__fillnc
* cell instance $177 r0 *1 1806.16,0
X$177 1 53 1 53 365 365 43 43 452 gf180mcu_fd_io__asig_5p0
* cell instance $178 r0 *1 1881.16,0
X$178 452 365 381 1 53 1 53 gf180mcu_fd_io__fill10
* cell instance $179 r0 *1 1891.16,0
X$179 452 381 386 1 53 1 53 gf180mcu_fd_io__fill10
* cell instance $180 r0 *1 1901.16,0
X$180 452 386 374 1 53 1 53 gf180mcu_fd_io__fill10
* cell instance $181 r0 *1 1911.16,0
X$181 452 374 373 1 53 1 53 gf180mcu_fd_io__fill10
* cell instance $182 r0 *1 1921.16,0
X$182 452 373 372 1 53 1 53 gf180mcu_fd_io__fill10
* cell instance $183 r0 *1 1931.16,0
X$183 452 372 371 1 53 1 53 gf180mcu_fd_io__fill10
* cell instance $184 r0 *1 1941.16,0
X$184 452 371 370 1 53 1 53 gf180mcu_fd_io__fill10
* cell instance $185 r0 *1 1951.16,0
X$185 452 370 369 1 53 1 53 gf180mcu_fd_io__fill10
* cell instance $186 r0 *1 1961.16,0
X$186 452 369 46 1 53 1 53 gf180mcu_fd_io__fill10
* cell instance $187 r0 *1 1971.16,0
X$187 1 53 1 53 452 46 46 gf180mcu_fd_io__fill1
* cell instance $188 r0 *1 1972.16,0
X$188 1 53 1 53 452 46 46 gf180mcu_fd_io__fill1
* cell instance $189 r0 *1 1973.16,0
X$189 1 53 1 53 452 46 46 gf180mcu_fd_io__fill1
* cell instance $190 r0 *1 1974.16,0
X$190 1 53 1 53 452 46 46 gf180mcu_fd_io__fill1
* cell instance $191 r0 *1 1975.16,0
X$191 1 53 1 53 452 46 46 1 1 1 gf180mcu_fd_io__fillnc
* cell instance $192 r0 *1 1975.26,0
X$192 1 53 1 53 452 46 46 1 1 1 gf180mcu_fd_io__fillnc
* cell instance $193 r0 *1 1975.36,0
X$193 1 53 1 53 452 46 46 1 1 1 gf180mcu_fd_io__fillnc
* cell instance $194 r0 *1 1975.46,0
X$194 1 53 1 53 452 46 46 1 1 1 gf180mcu_fd_io__fillnc
* cell instance $195 r0 *1 1975.56,0
X$195 1 53 1 53 452 46 46 1 1 1 gf180mcu_fd_io__fillnc
* cell instance $196 r0 *1 1975.66,0
X$196 1 53 1 53 368 368 46 46 452 gf180mcu_fd_io__asig_5p0
* cell instance $197 r0 *1 2050.66,0
X$197 452 368 366 1 53 1 53 gf180mcu_fd_io__fill10
* cell instance $198 r0 *1 2060.66,0
X$198 452 366 367 1 53 1 53 gf180mcu_fd_io__fill10
* cell instance $199 r0 *1 2070.66,0
X$199 452 367 376 1 53 1 53 gf180mcu_fd_io__fill10
* cell instance $200 r0 *1 2080.66,0
X$200 452 376 377 1 53 1 53 gf180mcu_fd_io__fill10
* cell instance $201 r0 *1 2090.66,0
X$201 452 377 378 1 53 1 53 gf180mcu_fd_io__fill10
* cell instance $202 r0 *1 2100.66,0
X$202 452 378 379 1 53 1 53 gf180mcu_fd_io__fill10
* cell instance $203 r0 *1 2110.66,0
X$203 452 379 380 1 53 1 53 gf180mcu_fd_io__fill10
* cell instance $204 r0 *1 2120.66,0
X$204 452 380 361 1 53 1 53 gf180mcu_fd_io__fill10
* cell instance $205 r0 *1 2130.66,0
X$205 452 361 50 1 53 1 53 gf180mcu_fd_io__fill10
* cell instance $206 r0 *1 2140.66,0
X$206 1 53 1 53 452 50 50 gf180mcu_fd_io__fill1
* cell instance $207 r0 *1 2141.66,0
X$207 1 53 1 53 452 50 50 gf180mcu_fd_io__fill1
* cell instance $208 r0 *1 2142.66,0
X$208 1 53 1 53 452 50 50 gf180mcu_fd_io__fill1
* cell instance $209 r0 *1 2143.66,0
X$209 1 53 1 53 452 50 50 gf180mcu_fd_io__fill1
* cell instance $210 r0 *1 2144.66,0
X$210 1 53 1 53 452 50 50 1 1 1 gf180mcu_fd_io__fillnc
* cell instance $211 r0 *1 2144.76,0
X$211 1 53 1 53 452 50 50 1 1 1 gf180mcu_fd_io__fillnc
* cell instance $212 r0 *1 2144.86,0
X$212 1 53 1 53 452 50 50 1 1 1 gf180mcu_fd_io__fillnc
* cell instance $213 r0 *1 2144.96,0
X$213 1 53 1 53 452 50 50 1 1 1 gf180mcu_fd_io__fillnc
* cell instance $214 r0 *1 2145.06,0
X$214 1 53 1 53 452 50 50 1 1 1 gf180mcu_fd_io__fillnc
* cell instance $215 r90 *1 2500.16,0
X$215 1 53 53 1 2 452 gf180mcu_fd_io__cor
* cell instance $216 r270 *1 0,618.76
X$216 1 52 1 52 51 22 22 gf180mcu_fd_io__fill1
* cell instance $217 r270 *1 0,617.76
X$217 1 52 1 52 51 22 22 gf180mcu_fd_io__fill1
* cell instance $218 r270 *1 0,616.76
X$218 1 52 1 52 51 22 22 gf180mcu_fd_io__fill1
* cell instance $219 r270 *1 0,618.86
X$219 1 52 1 52 51 22 22 1 1 1 gf180mcu_fd_io__fillnc
* cell instance $220 r270 *1 0,618.96
X$220 1 52 1 52 51 22 22 1 1 1 gf180mcu_fd_io__fillnc
* cell instance $221 r270 *1 0,615.76
X$221 1 52 1 52 51 22 22 gf180mcu_fd_io__fill1
* cell instance $222 r270 *1 0,614.76
X$222 51 22 279 1 52 1 52 gf180mcu_fd_io__fill10
* cell instance $223 r270 *1 0,619.06
X$223 1 52 1 52 51 22 22 1 1 1 gf180mcu_fd_io__fillnc
* cell instance $224 r270 *1 0,694.36
X$224 1 52 1 52 22 22 137 137 51 gf180mcu_fd_io__asig_5p0
* cell instance $225 r270 *1 0,619.16
X$225 1 52 1 52 51 22 22 1 1 1 gf180mcu_fd_io__fillnc
* cell instance $226 r270 *1 0,619.26
X$226 1 52 1 52 51 22 22 1 1 1 gf180mcu_fd_io__fillnc
* cell instance $227 r270 *1 0,619.36
X$227 1 52 1 52 51 22 22 1 1 1 gf180mcu_fd_io__fillnc
* cell instance $228 r270 *1 0,704.36
X$228 51 143 137 1 52 1 52 gf180mcu_fd_io__fill10
* cell instance $229 r270 *1 0,714.36
X$229 51 134 143 1 52 1 52 gf180mcu_fd_io__fill10
* cell instance $230 r270 *1 0,724.36
X$230 51 136 134 1 52 1 52 gf180mcu_fd_io__fill10
* cell instance $231 r270 *1 0,734.36
X$231 51 141 136 1 52 1 52 gf180mcu_fd_io__fill10
* cell instance $232 r270 *1 0,744.36
X$232 51 142 141 1 52 1 52 gf180mcu_fd_io__fill10
* cell instance $233 r270 *1 0,754.36
X$233 51 135 142 1 52 1 52 gf180mcu_fd_io__fill10
* cell instance $234 r270 *1 0,764.36
X$234 51 86 135 1 52 1 52 gf180mcu_fd_io__fill10
* cell instance $235 r270 *1 0,774.36
X$235 51 96 86 1 52 1 52 gf180mcu_fd_io__fill10
* cell instance $236 r270 *1 0,784.36
X$236 51 15 96 1 52 1 52 gf180mcu_fd_io__fill10
* cell instance $237 r270 *1 0,785.36
X$237 1 52 1 52 51 15 15 gf180mcu_fd_io__fill1
* cell instance $238 r270 *1 0,786.36
X$238 1 52 1 52 51 15 15 gf180mcu_fd_io__fill1
* cell instance $239 r270 *1 0,787.36
X$239 1 52 1 52 51 15 15 gf180mcu_fd_io__fill1
* cell instance $240 r270 *1 0,788.36
X$240 1 52 1 52 51 15 15 gf180mcu_fd_io__fill1
* cell instance $241 r270 *1 0,604.76
X$241 51 279 98 1 52 1 52 gf180mcu_fd_io__fill10
* cell instance $242 r270 *1 0,594.76
X$242 51 98 280 1 52 1 52 gf180mcu_fd_io__fill10
* cell instance $243 r270 *1 0,584.76
X$243 51 280 99 1 52 1 52 gf180mcu_fd_io__fill10
* cell instance $244 r270 *1 0,375.16
X$244 51 111 112 1 52 1 52 gf180mcu_fd_io__fill10
* cell instance $245 r270 *1 0,365.16
X$245 51 112 113 1 52 1 52 gf180mcu_fd_io__fill10
* cell instance $246 r270 *1 0,385.16
X$246 51 110 111 1 52 1 52 gf180mcu_fd_io__fill10
* cell instance $247 r270 *1 0,395.16
X$247 51 109 110 1 52 1 52 gf180mcu_fd_io__fill10
* cell instance $248 r270 *1 0,405.16
X$248 51 108 109 1 52 1 52 gf180mcu_fd_io__fill10
* cell instance $249 r270 *1 0,415.16
X$249 51 107 108 1 52 1 52 gf180mcu_fd_io__fill10
* cell instance $250 r270 *1 0,425.16
X$250 51 106 107 1 52 1 52 gf180mcu_fd_io__fill10
* cell instance $251 r270 *1 0,435.16
X$251 51 116 106 1 52 1 52 gf180mcu_fd_io__fill10
* cell instance $252 r270 *1 0,445.16
X$252 51 14 116 1 52 1 52 gf180mcu_fd_io__fill10
* cell instance $253 r270 *1 0,446.16
X$253 1 52 1 52 51 14 14 gf180mcu_fd_io__fill1
* cell instance $254 r270 *1 0,447.16
X$254 1 52 1 52 51 14 14 gf180mcu_fd_io__fill1
* cell instance $255 r270 *1 0,448.16
X$255 1 52 1 52 51 14 14 gf180mcu_fd_io__fill1
* cell instance $256 r270 *1 0,449.16
X$256 1 52 1 52 51 14 14 gf180mcu_fd_io__fill1
* cell instance $257 r270 *1 0,449.26
X$257 1 52 1 52 51 14 14 1 1 1 gf180mcu_fd_io__fillnc
* cell instance $258 r270 *1 0,449.36
X$258 1 52 1 52 51 14 14 1 1 1 gf180mcu_fd_io__fillnc
* cell instance $259 r270 *1 0,449.46
X$259 1 52 1 52 51 14 14 1 1 1 gf180mcu_fd_io__fillnc
* cell instance $260 r270 *1 0,524.76
X$260 1 52 1 52 14 14 104 104 51 gf180mcu_fd_io__asig_5p0
* cell instance $261 r270 *1 0,449.56
X$261 1 52 1 52 51 14 14 1 1 1 gf180mcu_fd_io__fillnc
* cell instance $262 r270 *1 0,449.66
X$262 1 52 1 52 51 14 14 1 1 1 gf180mcu_fd_io__fillnc
* cell instance $263 r270 *1 0,449.76
X$263 1 52 1 52 51 14 14 1 1 1 gf180mcu_fd_io__fillnc
* cell instance $264 r270 *1 0,534.76
X$264 51 103 104 1 52 1 52 gf180mcu_fd_io__fill10
* cell instance $265 r270 *1 0,544.76
X$265 51 102 103 1 52 1 52 gf180mcu_fd_io__fill10
* cell instance $266 r270 *1 0,554.76
X$266 51 101 102 1 52 1 52 gf180mcu_fd_io__fill10
* cell instance $267 r270 *1 0,564.76
X$267 51 100 101 1 52 1 52 gf180mcu_fd_io__fill10
* cell instance $268 r270 *1 0,574.76
X$268 51 99 100 1 52 1 52 gf180mcu_fd_io__fill10
* cell instance $269 r270 *1 0,788.56
X$269 1 52 1 52 51 15 15 1 1 1 gf180mcu_fd_io__fillnc
* cell instance $270 r270 *1 0,788.66
X$270 1 52 1 52 51 15 15 1 1 1 gf180mcu_fd_io__fillnc
* cell instance $271 r270 *1 0,863.96
X$271 1 52 1 52 15 15 95 95 51 gf180mcu_fd_io__asig_5p0
* cell instance $272 r270 *1 0,788.76
X$272 1 52 1 52 51 15 15 1 1 1 gf180mcu_fd_io__fillnc
* cell instance $273 r270 *1 0,788.86
X$273 1 52 1 52 51 15 15 1 1 1 gf180mcu_fd_io__fillnc
* cell instance $274 r270 *1 0,788.96
X$274 1 52 1 52 51 15 15 1 1 1 gf180mcu_fd_io__fillnc
* cell instance $275 r270 *1 0,873.96
X$275 51 94 95 1 52 1 52 gf180mcu_fd_io__fill10
* cell instance $276 r270 *1 0,883.96
X$276 51 93 94 1 52 1 52 gf180mcu_fd_io__fill10
* cell instance $277 r270 *1 0,893.96
X$277 51 92 93 1 52 1 52 gf180mcu_fd_io__fill10
* cell instance $278 r270 *1 0,903.96
X$278 51 91 92 1 52 1 52 gf180mcu_fd_io__fill10
* cell instance $279 r270 *1 0,913.96
X$279 51 90 91 1 52 1 52 gf180mcu_fd_io__fill10
* cell instance $280 r270 *1 0,923.96
X$280 51 89 90 1 52 1 52 gf180mcu_fd_io__fill10
* cell instance $281 r270 *1 0,933.96
X$281 51 88 89 1 52 1 52 gf180mcu_fd_io__fill10
* cell instance $282 r270 *1 0,943.96
X$282 51 87 88 1 52 1 52 gf180mcu_fd_io__fill10
* cell instance $283 r270 *1 0,953.96
X$283 51 21 87 1 52 1 52 gf180mcu_fd_io__fill10
* cell instance $284 r270 *1 0,954.96
X$284 1 52 1 52 51 21 21 gf180mcu_fd_io__fill1
* cell instance $285 r270 *1 0,955.96
X$285 1 52 1 52 51 21 21 gf180mcu_fd_io__fill1
* cell instance $286 r270 *1 0,956.96
X$286 1 52 1 52 51 21 21 gf180mcu_fd_io__fill1
* cell instance $287 r270 *1 0,957.96
X$287 1 52 1 52 51 21 21 gf180mcu_fd_io__fill1
* cell instance $288 r270 *1 0,958.06
X$288 1 52 1 52 51 21 21 1 1 1 gf180mcu_fd_io__fillnc
* cell instance $289 r270 *1 0,958.16
X$289 1 52 1 52 51 21 21 1 1 1 gf180mcu_fd_io__fillnc
* cell instance $290 r270 *1 0,1073.56
X$290 51 84 85 1 52 1 52 gf180mcu_fd_io__fill10
* cell instance $291 r270 *1 0,1063.56
X$291 51 85 277 1 52 1 52 gf180mcu_fd_io__fill10
* cell instance $292 r270 *1 0,1083.56
X$292 51 83 84 1 52 1 52 gf180mcu_fd_io__fill10
* cell instance $293 r270 *1 0,1093.56
X$293 51 82 83 1 52 1 52 gf180mcu_fd_io__fill10
* cell instance $294 r270 *1 0,1103.56
X$294 51 81 82 1 52 1 52 gf180mcu_fd_io__fill10
* cell instance $295 r270 *1 0,1113.56
X$295 51 80 81 1 52 1 52 gf180mcu_fd_io__fill10
* cell instance $296 r270 *1 0,1123.56
X$296 51 13 80 1 52 1 52 gf180mcu_fd_io__fill10
* cell instance $297 r270 *1 0,1124.56
X$297 1 52 1 52 51 13 13 gf180mcu_fd_io__fill1
* cell instance $298 r270 *1 0,1125.56
X$298 1 52 1 52 51 13 13 gf180mcu_fd_io__fill1
* cell instance $299 r270 *1 0,1126.56
X$299 1 52 1 52 51 13 13 gf180mcu_fd_io__fill1
* cell instance $300 r270 *1 0,1127.86
X$300 1 52 1 52 51 13 13 1 1 1 gf180mcu_fd_io__fillnc
* cell instance $301 r270 *1 0,1203.16
X$301 52 1 1 2 13 13 79 79 51 gf180mcu_fd_io__dvdd
* cell instance $302 r270 *1 0,1127.56
X$302 1 52 1 52 51 13 13 gf180mcu_fd_io__fill1
* cell instance $303 r270 *1 0,1127.66
X$303 1 52 1 52 51 13 13 1 1 1 gf180mcu_fd_io__fillnc
* cell instance $304 r270 *1 0,1127.76
X$304 1 52 1 52 51 13 13 1 1 1 gf180mcu_fd_io__fillnc
* cell instance $305 r270 *1 0,1053.56
X$305 51 277 278 1 52 1 52 gf180mcu_fd_io__fill10
* cell instance $306 r270 *1 0,1127.96
X$306 1 52 1 52 51 13 13 1 1 1 gf180mcu_fd_io__fillnc
* cell instance $307 r270 *1 0,1128.06
X$307 1 52 1 52 51 13 13 1 1 1 gf180mcu_fd_io__fillnc
* cell instance $308 r270 *1 0,1128.16
X$308 1 52 1 52 51 13 13 1 1 1 gf180mcu_fd_io__fillnc
* cell instance $309 r270 *1 0,1213.16
X$309 51 105 79 1 52 1 52 gf180mcu_fd_io__fill10
* cell instance $310 r270 *1 0,1223.16
X$310 51 115 105 1 52 1 52 gf180mcu_fd_io__fill10
* cell instance $311 r270 *1 0,1233.16
X$311 51 114 115 1 52 1 52 gf180mcu_fd_io__fill10
* cell instance $312 r270 *1 0,1243.16
X$312 51 62 114 1 52 1 52 gf180mcu_fd_io__fill10
* cell instance $313 r270 *1 0,1253.16
X$313 51 126 62 1 52 1 52 gf180mcu_fd_io__fill10
* cell instance $314 r270 *1 0,1263.16
X$314 51 140 126 1 52 1 52 gf180mcu_fd_io__fill10
* cell instance $315 r270 *1 0,1273.16
X$315 51 139 140 1 52 1 52 gf180mcu_fd_io__fill10
* cell instance $316 r270 *1 0,1283.16
X$316 51 138 139 1 52 1 52 gf180mcu_fd_io__fill10
* cell instance $317 r270 *1 0,1043.56
X$317 51 278 97 1 52 1 52 gf180mcu_fd_io__fill10
* cell instance $318 r270 *1 0,1033.56
X$318 1 52 1 52 21 21 97 97 51 gf180mcu_fd_io__asig_5p0
* cell instance $319 r270 *1 0,958.26
X$319 1 52 1 52 51 21 21 1 1 1 gf180mcu_fd_io__fillnc
* cell instance $320 r270 *1 0,958.36
X$320 1 52 1 52 51 21 21 1 1 1 gf180mcu_fd_io__fillnc
* cell instance $321 r270 *1 0,958.46
X$321 1 52 1 52 51 21 21 1 1 1 gf180mcu_fd_io__fillnc
* cell instance $322 r270 *1 0,958.56
X$322 1 52 1 52 51 21 21 1 1 1 gf180mcu_fd_io__fillnc
* cell instance $323 r270 *1 0,788.46
X$323 1 52 1 52 51 15 15 1 1 1 gf180mcu_fd_io__fillnc
* cell instance $324 r90 *1 2500,355.16
X$324 11 352 350 1 54 1 54 gf180mcu_fd_io__fill10
* cell instance $325 r90 *1 2500,365.16
X$325 11 350 351 1 54 1 54 gf180mcu_fd_io__fill10
* cell instance $326 r90 *1 2500,375.16
X$326 11 351 270 1 54 1 54 gf180mcu_fd_io__fill10
* cell instance $327 r90 *1 2500,449.36
X$327 1 54 1 54 11 9 9 1 1 1 gf180mcu_fd_io__fillnc
* cell instance $328 r90 *1 2500,449.76
X$328 1 54 1 54 293 293 9 9 11 gf180mcu_fd_io__asig_5p0
* cell instance $329 r90 *1 2500,449.26
X$329 1 54 1 54 11 9 9 1 1 1 gf180mcu_fd_io__fillnc
* cell instance $330 r90 *1 2500,449.46
X$330 1 54 1 54 11 9 9 1 1 1 gf180mcu_fd_io__fillnc
* cell instance $331 r90 *1 2500,449.56
X$331 1 54 1 54 11 9 9 1 1 1 gf180mcu_fd_io__fillnc
* cell instance $332 r90 *1 2500,448.16
X$332 1 54 1 54 11 9 9 gf180mcu_fd_io__fill1
* cell instance $333 r90 *1 2500,445.16
X$333 1 54 1 54 11 9 9 gf180mcu_fd_io__fill1
* cell instance $334 r90 *1 2500,446.16
X$334 1 54 1 54 11 9 9 gf180mcu_fd_io__fill1
* cell instance $335 r90 *1 2500,447.16
X$335 1 54 1 54 11 9 9 gf180mcu_fd_io__fill1
* cell instance $336 r90 *1 2500,449.16
X$336 1 54 1 54 11 9 9 1 1 1 gf180mcu_fd_io__fillnc
* cell instance $337 r90 *1 2500,425.16
X$337 11 344 292 1 54 1 54 gf180mcu_fd_io__fill10
* cell instance $338 r90 *1 2500,415.16
X$338 11 272 344 1 54 1 54 gf180mcu_fd_io__fill10
* cell instance $339 r90 *1 2500,405.16
X$339 11 353 272 1 54 1 54 gf180mcu_fd_io__fill10
* cell instance $340 r90 *1 2500,385.16
X$340 11 270 271 1 54 1 54 gf180mcu_fd_io__fill10
* cell instance $341 r90 *1 2500,395.16
X$341 11 271 353 1 54 1 54 gf180mcu_fd_io__fill10
* cell instance $342 r90 *1 2500,435.16
X$342 11 292 9 1 54 1 54 gf180mcu_fd_io__fill10
* cell instance $343 r90 *1 2500,449.66
X$343 1 54 1 54 11 9 9 1 1 1 gf180mcu_fd_io__fillnc
* cell instance $344 r90 *1 2500,524.76
X$344 11 293 294 1 54 1 54 gf180mcu_fd_io__fill10
* cell instance $345 r90 *1 2500,554.76
X$345 11 295 296 1 54 1 54 gf180mcu_fd_io__fill10
* cell instance $346 r90 *1 2500,544.76
X$346 11 255 295 1 54 1 54 gf180mcu_fd_io__fill10
* cell instance $347 r90 *1 2500,534.76
X$347 11 294 255 1 54 1 54 gf180mcu_fd_io__fill10
* cell instance $348 r90 *1 2500,564.76
X$348 11 296 297 1 54 1 54 gf180mcu_fd_io__fill10
* cell instance $349 r90 *1 2500,574.76
X$349 11 297 298 1 54 1 54 gf180mcu_fd_io__fill10
* cell instance $350 r90 *1 2500,584.76
X$350 11 298 299 1 54 1 54 gf180mcu_fd_io__fill10
* cell instance $351 r90 *1 2500,1127.96
X$351 1 54 1 54 11 39 39 1 1 1 gf180mcu_fd_io__fillnc
* cell instance $352 r90 *1 2500,1128.16
X$352 54 1 1 2 314 314 39 39 11 gf180mcu_fd_io__dvdd
* cell instance $353 r90 *1 2500,1203.16
X$353 11 314 313 1 54 1 54 gf180mcu_fd_io__fill10
* cell instance $354 r90 *1 2500,1128.06
X$354 1 54 1 54 11 39 39 1 1 1 gf180mcu_fd_io__fillnc
* cell instance $355 r90 *1 2500,1127.56
X$355 1 54 1 54 11 39 39 1 1 1 gf180mcu_fd_io__fillnc
* cell instance $356 r90 *1 2500,1126.56
X$356 1 54 1 54 11 39 39 gf180mcu_fd_io__fill1
* cell instance $357 r90 *1 2500,1127.76
X$357 1 54 1 54 11 39 39 1 1 1 gf180mcu_fd_io__fillnc
* cell instance $358 r90 *1 2500,1125.56
X$358 1 54 1 54 11 39 39 gf180mcu_fd_io__fill1
* cell instance $359 r90 *1 2500,1124.56
X$359 1 54 1 54 11 39 39 gf180mcu_fd_io__fill1
* cell instance $360 r90 *1 2500,1127.66
X$360 1 54 1 54 11 39 39 1 1 1 gf180mcu_fd_io__fillnc
* cell instance $361 r90 *1 2500,1123.56
X$361 1 54 1 54 11 39 39 gf180mcu_fd_io__fill1
* cell instance $362 r90 *1 2500,1127.86
X$362 1 54 1 54 11 39 39 1 1 1 gf180mcu_fd_io__fillnc
* cell instance $363 r90 *1 2500,1113.56
X$363 11 260 39 1 54 1 54 gf180mcu_fd_io__fill10
* cell instance $364 r90 *1 2500,1213.16
X$364 11 313 259 1 54 1 54 gf180mcu_fd_io__fill10
* cell instance $365 r90 *1 2500,1233.16
X$365 11 312 325 1 54 1 54 gf180mcu_fd_io__fill10
* cell instance $366 r90 *1 2500,1223.16
X$366 11 259 312 1 54 1 54 gf180mcu_fd_io__fill10
* cell instance $367 r90 *1 2500,1263.16
X$367 11 326 327 1 54 1 54 gf180mcu_fd_io__fill10
* cell instance $368 r90 *1 2500,1253.16
X$368 11 269 326 1 54 1 54 gf180mcu_fd_io__fill10
* cell instance $369 r90 *1 2500,1273.16
X$369 11 327 328 1 54 1 54 gf180mcu_fd_io__fill10
* cell instance $370 r90 *1 2500,1243.16
X$370 11 325 269 1 54 1 54 gf180mcu_fd_io__fill10
* cell instance $371 r90 *1 2500,1103.56
X$371 11 261 260 1 54 1 54 gf180mcu_fd_io__fill10
* cell instance $372 r90 *1 2500,1073.56
X$372 11 263 262 1 54 1 54 gf180mcu_fd_io__fill10
* cell instance $373 r90 *1 2500,1083.56
X$373 11 262 315 1 54 1 54 gf180mcu_fd_io__fill10
* cell instance $374 r90 *1 2500,1063.56
X$374 11 264 263 1 54 1 54 gf180mcu_fd_io__fill10
* cell instance $375 r90 *1 2500,1053.56
X$375 11 265 264 1 54 1 54 gf180mcu_fd_io__fill10
* cell instance $376 r90 *1 2500,1043.56
X$376 11 266 265 1 54 1 54 gf180mcu_fd_io__fill10
* cell instance $377 r90 *1 2500,1033.56
X$377 11 316 266 1 54 1 54 gf180mcu_fd_io__fill10
* cell instance $378 r90 *1 2500,958.56
X$378 1 54 1 54 316 316 10 10 11 gf180mcu_fd_io__asig_5p0
* cell instance $379 r90 *1 2500,1093.56
X$379 11 315 261 1 54 1 54 gf180mcu_fd_io__fill10
* cell instance $380 r90 *1 2500,958.36
X$380 1 54 1 54 11 10 10 1 1 1 gf180mcu_fd_io__fillnc
* cell instance $381 r90 *1 2500,958.26
X$381 1 54 1 54 11 10 10 1 1 1 gf180mcu_fd_io__fillnc
* cell instance $382 r90 *1 2500,958.16
X$382 1 54 1 54 11 10 10 1 1 1 gf180mcu_fd_io__fillnc
* cell instance $383 r90 *1 2500,958.06
X$383 1 54 1 54 11 10 10 1 1 1 gf180mcu_fd_io__fillnc
* cell instance $384 r90 *1 2500,957.96
X$384 1 54 1 54 11 10 10 1 1 1 gf180mcu_fd_io__fillnc
* cell instance $385 r90 *1 2500,956.96
X$385 1 54 1 54 11 10 10 gf180mcu_fd_io__fill1
* cell instance $386 r90 *1 2500,955.96
X$386 1 54 1 54 11 10 10 gf180mcu_fd_io__fill1
* cell instance $387 r90 *1 2500,954.96
X$387 1 54 1 54 11 10 10 gf180mcu_fd_io__fill1
* cell instance $388 r90 *1 2500,953.96
X$388 1 54 1 54 11 10 10 gf180mcu_fd_io__fill1
* cell instance $389 r90 *1 2500,943.96
X$389 11 267 10 1 54 1 54 gf180mcu_fd_io__fill10
* cell instance $390 r90 *1 2500,933.96
X$390 11 268 267 1 54 1 54 gf180mcu_fd_io__fill10
* cell instance $391 r90 *1 2500,958.46
X$391 1 54 1 54 11 10 10 1 1 1 gf180mcu_fd_io__fillnc
* cell instance $392 r90 *1 2500,923.96
X$392 11 253 268 1 54 1 54 gf180mcu_fd_io__fill10
* cell instance $393 r90 *1 2500,913.96
X$393 11 257 253 1 54 1 54 gf180mcu_fd_io__fill10
* cell instance $394 r90 *1 2500,903.96
X$394 11 252 257 1 54 1 54 gf180mcu_fd_io__fill10
* cell instance $395 r90 *1 2500,893.96
X$395 11 251 252 1 54 1 54 gf180mcu_fd_io__fill10
* cell instance $396 r90 *1 2500,883.96
X$396 11 250 251 1 54 1 54 gf180mcu_fd_io__fill10
* cell instance $397 r90 *1 2500,873.96
X$397 11 249 250 1 54 1 54 gf180mcu_fd_io__fill10
* cell instance $398 r90 *1 2500,788.66
X$398 1 54 1 54 11 8 8 1 1 1 gf180mcu_fd_io__fillnc
* cell instance $399 r90 *1 2500,788.96
X$399 1 54 1 54 284 284 8 8 11 gf180mcu_fd_io__asig_5p0
* cell instance $400 r90 *1 2500,788.56
X$400 1 54 1 54 11 8 8 1 1 1 gf180mcu_fd_io__fillnc
* cell instance $401 r90 *1 2500,788.46
X$401 1 54 1 54 11 8 8 1 1 1 gf180mcu_fd_io__fillnc
* cell instance $402 r90 *1 2500,788.36
X$402 1 54 1 54 11 8 8 1 1 1 gf180mcu_fd_io__fillnc
* cell instance $403 r90 *1 2500,787.36
X$403 1 54 1 54 11 8 8 gf180mcu_fd_io__fill1
* cell instance $404 r90 *1 2500,786.36
X$404 1 54 1 54 11 8 8 gf180mcu_fd_io__fill1
* cell instance $405 r90 *1 2500,785.36
X$405 1 54 1 54 11 8 8 gf180mcu_fd_io__fill1
* cell instance $406 r90 *1 2500,784.36
X$406 1 54 1 54 11 8 8 gf180mcu_fd_io__fill1
* cell instance $407 r90 *1 2500,774.36
X$407 11 248 8 1 54 1 54 gf180mcu_fd_io__fill10
* cell instance $408 r90 *1 2500,764.36
X$408 11 247 248 1 54 1 54 gf180mcu_fd_io__fill10
* cell instance $409 r90 *1 2500,754.36
X$409 11 246 247 1 54 1 54 gf180mcu_fd_io__fill10
* cell instance $410 r90 *1 2500,744.36
X$410 11 254 246 1 54 1 54 gf180mcu_fd_io__fill10
* cell instance $411 r90 *1 2500,734.36
X$411 11 285 254 1 54 1 54 gf180mcu_fd_io__fill10
* cell instance $412 r90 *1 2500,724.36
X$412 11 244 285 1 54 1 54 gf180mcu_fd_io__fill10
* cell instance $413 r90 *1 2500,714.36
X$413 11 245 244 1 54 1 54 gf180mcu_fd_io__fill10
* cell instance $414 r90 *1 2500,704.36
X$414 11 258 245 1 54 1 54 gf180mcu_fd_io__fill10
* cell instance $415 r90 *1 2500,694.36
X$415 11 311 258 1 54 1 54 gf180mcu_fd_io__fill10
* cell instance $416 r90 *1 2500,619.36
X$416 1 54 1 54 311 311 7 7 11 gf180mcu_fd_io__asig_5p0
* cell instance $417 r90 *1 2500,619.26
X$417 1 54 1 54 11 7 7 1 1 1 gf180mcu_fd_io__fillnc
* cell instance $418 r90 *1 2500,619.16
X$418 1 54 1 54 11 7 7 1 1 1 gf180mcu_fd_io__fillnc
* cell instance $419 r90 *1 2500,619.06
X$419 1 54 1 54 11 7 7 1 1 1 gf180mcu_fd_io__fillnc
* cell instance $420 r90 *1 2500,618.96
X$420 1 54 1 54 11 7 7 1 1 1 gf180mcu_fd_io__fillnc
* cell instance $421 r90 *1 2500,618.86
X$421 1 54 1 54 11 7 7 1 1 1 gf180mcu_fd_io__fillnc
* cell instance $422 r90 *1 2500,618.76
X$422 1 54 1 54 11 7 7 1 1 1 gf180mcu_fd_io__fillnc
* cell instance $423 r90 *1 2500,617.76
X$423 1 54 1 54 11 7 7 gf180mcu_fd_io__fill1
* cell instance $424 r90 *1 2500,616.76
X$424 1 54 1 54 11 7 7 gf180mcu_fd_io__fill1
* cell instance $425 r90 *1 2500,615.76
X$425 1 54 1 54 11 7 7 gf180mcu_fd_io__fill1
* cell instance $426 r90 *1 2500,614.76
X$426 1 54 1 54 11 7 7 gf180mcu_fd_io__fill1
* cell instance $427 r90 *1 2500,604.76
X$427 11 256 7 1 54 1 54 gf180mcu_fd_io__fill10
* cell instance $428 r90 *1 2500,863.96
X$428 11 284 249 1 54 1 54 gf180mcu_fd_io__fill10
* cell instance $429 r90 *1 2500,788.86
X$429 1 54 1 54 11 8 8 1 1 1 gf180mcu_fd_io__fillnc
* cell instance $430 r90 *1 2500,594.76
X$430 11 299 256 1 54 1 54 gf180mcu_fd_io__fill10
* cell instance $431 r90 *1 2500,788.76
X$431 1 54 1 54 11 8 8 1 1 1 gf180mcu_fd_io__fillnc
* cell instance $432 r270 *1 0,1293.16
X$432 51 17 138 1 52 1 52 gf180mcu_fd_io__fill10
* cell instance $433 r270 *1 0,1294.16
X$433 1 52 1 52 51 17 17 gf180mcu_fd_io__fill1
* cell instance $434 r90 *1 2500,1283.16
X$434 11 328 34 1 54 1 54 gf180mcu_fd_io__fill10
* cell instance $435 r90 *1 2500,1293.16
X$435 1 54 1 54 11 34 34 gf180mcu_fd_io__fill1
* cell instance $436 r270 *1 0,1295.16
X$436 1 52 1 52 51 17 17 gf180mcu_fd_io__fill1
* cell instance $437 r270 *1 0,1296.16
X$437 1 52 1 52 51 17 17 gf180mcu_fd_io__fill1
* cell instance $438 r90 *1 2500,1294.16
X$438 1 54 1 54 11 34 34 gf180mcu_fd_io__fill1
* cell instance $439 r90 *1 2500,1295.16
X$439 1 54 1 54 11 34 34 gf180mcu_fd_io__fill1
* cell instance $440 r270 *1 0,1297.16
X$440 1 52 1 52 51 17 17 gf180mcu_fd_io__fill1
* cell instance $441 r270 *1 0,1297.26
X$441 1 52 1 52 51 17 17 1 1 1 gf180mcu_fd_io__fillnc
* cell instance $442 r90 *1 2500,1296.16
X$442 1 54 1 54 11 34 34 gf180mcu_fd_io__fill1
* cell instance $443 r90 *1 2500,1297.16
X$443 1 54 1 54 11 34 34 1 1 1 gf180mcu_fd_io__fillnc
* cell instance $444 r270 *1 0,1297.36
X$444 1 52 1 52 51 17 17 1 1 1 gf180mcu_fd_io__fillnc
* cell instance $445 r270 *1 0,1297.46
X$445 1 52 1 52 51 17 17 1 1 1 gf180mcu_fd_io__fillnc
* cell instance $446 r90 *1 2500,1297.26
X$446 1 54 1 54 11 34 34 1 1 1 gf180mcu_fd_io__fillnc
* cell instance $447 r90 *1 2500,1297.36
X$447 1 54 1 54 11 34 34 1 1 1 gf180mcu_fd_io__fillnc
* cell instance $448 r270 *1 0,1372.66
X$448 1 52 52 2 17 17 117 117 51 gf180mcu_fd_io__dvss
* cell instance $449 r270 *1 0,1297.56
X$449 1 52 1 52 51 17 17 1 1 1 gf180mcu_fd_io__fillnc
* cell instance $450 r270 *1 0,1297.66
X$450 1 52 1 52 51 17 17 1 1 1 gf180mcu_fd_io__fillnc
* cell instance $451 r270 *1 0,1382.66
X$451 51 58 117 1 52 1 52 gf180mcu_fd_io__fill10
* cell instance $452 r90 *1 2500,1297.66
X$452 1 54 54 2 343 343 34 34 11 gf180mcu_fd_io__dvss
* cell instance $453 r90 *1 2500,1297.46
X$453 1 54 1 54 11 34 34 1 1 1 gf180mcu_fd_io__fillnc
* cell instance $454 r90 *1 2500,1297.56
X$454 1 54 1 54 11 34 34 1 1 1 gf180mcu_fd_io__fillnc
* cell instance $455 r90 *1 2500,1372.66
X$455 11 343 330 1 54 1 54 gf180mcu_fd_io__fill10
* cell instance $456 r270 *1 0,1392.66
X$456 51 59 58 1 52 1 52 gf180mcu_fd_io__fill10
* cell instance $457 r270 *1 0,1402.66
X$457 51 60 59 1 52 1 52 gf180mcu_fd_io__fill10
* cell instance $458 r90 *1 2500,1382.66
X$458 11 330 331 1 54 1 54 gf180mcu_fd_io__fill10
* cell instance $459 r90 *1 2500,1392.66
X$459 11 331 332 1 54 1 54 gf180mcu_fd_io__fill10
* cell instance $460 r270 *1 0,1412.66
X$460 51 57 60 1 52 1 52 gf180mcu_fd_io__fill10
* cell instance $461 r270 *1 0,1422.66
X$461 51 56 57 1 52 1 52 gf180mcu_fd_io__fill10
* cell instance $462 r90 *1 2500,1402.66
X$462 11 332 333 1 54 1 54 gf180mcu_fd_io__fill10
* cell instance $463 r90 *1 2500,1412.66
X$463 11 333 334 1 54 1 54 gf180mcu_fd_io__fill10
* cell instance $464 r270 *1 0,1432.66
X$464 51 68 56 1 52 1 52 gf180mcu_fd_io__fill10
* cell instance $465 r270 *1 0,1442.66
X$465 51 61 68 1 52 1 52 gf180mcu_fd_io__fill10
* cell instance $466 r90 *1 2500,1422.66
X$466 11 334 335 1 54 1 54 gf180mcu_fd_io__fill10
* cell instance $467 r90 *1 2500,1432.66
X$467 11 335 336 1 54 1 54 gf180mcu_fd_io__fill10
* cell instance $468 r270 *1 0,1452.66
X$468 51 144 61 1 52 1 52 gf180mcu_fd_io__fill10
* cell instance $469 r270 *1 0,1462.66
X$469 51 18 144 1 52 1 52 gf180mcu_fd_io__fill10
* cell instance $470 r90 *1 2500,1442.66
X$470 11 336 337 1 54 1 54 gf180mcu_fd_io__fill10
* cell instance $471 r90 *1 2500,1452.66
X$471 11 337 37 1 54 1 54 gf180mcu_fd_io__fill10
* cell instance $472 r270 *1 0,1463.66
X$472 1 52 1 52 51 18 18 gf180mcu_fd_io__fill1
* cell instance $473 r270 *1 0,1464.66
X$473 1 52 1 52 51 18 18 gf180mcu_fd_io__fill1
* cell instance $474 r90 *1 2500,1462.66
X$474 1 54 1 54 11 37 37 gf180mcu_fd_io__fill1
* cell instance $475 r90 *1 2500,1463.66
X$475 1 54 1 54 11 37 37 gf180mcu_fd_io__fill1
* cell instance $476 r270 *1 0,1465.66
X$476 1 52 1 52 51 18 18 gf180mcu_fd_io__fill1
* cell instance $477 r270 *1 0,1466.66
X$477 1 52 1 52 51 18 18 gf180mcu_fd_io__fill1
* cell instance $478 r90 *1 2500,1464.66
X$478 1 54 1 54 11 37 37 gf180mcu_fd_io__fill1
* cell instance $479 r90 *1 2500,1465.66
X$479 1 54 1 54 11 37 37 gf180mcu_fd_io__fill1
* cell instance $480 r270 *1 0,1466.76
X$480 1 52 1 52 51 18 18 1 1 1 gf180mcu_fd_io__fillnc
* cell instance $481 r270 *1 0,1466.86
X$481 1 52 1 52 51 18 18 1 1 1 gf180mcu_fd_io__fillnc
* cell instance $482 r90 *1 2500,1466.66
X$482 1 54 1 54 11 37 37 1 1 1 gf180mcu_fd_io__fillnc
* cell instance $483 r90 *1 2500,1466.76
X$483 1 54 1 54 11 37 37 1 1 1 gf180mcu_fd_io__fillnc
* cell instance $484 r270 *1 0,1466.96
X$484 1 52 1 52 51 18 18 1 1 1 gf180mcu_fd_io__fillnc
* cell instance $485 r270 *1 0,1467.06
X$485 1 52 1 52 51 18 18 1 1 1 gf180mcu_fd_io__fillnc
* cell instance $486 r270 *1 0,1467.16
X$486 1 52 1 52 51 18 18 1 1 1 gf180mcu_fd_io__fillnc
* cell instance $487 r90 *1 2500,1466.86
X$487 1 54 1 54 11 37 37 1 1 1 gf180mcu_fd_io__fillnc
* cell instance $488 r90 *1 2500,1466.96
X$488 1 54 1 54 11 37 37 1 1 1 gf180mcu_fd_io__fillnc
* cell instance $489 r90 *1 2500,1467.06
X$489 1 54 1 54 11 37 37 1 1 1 gf180mcu_fd_io__fillnc
* cell instance $490 r270 *1 0,1542.16
X$490 1 52 1 52 18 18 131 131 51 gf180mcu_fd_io__asig_5p0
* cell instance $491 r270 *1 0,1552.16
X$491 51 283 131 1 52 1 52 gf180mcu_fd_io__fill10
* cell instance $492 r270 *1 0,1572.16
X$492 51 281 282 1 52 1 52 gf180mcu_fd_io__fill10
* cell instance $493 r270 *1 0,1582.16
X$493 51 130 281 1 52 1 52 gf180mcu_fd_io__fill10
* cell instance $494 r270 *1 0,1562.16
X$494 51 282 283 1 52 1 52 gf180mcu_fd_io__fill10
* cell instance $495 r90 *1 2500,1467.16
X$495 1 54 1 54 338 338 37 37 11 gf180mcu_fd_io__asig_5p0
* cell instance $496 r90 *1 2500,1542.16
X$496 11 338 339 1 54 1 54 gf180mcu_fd_io__fill10
* cell instance $497 r90 *1 2500,1552.16
X$497 11 339 340 1 54 1 54 gf180mcu_fd_io__fill10
* cell instance $498 r90 *1 2500,1562.16
X$498 11 340 341 1 54 1 54 gf180mcu_fd_io__fill10
* cell instance $499 r90 *1 2500,1572.16
X$499 11 341 342 1 54 1 54 gf180mcu_fd_io__fill10
* cell instance $500 r270 *1 0,1592.16
X$500 51 129 130 1 52 1 52 gf180mcu_fd_io__fill10
* cell instance $501 r270 *1 0,1602.16
X$501 51 128 129 1 52 1 52 gf180mcu_fd_io__fill10
* cell instance $502 r90 *1 2500,1582.16
X$502 11 342 346 1 54 1 54 gf180mcu_fd_io__fill10
* cell instance $503 r90 *1 2500,1592.16
X$503 11 346 347 1 54 1 54 gf180mcu_fd_io__fill10
* cell instance $504 r270 *1 0,1612.16
X$504 51 127 128 1 52 1 52 gf180mcu_fd_io__fill10
* cell instance $505 r270 *1 0,1622.16
X$505 51 133 127 1 52 1 52 gf180mcu_fd_io__fill10
* cell instance $506 r90 *1 2500,1602.16
X$506 11 347 348 1 54 1 54 gf180mcu_fd_io__fill10
* cell instance $507 r90 *1 2500,1612.16
X$507 11 348 349 1 54 1 54 gf180mcu_fd_io__fill10
* cell instance $508 r270 *1 0,1632.16
X$508 51 12 133 1 52 1 52 gf180mcu_fd_io__fill10
* cell instance $509 r270 *1 0,1633.16
X$509 1 52 1 52 51 12 12 gf180mcu_fd_io__fill1
* cell instance $510 r90 *1 2500,1622.16
X$510 11 349 36 1 54 1 54 gf180mcu_fd_io__fill10
* cell instance $511 r90 *1 2500,1632.16
X$511 1 54 1 54 11 36 36 gf180mcu_fd_io__fill1
* cell instance $512 r270 *1 0,1634.16
X$512 1 52 1 52 51 12 12 gf180mcu_fd_io__fill1
* cell instance $513 r270 *1 0,1635.16
X$513 1 52 1 52 51 12 12 gf180mcu_fd_io__fill1
* cell instance $514 r90 *1 2500,1633.16
X$514 1 54 1 54 11 36 36 gf180mcu_fd_io__fill1
* cell instance $515 r90 *1 2500,1634.16
X$515 1 54 1 54 11 36 36 gf180mcu_fd_io__fill1
* cell instance $516 r270 *1 0,1636.16
X$516 1 52 1 52 51 12 12 gf180mcu_fd_io__fill1
* cell instance $517 r270 *1 0,1636.26
X$517 1 52 1 52 51 12 12 1 1 1 gf180mcu_fd_io__fillnc
* cell instance $518 r90 *1 2500,1635.16
X$518 1 54 1 54 11 36 36 gf180mcu_fd_io__fill1
* cell instance $519 r90 *1 2500,1636.16
X$519 1 54 1 54 11 36 36 1 1 1 gf180mcu_fd_io__fillnc
* cell instance $520 r270 *1 0,1636.36
X$520 1 52 1 52 51 12 12 1 1 1 gf180mcu_fd_io__fillnc
* cell instance $521 r270 *1 0,1636.46
X$521 1 52 1 52 51 12 12 1 1 1 gf180mcu_fd_io__fillnc
* cell instance $522 r90 *1 2500,1636.26
X$522 1 54 1 54 11 36 36 1 1 1 gf180mcu_fd_io__fillnc
* cell instance $523 r90 *1 2500,1636.36
X$523 1 54 1 54 11 36 36 1 1 1 gf180mcu_fd_io__fillnc
* cell instance $524 r270 *1 0,1711.66
X$524 1 52 1 52 12 12 125 125 51 gf180mcu_fd_io__asig_5p0
* cell instance $525 r270 *1 0,1636.56
X$525 1 52 1 52 51 12 12 1 1 1 gf180mcu_fd_io__fillnc
* cell instance $526 r270 *1 0,1636.66
X$526 1 52 1 52 51 12 12 1 1 1 gf180mcu_fd_io__fillnc
* cell instance $527 r270 *1 0,1721.66
X$527 51 132 125 1 52 1 52 gf180mcu_fd_io__fill10
* cell instance $528 r90 *1 2500,1636.66
X$528 1 54 1 54 329 329 36 36 11 gf180mcu_fd_io__asig_5p0
* cell instance $529 r90 *1 2500,1636.46
X$529 1 54 1 54 11 36 36 1 1 1 gf180mcu_fd_io__fillnc
* cell instance $530 r90 *1 2500,1636.56
X$530 1 54 1 54 11 36 36 1 1 1 gf180mcu_fd_io__fillnc
* cell instance $531 r90 *1 2500,1711.66
X$531 11 329 317 1 54 1 54 gf180mcu_fd_io__fill10
* cell instance $532 r270 *1 0,1731.66
X$532 51 124 132 1 52 1 52 gf180mcu_fd_io__fill10
* cell instance $533 r270 *1 0,1741.66
X$533 51 123 124 1 52 1 52 gf180mcu_fd_io__fill10
* cell instance $534 r90 *1 2500,1721.66
X$534 11 317 318 1 54 1 54 gf180mcu_fd_io__fill10
* cell instance $535 r90 *1 2500,1731.66
X$535 11 318 319 1 54 1 54 gf180mcu_fd_io__fill10
* cell instance $536 r270 *1 0,1751.66
X$536 51 122 123 1 52 1 52 gf180mcu_fd_io__fill10
* cell instance $537 r270 *1 0,1761.66
X$537 51 121 122 1 52 1 52 gf180mcu_fd_io__fill10
* cell instance $538 r90 *1 2500,1741.66
X$538 11 319 320 1 54 1 54 gf180mcu_fd_io__fill10
* cell instance $539 r90 *1 2500,1751.66
X$539 11 320 321 1 54 1 54 gf180mcu_fd_io__fill10
* cell instance $540 r270 *1 0,1771.66
X$540 51 120 121 1 52 1 52 gf180mcu_fd_io__fill10
* cell instance $541 r270 *1 0,1781.66
X$541 51 119 120 1 52 1 52 gf180mcu_fd_io__fill10
* cell instance $542 r90 *1 2500,1761.66
X$542 11 321 345 1 54 1 54 gf180mcu_fd_io__fill10
* cell instance $543 r90 *1 2500,1771.66
X$543 11 345 323 1 54 1 54 gf180mcu_fd_io__fill10
* cell instance $544 r270 *1 0,1791.66
X$544 51 118 119 1 52 1 52 gf180mcu_fd_io__fill10
* cell instance $545 r270 *1 0,1801.66
X$545 51 20 118 1 52 1 52 gf180mcu_fd_io__fill10
* cell instance $546 r90 *1 2500,1781.66
X$546 11 323 324 1 54 1 54 gf180mcu_fd_io__fill10
* cell instance $547 r90 *1 2500,1791.66
X$547 11 324 40 1 54 1 54 gf180mcu_fd_io__fill10
* cell instance $548 r270 *1 0,1802.66
X$548 1 52 1 52 51 20 20 gf180mcu_fd_io__fill1
* cell instance $549 r270 *1 0,1803.66
X$549 1 52 1 52 51 20 20 gf180mcu_fd_io__fill1
* cell instance $550 r90 *1 2500,1801.66
X$550 1 54 1 54 11 40 40 gf180mcu_fd_io__fill1
* cell instance $551 r90 *1 2500,1802.66
X$551 1 54 1 54 11 40 40 gf180mcu_fd_io__fill1
* cell instance $552 r270 *1 0,1804.66
X$552 1 52 1 52 51 20 20 gf180mcu_fd_io__fill1
* cell instance $553 r270 *1 0,1805.66
X$553 1 52 1 52 51 20 20 gf180mcu_fd_io__fill1
* cell instance $554 r90 *1 2500,1803.66
X$554 1 54 1 54 11 40 40 gf180mcu_fd_io__fill1
* cell instance $555 r90 *1 2500,1804.66
X$555 1 54 1 54 11 40 40 gf180mcu_fd_io__fill1
* cell instance $556 r270 *1 0,1805.76
X$556 1 52 1 52 51 20 20 1 1 1 gf180mcu_fd_io__fillnc
* cell instance $557 r270 *1 0,1805.86
X$557 1 52 1 52 51 20 20 1 1 1 gf180mcu_fd_io__fillnc
* cell instance $558 r90 *1 2500,1805.66
X$558 1 54 1 54 11 40 40 1 1 1 gf180mcu_fd_io__fillnc
* cell instance $559 r90 *1 2500,1805.76
X$559 1 54 1 54 11 40 40 1 1 1 gf180mcu_fd_io__fillnc
* cell instance $560 r270 *1 0,1805.96
X$560 1 52 1 52 51 20 20 1 1 1 gf180mcu_fd_io__fillnc
* cell instance $561 r270 *1 0,1806.06
X$561 1 52 1 52 51 20 20 1 1 1 gf180mcu_fd_io__fillnc
* cell instance $562 r270 *1 0,1806.16
X$562 1 52 1 52 51 20 20 1 1 1 gf180mcu_fd_io__fillnc
* cell instance $563 r90 *1 2500,1805.86
X$563 1 54 1 54 11 40 40 1 1 1 gf180mcu_fd_io__fillnc
* cell instance $564 r90 *1 2500,1805.96
X$564 1 54 1 54 11 40 40 1 1 1 gf180mcu_fd_io__fillnc
* cell instance $565 r90 *1 2500,1806.06
X$565 1 54 1 54 11 40 40 1 1 1 gf180mcu_fd_io__fillnc
* cell instance $566 r270 *1 0,1881.16
X$566 1 52 1 52 20 20 63 63 51 gf180mcu_fd_io__asig_5p0
* cell instance $567 r270 *1 0,1891.16
X$567 51 274 63 1 52 1 52 gf180mcu_fd_io__fill10
* cell instance $568 r270 *1 0,1911.16
X$568 51 276 275 1 52 1 52 gf180mcu_fd_io__fill10
* cell instance $569 r270 *1 0,1921.16
X$569 51 64 276 1 52 1 52 gf180mcu_fd_io__fill10
* cell instance $570 r270 *1 0,1901.16
X$570 51 275 274 1 52 1 52 gf180mcu_fd_io__fill10
* cell instance $571 r90 *1 2500,1806.16
X$571 1 54 1 54 291 291 40 40 11 gf180mcu_fd_io__asig_5p0
* cell instance $572 r90 *1 2500,1881.16
X$572 11 291 290 1 54 1 54 gf180mcu_fd_io__fill10
* cell instance $573 r90 *1 2500,1891.16
X$573 11 290 289 1 54 1 54 gf180mcu_fd_io__fill10
* cell instance $574 r90 *1 2500,1901.16
X$574 11 289 288 1 54 1 54 gf180mcu_fd_io__fill10
* cell instance $575 r90 *1 2500,1911.16
X$575 11 288 287 1 54 1 54 gf180mcu_fd_io__fill10
* cell instance $576 r270 *1 0,1931.16
X$576 51 65 64 1 52 1 52 gf180mcu_fd_io__fill10
* cell instance $577 r270 *1 0,1941.16
X$577 51 66 65 1 52 1 52 gf180mcu_fd_io__fill10
* cell instance $578 r90 *1 2500,1921.16
X$578 11 287 286 1 54 1 54 gf180mcu_fd_io__fill10
* cell instance $579 r90 *1 2500,1931.16
X$579 11 286 310 1 54 1 54 gf180mcu_fd_io__fill10
* cell instance $580 r270 *1 0,1951.16
X$580 51 67 66 1 52 1 52 gf180mcu_fd_io__fill10
* cell instance $581 r270 *1 0,1961.16
X$581 51 78 67 1 52 1 52 gf180mcu_fd_io__fill10
* cell instance $582 r90 *1 2500,1941.16
X$582 11 310 309 1 54 1 54 gf180mcu_fd_io__fill10
* cell instance $583 r90 *1 2500,1951.16
X$583 11 309 308 1 54 1 54 gf180mcu_fd_io__fill10
* cell instance $584 r270 *1 0,1971.16
X$584 51 19 78 1 52 1 52 gf180mcu_fd_io__fill10
* cell instance $585 r270 *1 0,1972.16
X$585 1 52 1 52 51 19 19 gf180mcu_fd_io__fill1
* cell instance $586 r90 *1 2500,1961.16
X$586 11 308 38 1 54 1 54 gf180mcu_fd_io__fill10
* cell instance $587 r90 *1 2500,1971.16
X$587 1 54 1 54 11 38 38 gf180mcu_fd_io__fill1
* cell instance $588 r270 *1 0,1973.16
X$588 1 52 1 52 51 19 19 gf180mcu_fd_io__fill1
* cell instance $589 r270 *1 0,1974.16
X$589 1 52 1 52 51 19 19 gf180mcu_fd_io__fill1
* cell instance $590 r90 *1 2500,1972.16
X$590 1 54 1 54 11 38 38 gf180mcu_fd_io__fill1
* cell instance $591 r90 *1 2500,1973.16
X$591 1 54 1 54 11 38 38 gf180mcu_fd_io__fill1
* cell instance $592 r270 *1 0,1975.16
X$592 1 52 1 52 51 19 19 gf180mcu_fd_io__fill1
* cell instance $593 r270 *1 0,1975.26
X$593 1 52 1 52 51 19 19 1 1 1 gf180mcu_fd_io__fillnc
* cell instance $594 r90 *1 2500,1974.16
X$594 1 54 1 54 11 38 38 gf180mcu_fd_io__fill1
* cell instance $595 r90 *1 2500,1975.16
X$595 1 54 1 54 11 38 38 1 1 1 gf180mcu_fd_io__fillnc
* cell instance $596 r270 *1 0,1975.36
X$596 1 52 1 52 51 19 19 1 1 1 gf180mcu_fd_io__fillnc
* cell instance $597 r270 *1 0,1975.46
X$597 1 52 1 52 51 19 19 1 1 1 gf180mcu_fd_io__fillnc
* cell instance $598 r90 *1 2500,1975.26
X$598 1 54 1 54 11 38 38 1 1 1 gf180mcu_fd_io__fillnc
* cell instance $599 r90 *1 2500,1975.36
X$599 1 54 1 54 11 38 38 1 1 1 gf180mcu_fd_io__fillnc
* cell instance $600 r270 *1 0,2050.66
X$600 1 52 1 52 19 19 69 69 51 gf180mcu_fd_io__asig_5p0
* cell instance $601 r270 *1 0,1975.56
X$601 1 52 1 52 51 19 19 1 1 1 gf180mcu_fd_io__fillnc
* cell instance $602 r270 *1 0,1975.66
X$602 1 52 1 52 51 19 19 1 1 1 gf180mcu_fd_io__fillnc
* cell instance $603 r270 *1 0,2060.66
X$603 51 70 69 1 52 1 52 gf180mcu_fd_io__fill10
* cell instance $604 r90 *1 2500,1975.66
X$604 1 54 1 54 307 307 38 38 11 gf180mcu_fd_io__asig_5p0
* cell instance $605 r90 *1 2500,1975.46
X$605 1 54 1 54 11 38 38 1 1 1 gf180mcu_fd_io__fillnc
* cell instance $606 r90 *1 2500,1975.56
X$606 1 54 1 54 11 38 38 1 1 1 gf180mcu_fd_io__fillnc
* cell instance $607 r90 *1 2500,2050.66
X$607 11 307 306 1 54 1 54 gf180mcu_fd_io__fill10
* cell instance $608 r270 *1 0,2070.66
X$608 51 71 70 1 52 1 52 gf180mcu_fd_io__fill10
* cell instance $609 r270 *1 0,2080.66
X$609 51 72 71 1 52 1 52 gf180mcu_fd_io__fill10
* cell instance $610 r90 *1 2500,2060.66
X$610 11 306 305 1 54 1 54 gf180mcu_fd_io__fill10
* cell instance $611 r90 *1 2500,2070.66
X$611 11 305 304 1 54 1 54 gf180mcu_fd_io__fill10
* cell instance $612 r270 *1 0,2090.66
X$612 51 73 72 1 52 1 52 gf180mcu_fd_io__fill10
* cell instance $613 r270 *1 0,2100.66
X$613 51 74 73 1 52 1 52 gf180mcu_fd_io__fill10
* cell instance $614 r90 *1 2500,2080.66
X$614 11 304 322 1 54 1 54 gf180mcu_fd_io__fill10
* cell instance $615 r90 *1 2500,2090.66
X$615 11 322 303 1 54 1 54 gf180mcu_fd_io__fill10
* cell instance $616 r270 *1 0,2110.66
X$616 51 75 74 1 52 1 52 gf180mcu_fd_io__fill10
* cell instance $617 r270 *1 0,2120.66
X$617 51 76 75 1 52 1 52 gf180mcu_fd_io__fill10
* cell instance $618 r90 *1 2500,2100.66
X$618 11 303 302 1 54 1 54 gf180mcu_fd_io__fill10
* cell instance $619 r90 *1 2500,2110.66
X$619 11 302 301 1 54 1 54 gf180mcu_fd_io__fill10
* cell instance $620 r270 *1 0,2130.66
X$620 51 77 76 1 52 1 52 gf180mcu_fd_io__fill10
* cell instance $621 r270 *1 0,2140.66
X$621 51 16 77 1 52 1 52 gf180mcu_fd_io__fill10
* cell instance $622 r90 *1 2500,2120.66
X$622 11 301 300 1 54 1 54 gf180mcu_fd_io__fill10
* cell instance $623 r90 *1 2500,2130.66
X$623 11 300 35 1 54 1 54 gf180mcu_fd_io__fill10
* cell instance $624 r270 *1 0,2141.66
X$624 1 52 1 52 51 16 16 gf180mcu_fd_io__fill1
* cell instance $625 r270 *1 0,2142.66
X$625 1 52 1 52 51 16 16 gf180mcu_fd_io__fill1
* cell instance $626 r90 *1 2500,2140.66
X$626 1 54 1 54 11 35 35 gf180mcu_fd_io__fill1
* cell instance $627 r90 *1 2500,2141.66
X$627 1 54 1 54 11 35 35 gf180mcu_fd_io__fill1
* cell instance $628 r270 *1 0,2143.66
X$628 1 52 1 52 51 16 16 gf180mcu_fd_io__fill1
* cell instance $629 r270 *1 0,2144.66
X$629 1 52 1 52 51 16 16 gf180mcu_fd_io__fill1
* cell instance $630 r90 *1 2500,2142.66
X$630 1 54 1 54 11 35 35 gf180mcu_fd_io__fill1
* cell instance $631 r90 *1 2500,2143.66
X$631 1 54 1 54 11 35 35 gf180mcu_fd_io__fill1
* cell instance $632 r270 *1 0,2144.76
X$632 1 52 1 52 51 16 16 1 1 1 gf180mcu_fd_io__fillnc
* cell instance $633 r270 *1 0,2144.86
X$633 1 52 1 52 51 16 16 1 1 1 gf180mcu_fd_io__fillnc
* cell instance $634 r90 *1 2500,2144.66
X$634 1 54 1 54 11 35 35 1 1 1 gf180mcu_fd_io__fillnc
* cell instance $635 r90 *1 2500,2144.76
X$635 1 54 1 54 11 35 35 1 1 1 gf180mcu_fd_io__fillnc
* cell instance $636 r270 *1 0,2144.96
X$636 1 52 1 52 51 16 16 1 1 1 gf180mcu_fd_io__fillnc
* cell instance $637 r270 *1 0,2145.06
X$637 1 52 1 52 51 16 16 1 1 1 gf180mcu_fd_io__fillnc
* cell instance $638 r270 *1 0,2145.16
X$638 1 52 1 52 51 16 16 1 1 1 gf180mcu_fd_io__fillnc
* cell instance $639 r90 *1 2500,2144.86
X$639 1 54 1 54 11 35 35 1 1 1 gf180mcu_fd_io__fillnc
* cell instance $640 r90 *1 2500,2144.96
X$640 1 54 1 54 11 35 35 1 1 1 gf180mcu_fd_io__fillnc
* cell instance $641 r90 *1 2500,2145.06
X$641 1 54 1 54 11 35 35 1 1 1 gf180mcu_fd_io__fillnc
* cell instance $642 r270 *1 0,2500.16
X$642 1 52 52 1 2 51 gf180mcu_fd_io__cor
* cell instance $643 r180 *1 2500.16,2500.16
X$643 1 54 54 1 2 11 gf180mcu_fd_io__cor
* cell instance $644 r180 *1 365.16,2500
X$644 11 221 220 1 54 1 54 gf180mcu_fd_io__fill10
* cell instance $645 r180 *1 375.16,2500
X$645 11 222 221 1 54 1 54 gf180mcu_fd_io__fill10
* cell instance $646 r180 *1 385.16,2500
X$646 11 223 222 1 54 1 54 gf180mcu_fd_io__fill10
* cell instance $647 r180 *1 395.16,2500
X$647 11 206 223 1 54 1 54 gf180mcu_fd_io__fill10
* cell instance $648 r180 *1 405.16,2500
X$648 11 207 206 1 54 1 54 gf180mcu_fd_io__fill10
* cell instance $649 r180 *1 415.16,2500
X$649 11 208 207 1 54 1 54 gf180mcu_fd_io__fill10
* cell instance $650 r180 *1 425.16,2500
X$650 11 209 208 1 54 1 54 gf180mcu_fd_io__fill10
* cell instance $651 r180 *1 435.16,2500
X$651 11 210 209 1 54 1 54 gf180mcu_fd_io__fill10
* cell instance $652 r180 *1 445.16,2500
X$652 11 24 210 1 54 1 54 gf180mcu_fd_io__fill10
* cell instance $653 r180 *1 446.16,2500
X$653 1 54 1 54 11 24 24 gf180mcu_fd_io__fill1
* cell instance $654 r180 *1 447.16,2500
X$654 1 54 1 54 11 24 24 gf180mcu_fd_io__fill1
* cell instance $655 r180 *1 448.16,2500
X$655 1 54 1 54 11 24 24 gf180mcu_fd_io__fill1
* cell instance $656 r180 *1 449.16,2500
X$656 1 54 1 54 11 24 24 gf180mcu_fd_io__fill1
* cell instance $657 r180 *1 449.26,2500
X$657 1 54 1 54 11 24 24 1 1 1 gf180mcu_fd_io__fillnc
* cell instance $658 r180 *1 449.36,2500
X$658 1 54 1 54 11 24 24 1 1 1 gf180mcu_fd_io__fillnc
* cell instance $659 r180 *1 449.46,2500
X$659 1 54 1 54 11 24 24 1 1 1 gf180mcu_fd_io__fillnc
* cell instance $660 r180 *1 449.56,2500
X$660 1 54 1 54 11 24 24 1 1 1 gf180mcu_fd_io__fillnc
* cell instance $661 r180 *1 449.66,2500
X$661 1 54 1 54 11 24 24 1 1 1 gf180mcu_fd_io__fillnc
* cell instance $662 r180 *1 449.76,2500
X$662 1 54 1 54 11 24 24 1 1 1 gf180mcu_fd_io__fillnc
* cell instance $663 r180 *1 524.76,2500
X$663 1 54 1 54 24 24 211 211 11 gf180mcu_fd_io__asig_5p0
* cell instance $664 r180 *1 534.76,2500
X$664 11 212 211 1 54 1 54 gf180mcu_fd_io__fill10
* cell instance $665 r180 *1 544.76,2500
X$665 11 225 212 1 54 1 54 gf180mcu_fd_io__fill10
* cell instance $666 r180 *1 554.76,2500
X$666 11 214 225 1 54 1 54 gf180mcu_fd_io__fill10
* cell instance $667 r180 *1 564.76,2500
X$667 11 215 214 1 54 1 54 gf180mcu_fd_io__fill10
* cell instance $668 r180 *1 574.76,2500
X$668 11 216 215 1 54 1 54 gf180mcu_fd_io__fill10
* cell instance $669 r180 *1 584.76,2500
X$669 11 217 216 1 54 1 54 gf180mcu_fd_io__fill10
* cell instance $670 r180 *1 594.76,2500
X$670 11 218 217 1 54 1 54 gf180mcu_fd_io__fill10
* cell instance $671 r180 *1 604.76,2500
X$671 11 219 218 1 54 1 54 gf180mcu_fd_io__fill10
* cell instance $672 r180 *1 614.76,2500
X$672 11 32 219 1 54 1 54 gf180mcu_fd_io__fill10
* cell instance $673 r180 *1 615.76,2500
X$673 1 54 1 54 11 32 32 gf180mcu_fd_io__fill1
* cell instance $674 r180 *1 616.76,2500
X$674 1 54 1 54 11 32 32 gf180mcu_fd_io__fill1
* cell instance $675 r180 *1 617.76,2500
X$675 1 54 1 54 11 32 32 gf180mcu_fd_io__fill1
* cell instance $676 r180 *1 618.76,2500
X$676 1 54 1 54 11 32 32 gf180mcu_fd_io__fill1
* cell instance $677 r180 *1 618.86,2500
X$677 1 54 1 54 11 32 32 1 1 1 gf180mcu_fd_io__fillnc
* cell instance $678 r180 *1 618.96,2500
X$678 1 54 1 54 11 32 32 1 1 1 gf180mcu_fd_io__fillnc
* cell instance $679 r180 *1 619.06,2500
X$679 1 54 1 54 11 32 32 1 1 1 gf180mcu_fd_io__fillnc
* cell instance $680 r180 *1 619.16,2500
X$680 1 54 1 54 11 32 32 1 1 1 gf180mcu_fd_io__fillnc
* cell instance $681 r180 *1 619.26,2500
X$681 1 54 1 54 11 32 32 1 1 1 gf180mcu_fd_io__fillnc
* cell instance $682 r180 *1 619.36,2500
X$682 1 54 1 54 11 32 32 1 1 1 gf180mcu_fd_io__fillnc
* cell instance $683 r180 *1 694.36,2500
X$683 1 54 1 54 32 32 146 146 11 gf180mcu_fd_io__asig_5p0
* cell instance $684 r180 *1 704.36,2500
X$684 11 147 146 1 54 1 54 gf180mcu_fd_io__fill10
* cell instance $685 r180 *1 714.36,2500
X$685 11 148 147 1 54 1 54 gf180mcu_fd_io__fill10
* cell instance $686 r180 *1 724.36,2500
X$686 11 149 148 1 54 1 54 gf180mcu_fd_io__fill10
* cell instance $687 r180 *1 734.36,2500
X$687 11 150 149 1 54 1 54 gf180mcu_fd_io__fill10
* cell instance $688 r180 *1 744.36,2500
X$688 11 151 150 1 54 1 54 gf180mcu_fd_io__fill10
* cell instance $689 r180 *1 754.36,2500
X$689 11 152 151 1 54 1 54 gf180mcu_fd_io__fill10
* cell instance $690 r180 *1 764.36,2500
X$690 11 167 152 1 54 1 54 gf180mcu_fd_io__fill10
* cell instance $691 r180 *1 774.36,2500
X$691 11 168 167 1 54 1 54 gf180mcu_fd_io__fill10
* cell instance $692 r180 *1 784.36,2500
X$692 11 28 168 1 54 1 54 gf180mcu_fd_io__fill10
* cell instance $693 r180 *1 785.36,2500
X$693 1 54 1 54 11 28 28 gf180mcu_fd_io__fill1
* cell instance $694 r180 *1 786.36,2500
X$694 1 54 1 54 11 28 28 gf180mcu_fd_io__fill1
* cell instance $695 r180 *1 787.36,2500
X$695 1 54 1 54 11 28 28 gf180mcu_fd_io__fill1
* cell instance $696 r180 *1 788.36,2500
X$696 1 54 1 54 11 28 28 gf180mcu_fd_io__fill1
* cell instance $697 r180 *1 788.46,2500
X$697 1 54 1 54 11 28 28 1 1 1 gf180mcu_fd_io__fillnc
* cell instance $698 r180 *1 788.56,2500
X$698 1 54 1 54 11 28 28 1 1 1 gf180mcu_fd_io__fillnc
* cell instance $699 r180 *1 788.66,2500
X$699 1 54 1 54 11 28 28 1 1 1 gf180mcu_fd_io__fillnc
* cell instance $700 r180 *1 788.76,2500
X$700 1 54 1 54 11 28 28 1 1 1 gf180mcu_fd_io__fillnc
* cell instance $701 r180 *1 788.86,2500
X$701 1 54 1 54 11 28 28 1 1 1 gf180mcu_fd_io__fillnc
* cell instance $702 r180 *1 788.96,2500
X$702 1 54 1 54 11 28 28 1 1 1 gf180mcu_fd_io__fillnc
* cell instance $703 r180 *1 863.96,2500
X$703 1 54 1 54 28 28 230 230 11 gf180mcu_fd_io__asig_5p0
* cell instance $704 r180 *1 873.96,2500
X$704 11 227 230 1 54 1 54 gf180mcu_fd_io__fill10
* cell instance $705 r180 *1 883.96,2500
X$705 11 226 227 1 54 1 54 gf180mcu_fd_io__fill10
* cell instance $706 r180 *1 893.96,2500
X$706 11 242 226 1 54 1 54 gf180mcu_fd_io__fill10
* cell instance $707 r180 *1 903.96,2500
X$707 11 241 242 1 54 1 54 gf180mcu_fd_io__fill10
* cell instance $708 r180 *1 913.96,2500
X$708 11 240 241 1 54 1 54 gf180mcu_fd_io__fill10
* cell instance $709 r180 *1 923.96,2500
X$709 11 239 240 1 54 1 54 gf180mcu_fd_io__fill10
* cell instance $710 r180 *1 933.96,2500
X$710 11 233 239 1 54 1 54 gf180mcu_fd_io__fill10
* cell instance $711 r180 *1 943.96,2500
X$711 11 232 233 1 54 1 54 gf180mcu_fd_io__fill10
* cell instance $712 r180 *1 953.96,2500
X$712 11 33 232 1 54 1 54 gf180mcu_fd_io__fill10
* cell instance $713 r180 *1 954.96,2500
X$713 1 54 1 54 11 33 33 gf180mcu_fd_io__fill1
* cell instance $714 r180 *1 955.96,2500
X$714 1 54 1 54 11 33 33 gf180mcu_fd_io__fill1
* cell instance $715 r180 *1 956.96,2500
X$715 1 54 1 54 11 33 33 gf180mcu_fd_io__fill1
* cell instance $716 r180 *1 957.96,2500
X$716 1 54 1 54 11 33 33 gf180mcu_fd_io__fill1
* cell instance $717 r180 *1 958.06,2500
X$717 1 54 1 54 11 33 33 1 1 1 gf180mcu_fd_io__fillnc
* cell instance $718 r180 *1 958.16,2500
X$718 1 54 1 54 11 33 33 1 1 1 gf180mcu_fd_io__fillnc
* cell instance $719 r180 *1 958.26,2500
X$719 1 54 1 54 11 33 33 1 1 1 gf180mcu_fd_io__fillnc
* cell instance $720 r180 *1 958.36,2500
X$720 1 54 1 54 11 33 33 1 1 1 gf180mcu_fd_io__fillnc
* cell instance $721 r180 *1 958.46,2500
X$721 1 54 1 54 11 33 33 1 1 1 gf180mcu_fd_io__fillnc
* cell instance $722 r180 *1 958.56,2500
X$722 1 54 1 54 11 33 33 1 1 1 gf180mcu_fd_io__fillnc
* cell instance $723 r180 *1 1033.56,2500
X$723 1 54 1 54 33 33 231 231 11 gf180mcu_fd_io__asig_5p0
* cell instance $724 r180 *1 1043.56,2500
X$724 11 229 231 1 54 1 54 gf180mcu_fd_io__fill10
* cell instance $725 r180 *1 1053.56,2500
X$725 11 228 229 1 54 1 54 gf180mcu_fd_io__fill10
* cell instance $726 r180 *1 1063.56,2500
X$726 11 234 228 1 54 1 54 gf180mcu_fd_io__fill10
* cell instance $727 r180 *1 1073.56,2500
X$727 11 243 234 1 54 1 54 gf180mcu_fd_io__fill10
* cell instance $728 r180 *1 1083.56,2500
X$728 11 235 243 1 54 1 54 gf180mcu_fd_io__fill10
* cell instance $729 r180 *1 1093.56,2500
X$729 11 236 235 1 54 1 54 gf180mcu_fd_io__fill10
* cell instance $730 r180 *1 1103.56,2500
X$730 11 237 236 1 54 1 54 gf180mcu_fd_io__fill10
* cell instance $731 r180 *1 1113.56,2500
X$731 11 238 237 1 54 1 54 gf180mcu_fd_io__fill10
* cell instance $732 r180 *1 1123.56,2500
X$732 11 23 238 1 54 1 54 gf180mcu_fd_io__fill10
* cell instance $733 r180 *1 1124.56,2500
X$733 1 54 1 54 11 23 23 gf180mcu_fd_io__fill1
* cell instance $734 r180 *1 1125.56,2500
X$734 1 54 1 54 11 23 23 gf180mcu_fd_io__fill1
* cell instance $735 r180 *1 1126.56,2500
X$735 1 54 1 54 11 23 23 gf180mcu_fd_io__fill1
* cell instance $736 r180 *1 1127.56,2500
X$736 1 54 1 54 11 23 23 gf180mcu_fd_io__fill1
* cell instance $737 r180 *1 1127.66,2500
X$737 1 54 1 54 11 23 23 1 1 1 gf180mcu_fd_io__fillnc
* cell instance $738 r180 *1 1127.76,2500
X$738 1 54 1 54 11 23 23 1 1 1 gf180mcu_fd_io__fillnc
* cell instance $739 r180 *1 1127.86,2500
X$739 1 54 1 54 11 23 23 1 1 1 gf180mcu_fd_io__fillnc
* cell instance $740 r180 *1 1127.96,2500
X$740 1 54 1 54 11 23 23 1 1 1 gf180mcu_fd_io__fillnc
* cell instance $741 r180 *1 1128.06,2500
X$741 1 54 1 54 11 23 23 1 1 1 gf180mcu_fd_io__fillnc
* cell instance $742 r180 *1 1128.16,2500
X$742 1 54 1 54 11 23 23 1 1 1 gf180mcu_fd_io__fillnc
* cell instance $743 r180 *1 1203.16,2500
X$743 54 1 1 2 23 23 213 213 11 gf180mcu_fd_io__dvdd
* cell instance $744 r180 *1 1213.16,2500
X$744 11 203 213 1 54 1 54 gf180mcu_fd_io__fill10
* cell instance $745 r180 *1 1223.16,2500
X$745 11 204 203 1 54 1 54 gf180mcu_fd_io__fill10
* cell instance $746 r180 *1 1233.16,2500
X$746 11 205 204 1 54 1 54 gf180mcu_fd_io__fill10
* cell instance $747 r180 *1 1243.16,2500
X$747 11 224 205 1 54 1 54 gf180mcu_fd_io__fill10
* cell instance $748 r180 *1 1253.16,2500
X$748 11 176 224 1 54 1 54 gf180mcu_fd_io__fill10
* cell instance $749 r180 *1 1263.16,2500
X$749 11 200 176 1 54 1 54 gf180mcu_fd_io__fill10
* cell instance $750 r180 *1 1273.16,2500
X$750 11 186 200 1 54 1 54 gf180mcu_fd_io__fill10
* cell instance $751 r180 *1 1283.16,2500
X$751 11 201 186 1 54 1 54 gf180mcu_fd_io__fill10
* cell instance $752 r180 *1 1293.16,2500
X$752 11 31 201 1 54 1 54 gf180mcu_fd_io__fill10
* cell instance $753 r180 *1 1294.16,2500
X$753 1 54 1 54 11 31 31 gf180mcu_fd_io__fill1
* cell instance $754 r180 *1 1295.16,2500
X$754 1 54 1 54 11 31 31 gf180mcu_fd_io__fill1
* cell instance $755 r180 *1 1296.16,2500
X$755 1 54 1 54 11 31 31 gf180mcu_fd_io__fill1
* cell instance $756 r180 *1 1297.16,2500
X$756 1 54 1 54 11 31 31 gf180mcu_fd_io__fill1
* cell instance $757 r180 *1 1297.26,2500
X$757 1 54 1 54 11 31 31 1 1 1 gf180mcu_fd_io__fillnc
* cell instance $758 r180 *1 1297.36,2500
X$758 1 54 1 54 11 31 31 1 1 1 gf180mcu_fd_io__fillnc
* cell instance $759 r180 *1 1297.46,2500
X$759 1 54 1 54 11 31 31 1 1 1 gf180mcu_fd_io__fillnc
* cell instance $760 r180 *1 1297.56,2500
X$760 1 54 1 54 11 31 31 1 1 1 gf180mcu_fd_io__fillnc
* cell instance $761 r180 *1 1297.66,2500
X$761 1 54 1 54 11 31 31 1 1 1 gf180mcu_fd_io__fillnc
* cell instance $762 r180 *1 1372.66,2500
X$762 1 54 54 2 31 31 164 164 11 gf180mcu_fd_io__dvss
* cell instance $763 r180 *1 1382.66,2500
X$763 11 163 164 1 54 1 54 gf180mcu_fd_io__fill10
* cell instance $764 r180 *1 1392.66,2500
X$764 11 159 163 1 54 1 54 gf180mcu_fd_io__fill10
* cell instance $765 r180 *1 1402.66,2500
X$765 11 155 159 1 54 1 54 gf180mcu_fd_io__fill10
* cell instance $766 r180 *1 1412.66,2500
X$766 11 154 155 1 54 1 54 gf180mcu_fd_io__fill10
* cell instance $767 r180 *1 1422.66,2500
X$767 11 182 154 1 54 1 54 gf180mcu_fd_io__fill10
* cell instance $768 r180 *1 1432.66,2500
X$768 11 181 182 1 54 1 54 gf180mcu_fd_io__fill10
* cell instance $769 r180 *1 1442.66,2500
X$769 11 179 181 1 54 1 54 gf180mcu_fd_io__fill10
* cell instance $770 r180 *1 1452.66,2500
X$770 11 178 179 1 54 1 54 gf180mcu_fd_io__fill10
* cell instance $771 r180 *1 1462.66,2500
X$771 11 25 178 1 54 1 54 gf180mcu_fd_io__fill10
* cell instance $772 r180 *1 1463.66,2500
X$772 1 54 1 54 11 25 25 gf180mcu_fd_io__fill1
* cell instance $773 r180 *1 1464.66,2500
X$773 1 54 1 54 11 25 25 gf180mcu_fd_io__fill1
* cell instance $774 r180 *1 1465.66,2500
X$774 1 54 1 54 11 25 25 gf180mcu_fd_io__fill1
* cell instance $775 r180 *1 1466.66,2500
X$775 1 54 1 54 11 25 25 gf180mcu_fd_io__fill1
* cell instance $776 r180 *1 1466.76,2500
X$776 1 54 1 54 11 25 25 1 1 1 gf180mcu_fd_io__fillnc
* cell instance $777 r180 *1 1466.86,2500
X$777 1 54 1 54 11 25 25 1 1 1 gf180mcu_fd_io__fillnc
* cell instance $778 r180 *1 1466.96,2500
X$778 1 54 1 54 11 25 25 1 1 1 gf180mcu_fd_io__fillnc
* cell instance $779 r180 *1 1467.06,2500
X$779 1 54 1 54 11 25 25 1 1 1 gf180mcu_fd_io__fillnc
* cell instance $780 r180 *1 1467.16,2500
X$780 1 54 1 54 11 25 25 1 1 1 gf180mcu_fd_io__fillnc
* cell instance $781 r180 *1 1542.16,2500
X$781 1 54 1 54 25 25 177 177 11 gf180mcu_fd_io__asig_5p0
* cell instance $782 r180 *1 1552.16,2500
X$782 11 145 177 1 54 1 54 gf180mcu_fd_io__fill10
* cell instance $783 r180 *1 1562.16,2500
X$783 11 153 145 1 54 1 54 gf180mcu_fd_io__fill10
* cell instance $784 r180 *1 1572.16,2500
X$784 11 156 153 1 54 1 54 gf180mcu_fd_io__fill10
* cell instance $785 r180 *1 1582.16,2500
X$785 11 166 156 1 54 1 54 gf180mcu_fd_io__fill10
* cell instance $786 r180 *1 1592.16,2500
X$786 11 169 166 1 54 1 54 gf180mcu_fd_io__fill10
* cell instance $787 r180 *1 1602.16,2500
X$787 11 183 169 1 54 1 54 gf180mcu_fd_io__fill10
* cell instance $788 r180 *1 1612.16,2500
X$788 11 175 183 1 54 1 54 gf180mcu_fd_io__fill10
* cell instance $789 r180 *1 1622.16,2500
X$789 11 174 175 1 54 1 54 gf180mcu_fd_io__fill10
* cell instance $790 r180 *1 1632.16,2500
X$790 11 30 174 1 54 1 54 gf180mcu_fd_io__fill10
* cell instance $791 r180 *1 1633.16,2500
X$791 1 54 1 54 11 30 30 gf180mcu_fd_io__fill1
* cell instance $792 r180 *1 1634.16,2500
X$792 1 54 1 54 11 30 30 gf180mcu_fd_io__fill1
* cell instance $793 r180 *1 1635.16,2500
X$793 1 54 1 54 11 30 30 gf180mcu_fd_io__fill1
* cell instance $794 r180 *1 1636.16,2500
X$794 1 54 1 54 11 30 30 gf180mcu_fd_io__fill1
* cell instance $795 r180 *1 1636.26,2500
X$795 1 54 1 54 11 30 30 1 1 1 gf180mcu_fd_io__fillnc
* cell instance $796 r180 *1 1636.36,2500
X$796 1 54 1 54 11 30 30 1 1 1 gf180mcu_fd_io__fillnc
* cell instance $797 r180 *1 1636.46,2500
X$797 1 54 1 54 11 30 30 1 1 1 gf180mcu_fd_io__fillnc
* cell instance $798 r180 *1 1636.56,2500
X$798 1 54 1 54 11 30 30 1 1 1 gf180mcu_fd_io__fillnc
* cell instance $799 r180 *1 1636.66,2500
X$799 1 54 1 54 11 30 30 1 1 1 gf180mcu_fd_io__fillnc
* cell instance $800 r180 *1 1711.66,2500
X$800 1 54 1 54 30 30 184 184 11 gf180mcu_fd_io__asig_5p0
* cell instance $801 r180 *1 1721.66,2500
X$801 11 185 184 1 54 1 54 gf180mcu_fd_io__fill10
* cell instance $802 r180 *1 1731.66,2500
X$802 11 202 185 1 54 1 54 gf180mcu_fd_io__fill10
* cell instance $803 r180 *1 1741.66,2500
X$803 11 191 202 1 54 1 54 gf180mcu_fd_io__fill10
* cell instance $804 r180 *1 1751.66,2500
X$804 11 192 191 1 54 1 54 gf180mcu_fd_io__fill10
* cell instance $805 r180 *1 1761.66,2500
X$805 11 193 192 1 54 1 54 gf180mcu_fd_io__fill10
* cell instance $806 r180 *1 1771.66,2500
X$806 11 197 193 1 54 1 54 gf180mcu_fd_io__fill10
* cell instance $807 r180 *1 1781.66,2500
X$807 11 198 197 1 54 1 54 gf180mcu_fd_io__fill10
* cell instance $808 r180 *1 1791.66,2500
X$808 11 199 198 1 54 1 54 gf180mcu_fd_io__fill10
* cell instance $809 r180 *1 1801.66,2500
X$809 11 26 199 1 54 1 54 gf180mcu_fd_io__fill10
* cell instance $810 r180 *1 1802.66,2500
X$810 1 54 1 54 11 26 26 gf180mcu_fd_io__fill1
* cell instance $811 r180 *1 1803.66,2500
X$811 1 54 1 54 11 26 26 gf180mcu_fd_io__fill1
* cell instance $812 r180 *1 1804.66,2500
X$812 1 54 1 54 11 26 26 gf180mcu_fd_io__fill1
* cell instance $813 r180 *1 1805.66,2500
X$813 1 54 1 54 11 26 26 gf180mcu_fd_io__fill1
* cell instance $814 r180 *1 1805.76,2500
X$814 1 54 1 54 11 26 26 1 1 1 gf180mcu_fd_io__fillnc
* cell instance $815 r180 *1 1805.86,2500
X$815 1 54 1 54 11 26 26 1 1 1 gf180mcu_fd_io__fillnc
* cell instance $816 r180 *1 1805.96,2500
X$816 1 54 1 54 11 26 26 1 1 1 gf180mcu_fd_io__fillnc
* cell instance $817 r180 *1 1806.06,2500
X$817 1 54 1 54 11 26 26 1 1 1 gf180mcu_fd_io__fillnc
* cell instance $818 r180 *1 1806.16,2500
X$818 1 54 1 54 11 26 26 1 1 1 gf180mcu_fd_io__fillnc
* cell instance $819 r180 *1 1881.16,2500
X$819 1 54 1 54 26 26 180 180 11 gf180mcu_fd_io__asig_5p0
* cell instance $820 r180 *1 1891.16,2500
X$820 11 170 180 1 54 1 54 gf180mcu_fd_io__fill10
* cell instance $821 r180 *1 1901.16,2500
X$821 11 157 170 1 54 1 54 gf180mcu_fd_io__fill10
* cell instance $822 r180 *1 1911.16,2500
X$822 11 162 157 1 54 1 54 gf180mcu_fd_io__fill10
* cell instance $823 r180 *1 1921.16,2500
X$823 11 161 162 1 54 1 54 gf180mcu_fd_io__fill10
* cell instance $824 r180 *1 1931.16,2500
X$824 11 160 161 1 54 1 54 gf180mcu_fd_io__fill10
* cell instance $825 r180 *1 1941.16,2500
X$825 11 196 160 1 54 1 54 gf180mcu_fd_io__fill10
* cell instance $826 r180 *1 1951.16,2500
X$826 11 195 196 1 54 1 54 gf180mcu_fd_io__fill10
* cell instance $827 r180 *1 1961.16,2500
X$827 11 194 195 1 54 1 54 gf180mcu_fd_io__fill10
* cell instance $828 r180 *1 1971.16,2500
X$828 11 27 194 1 54 1 54 gf180mcu_fd_io__fill10
* cell instance $829 r180 *1 1972.16,2500
X$829 1 54 1 54 11 27 27 gf180mcu_fd_io__fill1
* cell instance $830 r180 *1 1973.16,2500
X$830 1 54 1 54 11 27 27 gf180mcu_fd_io__fill1
* cell instance $831 r180 *1 1974.16,2500
X$831 1 54 1 54 11 27 27 gf180mcu_fd_io__fill1
* cell instance $832 r180 *1 1975.16,2500
X$832 1 54 1 54 11 27 27 gf180mcu_fd_io__fill1
* cell instance $833 r180 *1 1975.26,2500
X$833 1 54 1 54 11 27 27 1 1 1 gf180mcu_fd_io__fillnc
* cell instance $834 r180 *1 1975.36,2500
X$834 1 54 1 54 11 27 27 1 1 1 gf180mcu_fd_io__fillnc
* cell instance $835 r180 *1 1975.46,2500
X$835 1 54 1 54 11 27 27 1 1 1 gf180mcu_fd_io__fillnc
* cell instance $836 r180 *1 1975.56,2500
X$836 1 54 1 54 11 27 27 1 1 1 gf180mcu_fd_io__fillnc
* cell instance $837 r180 *1 1975.66,2500
X$837 1 54 1 54 11 27 27 1 1 1 gf180mcu_fd_io__fillnc
* cell instance $838 r180 *1 2050.66,2500
X$838 1 54 1 54 27 27 190 190 11 gf180mcu_fd_io__asig_5p0
* cell instance $839 r180 *1 2060.66,2500
X$839 11 189 190 1 54 1 54 gf180mcu_fd_io__fill10
* cell instance $840 r180 *1 2070.66,2500
X$840 11 188 189 1 54 1 54 gf180mcu_fd_io__fill10
* cell instance $841 r180 *1 2080.66,2500
X$841 11 187 188 1 54 1 54 gf180mcu_fd_io__fill10
* cell instance $842 r180 *1 2090.66,2500
X$842 11 173 187 1 54 1 54 gf180mcu_fd_io__fill10
* cell instance $843 r180 *1 2100.66,2500
X$843 11 172 173 1 54 1 54 gf180mcu_fd_io__fill10
* cell instance $844 r180 *1 2110.66,2500
X$844 11 171 172 1 54 1 54 gf180mcu_fd_io__fill10
* cell instance $845 r180 *1 2120.66,2500
X$845 11 165 171 1 54 1 54 gf180mcu_fd_io__fill10
* cell instance $846 r180 *1 2130.66,2500
X$846 11 158 165 1 54 1 54 gf180mcu_fd_io__fill10
* cell instance $847 r180 *1 2140.66,2500
X$847 11 29 158 1 54 1 54 gf180mcu_fd_io__fill10
* cell instance $848 r180 *1 2141.66,2500
X$848 1 54 1 54 11 29 29 gf180mcu_fd_io__fill1
* cell instance $849 r180 *1 2142.66,2500
X$849 1 54 1 54 11 29 29 gf180mcu_fd_io__fill1
* cell instance $850 r180 *1 2143.66,2500
X$850 1 54 1 54 11 29 29 gf180mcu_fd_io__fill1
* cell instance $851 r180 *1 2144.66,2500
X$851 1 54 1 54 11 29 29 gf180mcu_fd_io__fill1
* cell instance $852 r180 *1 2144.76,2500
X$852 1 54 1 54 11 29 29 1 1 1 gf180mcu_fd_io__fillnc
* cell instance $853 r180 *1 2144.86,2500
X$853 1 54 1 54 11 29 29 1 1 1 gf180mcu_fd_io__fillnc
* cell instance $854 r180 *1 2144.96,2500
X$854 1 54 1 54 11 29 29 1 1 1 gf180mcu_fd_io__fillnc
* cell instance $855 r180 *1 2145.06,2500
X$855 1 54 1 54 11 29 29 1 1 1 gf180mcu_fd_io__fillnc
* cell instance $856 r180 *1 2145.16,2500
X$856 1 54 1 54 11 29 29 1 1 1 gf180mcu_fd_io__fillnc
.ENDS PAD_RING_TOP

* cell gf180mcu_fd_io__dvdd
* pin DVDD
* pin DVSS
* pin VSS
* pin gf180mcu_gnd
* pin
* pin
* pin
* pin
* pin
.SUBCKT gf180mcu_fd_io__dvdd 1 2 3 4 5 6 7 8 9
* net 1 DVDD
* net 2 DVSS
* net 3 VSS
* net 4 gf180mcu_gnd
* cell instance $1 r0 *1 0,0
X$1 9 1 10 3 3 1 1 2 3LM_METAL_RAIL_PAD_60
* cell instance $2 r0 *1 0.055,62
X$2 3 3 10 1 2 10 10 10 10 10 8 6 2 3 3 7 3 5 4 GF_NI_DVDD_BASE
.ENDS gf180mcu_fd_io__dvdd

* cell gf180mcu_fd_io__dvss
* pin DVSS
* pin VDD
* pin DVDD
* pin gf180mcu_gnd
* pin
* pin
* pin
* pin
* pin
.SUBCKT gf180mcu_fd_io__dvss 1 2 3 4 5 6 7 8 9
* net 1 DVSS
* net 2 VDD
* net 3 DVDD
* net 4 gf180mcu_gnd
* cell instance $1 r0 *1 0,0
X$1 9 1 10 1 1 3 2 1 3LM_METAL_RAIL_PAD_60
* cell instance $2 r0 *1 0.055,62
X$2 1 1 10 1 10 10 10 10 10 3 8 6 2 1 1 1 1 2 3 1 7 1 5 1 1 4 GF_NI_DVSS_BASE
.ENDS gf180mcu_fd_io__dvss

* cell gf180mcu_fd_io__cor
* pin DVSS
* pin VDD
* pin DVDD
* pin VSS
* pin gf180mcu_gnd
* pin
.SUBCKT gf180mcu_fd_io__cor 1 2 3 4 5 6
* net 1 DVSS
* net 2 VDD
* net 3 DVDD
* net 4 VSS
* net 5 gf180mcu_gnd
* cell instance $1 r0 *1 0,0
X$1 4 6 1 3 4 2 POWER_RAIL_COR
* cell instance $2 r0 *1 0,0
X$2 1 3 1 1 2 1 5 1 4 3 3 1 4 4 4 4 1 3 3 3 3 3 3 3 GF_NI_COR_BASE
.ENDS gf180mcu_fd_io__cor

* cell gf180mcu_fd_io__fillnc
* pin VSS
* pin VDD
* pin DVSS
* pin DVDD
* pin
* pin
* pin
* pin
* pin
* pin
.SUBCKT gf180mcu_fd_io__fillnc 1 2 3 4 5 6 7 8 9 10
* net 1 VSS
* net 2 VDD
* net 3 DVSS
* net 4 DVDD
.ENDS gf180mcu_fd_io__fillnc

* cell gf180mcu_fd_io__fill1
* pin VSS
* pin VDD
* pin DVSS
* pin DVDD
* pin
* pin
* pin
.SUBCKT gf180mcu_fd_io__fill1 1 2 3 4 5 6 7
* net 1 VSS
* net 2 VDD
* net 3 DVSS
* net 4 DVDD
* cell instance $1 r0 *1 0.5,207.57
X$1 1 5 M1_PSUB_CDNS_40661956134167
* cell instance $2 r0 *1 0.505,321.5
X$2 1 6 M2_M1_CDNS_40661956134169
* cell instance $3 r0 *1 0.51,249.47
X$3 1 7 M2_M1_CDNS_40661956134168
* cell instance $4 r0 *1 0.505,321.5
X$4 1 6 M3_M2_CDNS_40661956134171
* cell instance $5 r0 *1 0.51,249.47
X$5 1 7 M3_M2_CDNS_40661956134170
.ENDS gf180mcu_fd_io__fill1

* cell gf180mcu_fd_io__asig_5p0
* pin VSS
* pin VDD
* pin DVSS
* pin DVDD
* pin
* pin
* pin
* pin
* pin
.SUBCKT gf180mcu_fd_io__asig_5p0 2 3 4 5 6 7 8 9 10
* net 1 ASIG5V
* net 2 VSS
* net 3 VDD
* net 4 DVSS
* net 5 DVDD
* cell instance $1 r0 *1 0,0
X$1 10 1 11 2 2 5 3 4 3LM_METAL_RAIL_PAD_60
* cell instance $2 r0 *1 -0.16,63.515
X$2 2 2 4 5 9 8 3 2 7 6 11 11 11 11 11 11 11 11 1 GF_NI_ASIG_5P0_BASE
.ENDS gf180mcu_fd_io__asig_5p0

* cell gf180mcu_fd_io__fill10
* pin
* pin
* pin
* pin VSS
* pin VDD
* pin DVSS
* pin DVDD
.SUBCKT gf180mcu_fd_io__fill10 1 2 3 4 5 6 7
* net 4 VSS
* net 5 VDD
* net 6 DVSS
* net 7 DVDD
* cell instance $1 r0 *1 5.005,349.365
X$1 4 1 M1_PSUB_CDNS_40661956134182
* cell instance $2 m0 *1 5.005,65.96
X$2 4 1 M1_PSUB_CDNS_40661956134182
* cell instance $3 m90 *1 0.24,207.62
X$3 4 1 M1_PSUB_CDNS_40661956134176
* cell instance $4 r0 *1 9.76,207.62
X$4 4 1 M1_PSUB_CDNS_40661956134176
* cell instance $5 r0 *1 0.91,321.5
X$5 4 2 M3_M2_CDNS_40661956134180
* cell instance $6 r0 *1 0.91,321.5
X$6 4 2 M2_M1_CDNS_40661956134179
* cell instance $7 r0 *1 0.91,249.505
X$7 4 2 M3_M2_CDNS_40661956134180
* cell instance $8 r0 *1 0.91,249.505
X$8 4 2 M2_M1_CDNS_40661956134179
* cell instance $9 r0 *1 9.09,321.5
X$9 4 3 M3_M2_CDNS_40661956134180
* cell instance $10 r0 *1 9.09,321.5
X$10 4 3 M2_M1_CDNS_40661956134179
* cell instance $11 r0 *1 9.09,249.505
X$11 4 3 M3_M2_CDNS_40661956134180
* cell instance $12 r0 *1 9.09,249.505
X$12 4 3 M2_M1_CDNS_40661956134179
* cell instance $13 m90 *1 11.435,71.96
X$13 4 5 10 POLY_SUB_FILL_1
* cell instance $14 m90 *1 11.435,89.02
X$14 4 5 10 POLY_SUB_FILL_1
* cell instance $15 m90 *1 11.435,106.08
X$15 4 5 10 POLY_SUB_FILL_1
* cell instance $16 m90 *1 11.435,123.14
X$16 4 5 10 POLY_SUB_FILL_1
* cell instance $17 m90 *1 11.435,140.2
X$17 4 5 10 POLY_SUB_FILL_1
* cell instance $18 m90 *1 11.435,157.26
X$18 4 5 10 POLY_SUB_FILL_1
* cell instance $19 m90 *1 11.435,174.32
X$19 4 5 10 POLY_SUB_FILL_1
* cell instance $20 m90 *1 11.435,191.38
X$20 4 5 10 POLY_SUB_FILL_1
* cell instance $21 m90 *1 11.435,208.44
X$21 4 5 10 POLY_SUB_FILL_1
* cell instance $22 m90 *1 11.435,225.5
X$22 4 5 10 POLY_SUB_FILL_1
* cell instance $23 m90 *1 11.435,242.56
X$23 4 5 10 POLY_SUB_FILL_1
* cell instance $24 m90 *1 11.435,259.62
X$24 4 5 10 POLY_SUB_FILL_1
* cell instance $25 m90 *1 11.435,276.68
X$25 4 5 10 POLY_SUB_FILL_1
* cell instance $26 m90 *1 11.435,293.74
X$26 4 5 10 POLY_SUB_FILL_1
* cell instance $27 m90 *1 11.435,310.8
X$27 4 5 10 POLY_SUB_FILL_1
* cell instance $28 m90 *1 11.435,327.86
X$28 4 5 10 POLY_SUB_FILL_1
* cell instance $29 r0 *1 5.125,257.585
X$29 5 10 M3_M2_CDNS_40661956134181
* cell instance $30 r0 *1 5.13,313.495
X$30 5 10 M3_M2_CDNS_40661956134181
* cell instance $31 r0 *1 7.375,93.61
X$31 6 9 M3_M2_CDNS_40661956134175
* cell instance $32 r0 *1 7.375,129.67
X$32 6 9 M3_M2_CDNS_40661956134172
* cell instance $33 r0 *1 7.375,329.585
X$33 6 9 M3_M2_CDNS_40661956134172
* cell instance $34 r0 *1 7.375,201.64
X$34 6 9 M3_M2_CDNS_40661956134172
* cell instance $35 r0 *1 7.375,289.415
X$35 6 9 M3_M2_CDNS_40661956134172
* cell instance $36 r0 *1 7.375,305.605
X$36 6 9 M3_M2_CDNS_40661956134172
* cell instance $37 r0 *1 7.375,345.27
X$37 6 9 M3_M2_CDNS_40661956134172
* cell instance $38 r0 *1 7.375,77.66
X$38 6 9 M3_M2_CDNS_40661956134175
* cell instance $39 r0 *1 7.375,109.345
X$39 6 9 M3_M2_CDNS_40661956134175
* cell instance $40 r0 *1 7.375,237.415
X$40 6 9 M3_M2_CDNS_40661956134175
* cell instance $41 r0 *1 2.76,209.5
X$41 7 8 M3_M2_CDNS_40661956134172
* cell instance $42 r0 *1 2.76,265.455
X$42 7 8 M3_M2_CDNS_40661956134172
* cell instance $43 r0 *1 2.76,273.525
X$43 7 8 M3_M2_CDNS_40661956134172
* cell instance $44 r0 *1 2.76,281.64
X$44 7 8 M3_M2_CDNS_40661956134172
* cell instance $45 r0 *1 2.76,297.4
X$45 7 8 M3_M2_CDNS_40661956134172
* cell instance $46 r0 *1 2.76,337.285
X$46 7 8 M3_M2_CDNS_40661956134172
* cell instance $47 r0 *1 2.76,121.505
X$47 7 8 M3_M2_CDNS_40661956134172
* cell instance $48 r0 *1 2.76,221.295
X$48 7 8 M3_M2_CDNS_40661956134175
* cell instance $49 r0 *1 2.76,141.75
X$49 7 8 M3_M2_CDNS_40661956134175
* cell instance $50 r0 *1 2.76,157.46
X$50 7 8 M3_M2_CDNS_40661956134175
* cell instance $51 r0 *1 2.76,173.585
X$51 7 8 M3_M2_CDNS_40661956134175
* cell instance $52 r0 *1 2.76,189.69
X$52 7 8 M3_M2_CDNS_40661956134175
.ENDS gf180mcu_fd_io__fill10

* cell GF_NI_DVDD_BASE
* pin
* pin
* pin
* pin DVDD
* pin DVSS
* pin
* pin
* pin
* pin
* pin
* pin
* pin
* pin
* pin
* pin
* pin
* pin
* pin
* pin gf180mcu_gnd
.SUBCKT GF_NI_DVDD_BASE 1 2 3 4 5 6 7 8 9 10 11 12 14 15 16 18 21 27 28
* net 4 DVDD
* net 5 DVSS
* net 28 gf180mcu_gnd
* cell instance $1 r0 *1 67.48,174.62
X$1 1 M1_PSUB_CDNS_40661956134228
* cell instance $2 r0 *1 72.435,109.62
X$2 1 M1_PSUB_CDNS_40661956134229
* cell instance $3 r0 *1 74.65,187.5
X$3 1 12 M3_M2_CDNS_40661956134114
* cell instance $4 r0 *1 74.65,187.5
X$4 1 12 M2_M1_CDNS_40661956134115
* cell instance $5 r0 *1 2.455,109.62
X$5 2 M1_PSUB_CDNS_40661956134229
* cell instance $6 r0 *1 0.24,187.5
X$6 2 11 M2_M1_CDNS_40661956134115
* cell instance $7 r0 *1 0.24,187.5
X$7 2 11 M3_M2_CDNS_40661956134114
* cell instance $8 r0 *1 6.055,275.5
X$8 4 3 M3_M2_CDNS_40661956134119
* cell instance $9 r0 *1 6.885,275.775
X$9 4 3 M2_M1_CDNS_40661956134214
* cell instance $10 r0 *1 6.055,251.5
X$10 4 3 M3_M2_CDNS_40661956134119
* cell instance $11 r0 *1 6.055,59.5
X$11 4 3 M3_M2_CDNS_40661956134119
* cell instance $12 r0 *1 5.04,5.735
X$12 14 4 3 20 23 6 7 24 8 25 9 26 10 28 comp018green_esd_clamp_v5p0_DVDD
* cell instance $13 r0 *1 6.055,95.5
X$13 4 3 M3_M2_CDNS_40661956134156
* cell instance $14 r0 *1 6.055,79.5
X$14 4 3 M3_M2_CDNS_40661956134156
* cell instance $15 r0 *1 6.055,127.5
X$15 4 3 M3_M2_CDNS_40661956134156
* cell instance $16 r0 *1 6.055,111.5
X$16 4 3 M3_M2_CDNS_40661956134156
* cell instance $17 r0 *1 6.055,147.5
X$17 4 3 M3_M2_CDNS_40661956134119
* cell instance $18 r0 *1 6.055,159.5
X$18 4 3 M3_M2_CDNS_40661956134156
* cell instance $19 r0 *1 6.055,195.5
X$19 4 3 M3_M2_CDNS_40661956134119
* cell instance $20 r0 *1 6.055,211.5
X$20 4 3 M3_M2_CDNS_40661956134119
* cell instance $21 r0 *1 6.055,203.5
X$21 4 3 M3_M2_CDNS_40661956134119
* cell instance $22 r0 *1 6.055,219.5
X$22 4 3 M3_M2_CDNS_40661956134119
* cell instance $23 r0 *1 6.055,235.5
X$23 4 3 M3_M2_CDNS_40661956134119
* cell instance $24 r0 *1 41.415,275.775
X$24 4 8 M2_M1_CDNS_40661956134208
* cell instance $25 r0 *1 38.535,268.275
X$25 14 4 nmoscap_6p0_CDNS_406619561348
* cell instance $26 r0 *1 44.21,275.5
X$26 4 8 M3_M2_CDNS_40661956134221
* cell instance $27 r0 *1 52.13,275.775
X$27 4 9 M2_M1_CDNS_40661956134213
* cell instance $28 r0 *1 56.06,275.5
X$28 4 9 M3_M2_CDNS_40661956134221
* cell instance $29 m90 *1 58.425,275.775
X$29 4 9 M2_M1_CDNS_40661956134214
* cell instance $30 r0 *1 55.715,268.275
X$30 14 4 nmoscap_6p0_CDNS_406619561348
* cell instance $31 m90 *1 68.005,275.775
X$31 4 10 M2_M1_CDNS_40661956134214
* cell instance $32 r0 *1 68.835,275.5
X$32 4 10 M3_M2_CDNS_40661956134119
* cell instance $33 r0 *1 20.715,243.685
X$33 4 6 M2_M1_CDNS_40661956134211
* cell instance $34 r0 *1 17.445,243.185
X$34 4 np_6p0_CDNS_406619561349
* cell instance $35 r0 *1 30.68,243.685
X$35 4 7 M2_M1_CDNS_40661956134212
* cell instance $36 m90 *1 44.21,243.685
X$36 4 8 M2_M1_CDNS_40661956134212
* cell instance $37 m90 *1 54.175,243.685
X$37 4 9 M2_M1_CDNS_40661956134211
* cell instance $38 r0 *1 20.715,248.355
X$38 4 6 M2_M1_CDNS_40661956134211
* cell instance $39 r0 *1 18.83,251.5
X$39 4 6 M3_M2_CDNS_40661956134221
* cell instance $40 r0 *1 17.445,247.855
X$40 4 np_6p0_CDNS_406619561349
* cell instance $41 r0 *1 30.68,248.355
X$41 4 7 M2_M1_CDNS_40661956134212
* cell instance $42 r0 *1 30.68,251.5
X$42 4 7 M3_M2_CDNS_40661956134221
* cell instance $43 m90 *1 44.21,248.355
X$43 4 8 M2_M1_CDNS_40661956134212
* cell instance $44 r0 *1 44.21,251.5
X$44 4 8 M3_M2_CDNS_40661956134221
* cell instance $45 m90 *1 54.175,248.355
X$45 4 9 M2_M1_CDNS_40661956134211
* cell instance $46 r0 *1 56.06,251.5
X$46 4 9 M3_M2_CDNS_40661956134221
* cell instance $47 r0 *1 20.715,253.025
X$47 4 6 M2_M1_CDNS_40661956134211
* cell instance $48 r0 *1 17.445,252.525
X$48 4 np_6p0_CDNS_406619561349
* cell instance $49 r0 *1 30.68,253.025
X$49 4 7 M2_M1_CDNS_40661956134212
* cell instance $50 m90 *1 44.21,253.025
X$50 4 8 M2_M1_CDNS_40661956134212
* cell instance $51 m90 *1 54.175,253.025
X$51 4 9 M2_M1_CDNS_40661956134211
* cell instance $52 r0 *1 20.715,257.695
X$52 4 6 M2_M1_CDNS_40661956134211
* cell instance $53 r0 *1 17.445,257.195
X$53 4 np_6p0_CDNS_406619561349
* cell instance $54 r0 *1 30.68,257.695
X$54 4 7 M2_M1_CDNS_40661956134212
* cell instance $55 m90 *1 44.21,257.695
X$55 4 8 M2_M1_CDNS_40661956134212
* cell instance $56 m90 *1 54.175,257.695
X$56 4 9 M2_M1_CDNS_40661956134211
* cell instance $57 r0 *1 37.445,239.19
X$57 4 4 29 17 M1_NWELL_CDNS_40661956134205
* cell instance $58 r0 *1 13.675,250.69
X$58 4 17 4 29 M1_NWELL_CDNS_40661956134204
* cell instance $59 r0 *1 61.215,250.69
X$59 4 17 4 29 M1_NWELL_CDNS_40661956134204
* cell instance $60 r0 *1 37.445,262.19
X$60 4 4 29 17 M1_NWELL_CDNS_40661956134205
* cell instance $61 r0 *1 68.835,251.5
X$61 4 10 M3_M2_CDNS_40661956134119
* cell instance $62 r0 *1 4.175,268.275
X$62 14 4 nmoscap_6p0_CDNS_406619561348
* cell instance $63 r0 *1 16.465,275.775
X$63 4 6 M2_M1_CDNS_40661956134214
* cell instance $64 r0 *1 18.83,275.5
X$64 4 6 M3_M2_CDNS_40661956134221
* cell instance $65 r0 *1 22.76,275.775
X$65 4 6 M2_M1_CDNS_40661956134213
* cell instance $66 r0 *1 21.355,268.275
X$66 14 4 nmoscap_6p0_CDNS_406619561348
* cell instance $67 r0 *1 33.475,275.775
X$67 4 7 M2_M1_CDNS_40661956134208
* cell instance $68 r0 *1 30.68,275.5
X$68 4 7 M3_M2_CDNS_40661956134221
* cell instance $69 r0 *1 18.83,59.5
X$69 4 6 M3_M2_CDNS_40661956134221
* cell instance $70 r0 *1 30.68,59.5
X$70 4 7 M3_M2_CDNS_40661956134221
* cell instance $71 r0 *1 44.21,59.5
X$71 4 8 M3_M2_CDNS_40661956134221
* cell instance $72 r0 *1 56.06,59.5
X$72 4 9 M3_M2_CDNS_40661956134221
* cell instance $73 r0 *1 68.835,59.5
X$73 4 10 M3_M2_CDNS_40661956134119
* cell instance $74 r0 *1 18.83,95.5
X$74 4 6 M3_M2_CDNS_40661956134222
* cell instance $75 r0 *1 18.83,79.5
X$75 4 6 M3_M2_CDNS_40661956134222
* cell instance $76 r0 *1 30.68,79.5
X$76 4 7 M3_M2_CDNS_40661956134222
* cell instance $77 r0 *1 30.68,95.5
X$77 4 7 M3_M2_CDNS_40661956134222
* cell instance $78 r0 *1 44.21,79.5
X$78 4 8 M3_M2_CDNS_40661956134222
* cell instance $79 r0 *1 44.21,95.5
X$79 4 8 M3_M2_CDNS_40661956134222
* cell instance $80 r0 *1 56.06,79.5
X$80 4 9 M3_M2_CDNS_40661956134222
* cell instance $81 r0 *1 56.06,95.5
X$81 4 9 M3_M2_CDNS_40661956134222
* cell instance $82 r0 *1 68.835,79.5
X$82 4 10 M3_M2_CDNS_40661956134156
* cell instance $83 r0 *1 68.835,95.5
X$83 4 10 M3_M2_CDNS_40661956134156
* cell instance $84 r0 *1 18.83,127.5
X$84 4 6 M3_M2_CDNS_40661956134222
* cell instance $85 r0 *1 18.83,111.5
X$85 4 6 M3_M2_CDNS_40661956134222
* cell instance $86 r0 *1 30.68,127.5
X$86 4 7 M3_M2_CDNS_40661956134222
* cell instance $87 r0 *1 30.68,111.5
X$87 4 7 M3_M2_CDNS_40661956134222
* cell instance $88 r0 *1 44.21,127.5
X$88 4 8 M3_M2_CDNS_40661956134222
* cell instance $89 r0 *1 44.21,111.5
X$89 4 8 M3_M2_CDNS_40661956134222
* cell instance $90 r0 *1 56.06,111.5
X$90 4 9 M3_M2_CDNS_40661956134222
* cell instance $91 r0 *1 56.06,127.5
X$91 4 9 M3_M2_CDNS_40661956134222
* cell instance $92 r0 *1 68.835,127.5
X$92 4 10 M3_M2_CDNS_40661956134156
* cell instance $93 r0 *1 68.835,111.5
X$93 4 10 M3_M2_CDNS_40661956134156
* cell instance $94 r0 *1 18.83,147.5
X$94 4 6 M3_M2_CDNS_40661956134221
* cell instance $95 r0 *1 30.68,147.5
X$95 4 7 M3_M2_CDNS_40661956134221
* cell instance $96 r0 *1 44.21,147.5
X$96 4 8 M3_M2_CDNS_40661956134221
* cell instance $97 r0 *1 56.06,147.5
X$97 4 9 M3_M2_CDNS_40661956134221
* cell instance $98 r0 *1 68.835,147.5
X$98 4 10 M3_M2_CDNS_40661956134119
* cell instance $99 r0 *1 18.83,159.5
X$99 4 6 M3_M2_CDNS_40661956134222
* cell instance $100 r0 *1 30.68,159.5
X$100 4 7 M3_M2_CDNS_40661956134222
* cell instance $101 r0 *1 44.21,159.5
X$101 4 8 M3_M2_CDNS_40661956134222
* cell instance $102 r0 *1 56.06,159.5
X$102 4 9 M3_M2_CDNS_40661956134222
* cell instance $103 r0 *1 68.835,159.5
X$103 4 10 M3_M2_CDNS_40661956134156
* cell instance $104 r0 *1 18.83,195.5
X$104 4 6 M3_M2_CDNS_40661956134221
* cell instance $105 r0 *1 30.68,195.5
X$105 4 7 M3_M2_CDNS_40661956134221
* cell instance $106 r0 *1 44.21,195.5
X$106 4 8 M3_M2_CDNS_40661956134221
* cell instance $107 r0 *1 56.06,195.5
X$107 4 9 M3_M2_CDNS_40661956134221
* cell instance $108 r0 *1 68.835,195.5
X$108 4 10 M3_M2_CDNS_40661956134119
* cell instance $109 r0 *1 18.83,211.5
X$109 4 6 M3_M2_CDNS_40661956134221
* cell instance $110 r0 *1 18.83,203.5
X$110 4 6 M3_M2_CDNS_40661956134221
* cell instance $111 r0 *1 30.68,211.5
X$111 4 7 M3_M2_CDNS_40661956134221
* cell instance $112 r0 *1 30.68,203.5
X$112 4 7 M3_M2_CDNS_40661956134221
* cell instance $113 r0 *1 44.21,211.5
X$113 4 8 M3_M2_CDNS_40661956134221
* cell instance $114 r0 *1 44.21,203.5
X$114 4 8 M3_M2_CDNS_40661956134221
* cell instance $115 r0 *1 56.06,203.5
X$115 4 9 M3_M2_CDNS_40661956134221
* cell instance $116 r0 *1 56.06,211.5
X$116 4 9 M3_M2_CDNS_40661956134221
* cell instance $117 r0 *1 68.835,203.5
X$117 4 10 M3_M2_CDNS_40661956134119
* cell instance $118 r0 *1 68.835,211.5
X$118 4 10 M3_M2_CDNS_40661956134119
* cell instance $119 r0 *1 18.83,219.5
X$119 4 6 M3_M2_CDNS_40661956134221
* cell instance $120 r0 *1 30.68,219.5
X$120 4 7 M3_M2_CDNS_40661956134221
* cell instance $121 r0 *1 44.21,219.5
X$121 4 8 M3_M2_CDNS_40661956134221
* cell instance $122 r0 *1 56.06,219.5
X$122 4 9 M3_M2_CDNS_40661956134221
* cell instance $123 r0 *1 68.835,219.5
X$123 4 10 M3_M2_CDNS_40661956134119
* cell instance $124 r0 *1 18.83,235.5
X$124 4 6 M3_M2_CDNS_40661956134221
* cell instance $125 r0 *1 30.68,235.5
X$125 4 7 M3_M2_CDNS_40661956134221
* cell instance $126 r0 *1 44.21,235.5
X$126 4 8 M3_M2_CDNS_40661956134221
* cell instance $127 r0 *1 56.06,235.5
X$127 4 9 M3_M2_CDNS_40661956134221
* cell instance $128 r0 *1 68.835,235.5
X$128 4 10 M3_M2_CDNS_40661956134119
* cell instance $129 r0 *1 18.83,239.19
X$129 4 6 M2_M1_CDNS_40661956134210
* cell instance $130 r0 *1 30.68,239.19
X$130 4 7 M2_M1_CDNS_40661956134210
* cell instance $131 m90 *1 44.21,239.19
X$131 4 8 M2_M1_CDNS_40661956134210
* cell instance $132 m90 *1 56.06,239.19
X$132 4 9 M2_M1_CDNS_40661956134210
* cell instance $133 r0 *1 18.83,262.19
X$133 4 6 M2_M1_CDNS_40661956134210
* cell instance $134 r0 *1 30.68,262.19
X$134 4 7 M2_M1_CDNS_40661956134210
* cell instance $135 m90 *1 44.21,262.19
X$135 4 8 M2_M1_CDNS_40661956134210
* cell instance $136 m90 *1 56.06,262.19
X$136 4 9 M2_M1_CDNS_40661956134210
* cell instance $137 r0 *1 15.695,250.69
X$137 14 13 M1_PSUB_CDNS_40661956134203
* cell instance $138 r0 *1 37.445,241.35
X$138 14 13 M1_PSUB_CDNS_40661956134202
* cell instance $139 r0 *1 37.445,242.12
X$139 14 13 M1_PSUB_CDNS_40661956134200
* cell instance $140 r0 *1 16.465,253.025
X$140 14 13 M1_PSUB_CDNS_40661956134199
* cell instance $141 r0 *1 37.445,250.69
X$141 14 13 M1_PSUB_CDNS_40661956134201
* cell instance $142 r0 *1 37.445,255.36
X$142 14 13 M1_PSUB_CDNS_40661956134201
* cell instance $143 r0 *1 37.445,246.02
X$143 14 13 M1_PSUB_CDNS_40661956134201
* cell instance $144 m90 *1 58.425,248.355
X$144 14 13 M1_PSUB_CDNS_40661956134199
* cell instance $145 m90 *1 58.425,257.695
X$145 14 13 M1_PSUB_CDNS_40661956134199
* cell instance $146 m90 *1 58.425,253.025
X$146 14 13 M1_PSUB_CDNS_40661956134199
* cell instance $147 m90 *1 58.425,243.685
X$147 14 13 M1_PSUB_CDNS_40661956134199
* cell instance $148 r0 *1 16.465,257.695
X$148 14 13 M1_PSUB_CDNS_40661956134199
* cell instance $149 r0 *1 16.465,248.355
X$149 14 13 M1_PSUB_CDNS_40661956134199
* cell instance $150 r0 *1 16.465,243.685
X$150 14 13 M1_PSUB_CDNS_40661956134199
* cell instance $151 m0 *1 37.445,259.26
X$151 14 13 M1_PSUB_CDNS_40661956134200
* cell instance $152 r0 *1 37.445,249.92
X$152 14 13 M1_PSUB_CDNS_40661956134200
* cell instance $153 r0 *1 37.445,245.25
X$153 14 13 M1_PSUB_CDNS_40661956134200
* cell instance $154 r0 *1 37.445,246.79
X$154 14 13 M1_PSUB_CDNS_40661956134200
* cell instance $155 r0 *1 37.445,251.46
X$155 14 13 M1_PSUB_CDNS_40661956134200
* cell instance $156 r0 *1 37.445,254.59
X$156 14 13 M1_PSUB_CDNS_40661956134200
* cell instance $157 r0 *1 37.445,256.13
X$157 14 13 M1_PSUB_CDNS_40661956134200
* cell instance $158 m0 *1 37.445,260.03
X$158 14 13 M1_PSUB_CDNS_40661956134202
* cell instance $159 m90 *1 59.195,250.69
X$159 14 13 M1_PSUB_CDNS_40661956134203
* cell instance $160 r0 *1 1.895,275.775
X$160 14 19 M1_PSUB_CDNS_40661956134197
* cell instance $161 r0 *1 72.995,275.775
X$161 14 19 M1_PSUB_CDNS_40661956134197
* cell instance $162 r0 *1 24.755,250.69
X$162 14 23 M2_M1_CDNS_40661956134216
* cell instance $163 m90 *1 37.445,250.69
X$163 14 24 M2_M1_CDNS_40661956134220
* cell instance $164 m90 *1 50.135,250.69
X$164 14 25 M2_M1_CDNS_40661956134216
* cell instance $165 r0 *1 24.755,255.36
X$165 14 23 M2_M1_CDNS_40661956134216
* cell instance $166 m90 *1 37.445,255.36
X$166 14 24 M2_M1_CDNS_40661956134220
* cell instance $167 m90 *1 50.135,255.36
X$167 14 25 M2_M1_CDNS_40661956134216
* cell instance $168 r0 *1 24.755,241.735
X$168 14 23 M2_M1_CDNS_40661956134209
* cell instance $169 r0 *1 24.755,243.5
X$169 14 23 M3_M2_CDNS_40661956134223
* cell instance $170 m90 *1 37.445,241.735
X$170 14 24 M2_M1_CDNS_40661956134215
* cell instance $171 r0 *1 37.445,243.5
X$171 14 24 M3_M2_CDNS_40661956134225
* cell instance $172 m90 *1 50.135,241.735
X$172 14 25 M2_M1_CDNS_40661956134209
* cell instance $173 r0 *1 50.135,243.5
X$173 14 25 M3_M2_CDNS_40661956134223
* cell instance $174 r0 *1 24.755,246.02
X$174 14 23 M2_M1_CDNS_40661956134216
* cell instance $175 m90 *1 37.445,246.02
X$175 14 24 M2_M1_CDNS_40661956134220
* cell instance $176 m90 *1 50.135,246.02
X$176 14 25 M2_M1_CDNS_40661956134216
* cell instance $177 r0 *1 24.755,259.645
X$177 14 23 M2_M1_CDNS_40661956134209
* cell instance $178 m90 *1 37.445,259.645
X$178 14 24 M2_M1_CDNS_40661956134215
* cell instance $179 m90 *1 50.135,259.645
X$179 14 25 M2_M1_CDNS_40661956134209
* cell instance $180 r0 *1 61.985,243.5
X$180 14 26 M3_M2_CDNS_40661956134223
* cell instance $181 r0 *1 12.905,243.5
X$181 14 20 M3_M2_CDNS_40661956134223
* cell instance $182 r0 *1 12.905,15.5
X$182 14 20 M3_M2_CDNS_40661956134226
* cell instance $183 r0 *1 24.755,15.5
X$183 14 23 M3_M2_CDNS_40661956134226
* cell instance $184 r0 *1 37.445,15.5
X$184 14 24 M3_M2_CDNS_40661956134227
* cell instance $185 r0 *1 50.135,15.5
X$185 14 25 M3_M2_CDNS_40661956134226
* cell instance $186 r0 *1 61.985,15.5
X$186 14 26 M3_M2_CDNS_40661956134226
* cell instance $187 r0 *1 12.905,47.5
X$187 14 20 M3_M2_CDNS_40661956134226
* cell instance $188 r0 *1 12.905,31.5
X$188 14 20 M3_M2_CDNS_40661956134226
* cell instance $189 r0 *1 24.755,47.5
X$189 14 23 M3_M2_CDNS_40661956134226
* cell instance $190 r0 *1 24.755,31.5
X$190 14 23 M3_M2_CDNS_40661956134226
* cell instance $191 r0 *1 37.445,31.5
X$191 14 24 M3_M2_CDNS_40661956134227
* cell instance $192 r0 *1 37.445,47.5
X$192 14 24 M3_M2_CDNS_40661956134227
* cell instance $193 r0 *1 50.135,31.5
X$193 14 25 M3_M2_CDNS_40661956134226
* cell instance $194 r0 *1 50.135,47.5
X$194 14 25 M3_M2_CDNS_40661956134226
* cell instance $195 r0 *1 61.985,31.5
X$195 14 26 M3_M2_CDNS_40661956134226
* cell instance $196 r0 *1 61.985,47.5
X$196 14 26 M3_M2_CDNS_40661956134226
* cell instance $197 r0 *1 12.905,67.5
X$197 14 20 M3_M2_CDNS_40661956134223
* cell instance $198 r0 *1 24.755,67.5
X$198 14 23 M3_M2_CDNS_40661956134223
* cell instance $199 r0 *1 37.445,67.5
X$199 14 24 M3_M2_CDNS_40661956134225
* cell instance $200 r0 *1 50.135,67.5
X$200 14 25 M3_M2_CDNS_40661956134223
* cell instance $201 r0 *1 61.985,67.5
X$201 14 26 M3_M2_CDNS_40661956134223
* cell instance $202 r0 *1 12.905,139.5
X$202 14 20 M3_M2_CDNS_40661956134223
* cell instance $203 r0 *1 24.755,139.5
X$203 14 23 M3_M2_CDNS_40661956134223
* cell instance $204 r0 *1 37.445,139.5
X$204 14 24 M3_M2_CDNS_40661956134225
* cell instance $205 r0 *1 50.135,139.5
X$205 14 25 M3_M2_CDNS_40661956134223
* cell instance $206 r0 *1 61.985,139.5
X$206 14 26 M3_M2_CDNS_40661956134223
* cell instance $207 r0 *1 12.905,175.5
X$207 14 20 M3_M2_CDNS_40661956134226
* cell instance $208 r0 *1 24.755,175.5
X$208 14 23 M3_M2_CDNS_40661956134226
* cell instance $209 r0 *1 37.445,175.5
X$209 14 24 M3_M2_CDNS_40661956134227
* cell instance $210 r0 *1 50.135,175.5
X$210 14 25 M3_M2_CDNS_40661956134226
* cell instance $211 r0 *1 61.985,175.5
X$211 14 26 M3_M2_CDNS_40661956134226
* cell instance $212 r0 *1 12.905,227.5
X$212 14 20 M3_M2_CDNS_40661956134223
* cell instance $213 r0 *1 24.755,227.5
X$213 14 23 M3_M2_CDNS_40661956134223
* cell instance $214 r0 *1 37.445,227.5
X$214 14 24 M3_M2_CDNS_40661956134225
* cell instance $215 r0 *1 50.135,227.5
X$215 14 25 M3_M2_CDNS_40661956134223
* cell instance $216 r0 *1 61.985,227.5
X$216 14 26 M3_M2_CDNS_40661956134223
* cell instance $217 r0 *1 12.905,285.41
X$217 14 20 M2_M1_CDNS_40661956134218
* cell instance $218 r0 *1 37.445,285.41
X$218 14 19 M1_PSUB_CDNS_40661956134198
* cell instance $219 r0 *1 12.905,283.195
X$219 14 20 M3_M2_CDNS_40661956134180
* cell instance $220 r0 *1 24.755,285.41
X$220 14 23 M2_M1_CDNS_40661956134218
* cell instance $221 r0 *1 24.755,283.195
X$221 14 23 M3_M2_CDNS_40661956134180
* cell instance $222 r0 *1 37.445,285.41
X$222 14 24 M2_M1_CDNS_40661956134217
* cell instance $223 r0 *1 37.445,283.195
X$223 14 24 M3_M2_CDNS_40661956134224
* cell instance $224 r0 *1 50.135,285.41
X$224 14 25 M2_M1_CDNS_40661956134218
* cell instance $225 r0 *1 50.135,283.195
X$225 14 25 M3_M2_CDNS_40661956134180
* cell instance $226 r0 *1 61.985,285.41
X$226 14 26 M2_M1_CDNS_40661956134218
* cell instance $227 r0 *1 61.985,283.195
X$227 14 26 M3_M2_CDNS_40661956134180
* cell instance $228 r0 *1 12.905,266.75
X$228 14 20 M2_M1_CDNS_40661956134206
* cell instance $229 r0 *1 37.445,266.14
X$229 14 19 M1_PSUB_CDNS_40661956134198
* cell instance $230 r0 *1 12.905,267.5
X$230 14 20 M3_M2_CDNS_40661956134223
* cell instance $231 r0 *1 24.755,266.75
X$231 14 23 M2_M1_CDNS_40661956134206
* cell instance $232 r0 *1 24.755,267.5
X$232 14 23 M3_M2_CDNS_40661956134223
* cell instance $233 r0 *1 37.445,266.75
X$233 14 24 M2_M1_CDNS_40661956134207
* cell instance $234 r0 *1 37.445,267.5
X$234 14 24 M3_M2_CDNS_40661956134225
* cell instance $235 r0 *1 50.135,266.75
X$235 14 25 M2_M1_CDNS_40661956134206
* cell instance $236 r0 *1 50.135,267.5
X$236 14 25 M3_M2_CDNS_40661956134223
* cell instance $237 r0 *1 61.985,266.75
X$237 14 26 M2_M1_CDNS_40661956134206
* cell instance $238 r0 *1 61.985,267.5
X$238 14 26 M3_M2_CDNS_40661956134223
* cell instance $239 r0 *1 68.685,250.69
X$239 15 M1_PSUB_CDNS_40661956134230
* cell instance $240 r0 *1 74.65,259.5
X$240 15 27 M3_M2_CDNS_40661956134114
* cell instance $241 r0 *1 74.65,259.5
X$241 15 27 M2_M1_CDNS_40661956134115
* cell instance $242 r0 *1 6.205,250.69
X$242 16 M1_PSUB_CDNS_40661956134230
* cell instance $243 r0 *1 0.24,259.5
X$243 16 18 M2_M1_CDNS_40661956134115
* cell instance $244 r0 *1 0.24,259.5
X$244 16 18 M3_M2_CDNS_40661956134114
* cell instance $245 r0 *1 11.585,187.565
X$245 21 22 M3_M2_CDNS_40661956134219
* cell instance $246 r0 *1 11.585,259.495
X$246 21 22 M3_M2_CDNS_40661956134219
.ENDS GF_NI_DVDD_BASE

* cell GF_NI_DVSS_BASE
* pin
* pin
* pin
* pin DVSS
* pin
* pin
* pin
* pin
* pin
* pin DVDD
* pin
* pin
* pin VDD
* pin
* pin
* pin
* pin
* pin
* pin
* pin
* pin
* pin
* pin
* pin
* pin
* pin gf180mcu_gnd
.SUBCKT GF_NI_DVSS_BASE 1 3 4 5 6 7 8 9 10 16 23 24 25 26 28 31 34 36 38 39 41
+ 42 50 51 53 55
* net 5 DVSS
* net 16 DVDD
* net 25 VDD
* net 55 gf180mcu_gnd
* cell instance $1 r0 *1 0.24,15.5
X$1 1 2 M3_M2_CDNS_40661956134259
* cell instance $2 r0 *1 0.24,15.5
X$2 1 2 M2_M1_CDNS_40661956134258
* cell instance $3 r0 *1 0.24,47.5
X$3 1 14 M2_M1_CDNS_40661956134258
* cell instance $4 r0 *1 0.24,47.5
X$4 1 14 M3_M2_CDNS_40661956134259
* cell instance $5 r0 *1 0.24,175.5
X$5 1 21 M2_M1_CDNS_40661956134258
* cell instance $6 r0 *1 0.24,175.5
X$6 1 21 M3_M2_CDNS_40661956134259
* cell instance $7 r0 *1 0.24,31.5
X$7 1 12 M3_M2_CDNS_40661956134259
* cell instance $8 r0 *1 0.24,31.5
X$8 1 12 M2_M1_CDNS_40661956134258
* cell instance $9 r0 *1 2.455,109.62
X$9 1 M1_PSUB_CDNS_40661956134229
* cell instance $10 r0 *1 0.24,67.5
X$10 1 17 M2_M1_CDNS_40661956134115
* cell instance $11 r0 *1 0.24,67.5
X$11 1 17 M3_M2_CDNS_40661956134114
* cell instance $12 r0 *1 0.24,139.5
X$12 1 19 M3_M2_CDNS_40661956134114
* cell instance $13 r0 *1 0.24,139.5
X$13 1 19 M2_M1_CDNS_40661956134115
* cell instance $14 r0 *1 0.24,187.5
X$14 1 23 M3_M2_CDNS_40661956134114
* cell instance $15 r0 *1 0.24,187.5
X$15 1 23 M2_M1_CDNS_40661956134115
* cell instance $16 r0 *1 74.65,31.5
X$16 3 13 M2_M1_CDNS_40661956134258
* cell instance $17 r0 *1 74.65,31.5
X$17 3 13 M3_M2_CDNS_40661956134259
* cell instance $18 r0 *1 74.65,47.5
X$18 3 15 M2_M1_CDNS_40661956134258
* cell instance $19 r0 *1 74.65,47.5
X$19 3 15 M3_M2_CDNS_40661956134259
* cell instance $20 r0 *1 74.65,175.5
X$20 3 22 M3_M2_CDNS_40661956134259
* cell instance $21 r0 *1 74.65,175.5
X$21 3 22 M2_M1_CDNS_40661956134258
* cell instance $22 r0 *1 74.65,15.5
X$22 3 11 M3_M2_CDNS_40661956134259
* cell instance $23 r0 *1 74.65,15.5
X$23 3 11 M2_M1_CDNS_40661956134258
* cell instance $24 m90 *1 67.48,174.62
X$24 3 M1_PSUB_CDNS_40661956134228
* cell instance $25 m90 *1 72.435,109.62
X$25 3 M1_PSUB_CDNS_40661956134229
* cell instance $26 r0 *1 74.65,139.5
X$26 3 20 M2_M1_CDNS_40661956134115
* cell instance $27 r0 *1 74.65,139.5
X$27 3 20 M3_M2_CDNS_40661956134114
* cell instance $28 r0 *1 74.65,67.5
X$28 3 18 M2_M1_CDNS_40661956134115
* cell instance $29 r0 *1 74.65,67.5
X$29 3 18 M3_M2_CDNS_40661956134114
* cell instance $30 r0 *1 74.65,187.5
X$30 3 24 M2_M1_CDNS_40661956134115
* cell instance $31 r0 *1 74.65,187.5
X$31 3 24 M3_M2_CDNS_40661956134114
* cell instance $32 r0 *1 6.055,15.5
X$32 5 4 M3_M2_CDNS_40661956134156
* cell instance $33 r0 *1 5.04,5.45
X$33 5 38 4 45 46 6 7 48 8 47 9 49 10 55 comp018green_esd_clamp_v5p0_DVSS
* cell instance $34 r0 *1 6.055,31.5
X$34 5 4 M3_M2_CDNS_40661956134156
* cell instance $35 r0 *1 6.055,47.5
X$35 5 4 M3_M2_CDNS_40661956134156
* cell instance $36 r0 *1 6.055,67.5
X$36 5 4 M3_M2_CDNS_40661956134119
* cell instance $37 r0 *1 6.055,139.5
X$37 5 4 M3_M2_CDNS_40661956134119
* cell instance $38 r0 *1 6.055,175.5
X$38 5 4 M3_M2_CDNS_40661956134156
* cell instance $39 r0 *1 6.055,187.5
X$39 5 4 M3_M2_CDNS_40661956134119
* cell instance $40 r0 *1 6.055,227.5
X$40 5 4 M3_M2_CDNS_40661956134119
* cell instance $41 r0 *1 6.055,259.5
X$41 5 4 M3_M2_CDNS_40661956134119
* cell instance $42 r0 *1 6.055,243.5
X$42 5 4 M3_M2_CDNS_40661956134119
* cell instance $43 r0 *1 6.055,267.5
X$43 5 4 M3_M2_CDNS_40661956134119
* cell instance $44 r0 *1 7.445,266.745
X$44 5 4 M2_M1_CDNS_40661956134253
* cell instance $45 r0 *1 2.905,274.715
X$45 5 4 M2_M1_CDNS_40661956134264
* cell instance $46 r0 *1 6.055,283.195
X$46 5 4 M3_M2_CDNS_40661956134257
* cell instance $47 r0 *1 6.055,285.39
X$47 5 4 M2_M1_CDNS_40661956134252
* cell instance $48 r0 *1 6.055,287.365
X$48 5 4 M2_M1_CDNS_40661956134140
* cell instance $49 r0 *1 6.055,3.96
X$49 5 4 M2_M1_CDNS_40661956134140
* cell instance $50 m90 *1 58.425,248.355
X$50 5 30 M1_PSUB_CDNS_40661956134199
* cell instance $51 m90 *1 58.425,253.025
X$51 5 30 M1_PSUB_CDNS_40661956134199
* cell instance $52 r0 *1 16.465,248.355
X$52 5 30 M1_PSUB_CDNS_40661956134199
* cell instance $53 r0 *1 16.465,253.025
X$53 5 30 M1_PSUB_CDNS_40661956134199
* cell instance $54 r0 *1 18.83,243.5
X$54 5 6 M3_M2_CDNS_40661956134221
* cell instance $55 r0 *1 19.715,246.02
X$55 5 6 M2_M1_CDNS_40661956134251
* cell instance $56 r0 *1 15.695,250.69
X$56 5 30 M1_PSUB_CDNS_40661956134203
* cell instance $57 r0 *1 19.715,241.735
X$57 5 6 M2_M1_CDNS_40661956134152
* cell instance $58 r0 *1 37.445,241.35
X$58 5 30 M1_PSUB_CDNS_40661956134202
* cell instance $59 r0 *1 16.465,243.685
X$59 5 30 M1_PSUB_CDNS_40661956134199
* cell instance $60 r0 *1 37.445,245.25
X$60 5 30 M1_PSUB_CDNS_40661956134200
* cell instance $61 r0 *1 37.445,242.12
X$61 5 30 M1_PSUB_CDNS_40661956134200
* cell instance $62 r0 *1 30.68,246.02
X$62 5 7 M2_M1_CDNS_40661956134247
* cell instance $63 r0 *1 30.68,241.735
X$63 5 7 M2_M1_CDNS_40661956134255
* cell instance $64 r0 *1 30.68,243.5
X$64 5 7 M3_M2_CDNS_40661956134221
* cell instance $65 r0 *1 44.21,241.735
X$65 5 8 M2_M1_CDNS_40661956134255
* cell instance $66 r0 *1 44.21,246.02
X$66 5 8 M2_M1_CDNS_40661956134247
* cell instance $67 m90 *1 44.21,243.5
X$67 5 8 M3_M2_CDNS_40661956134221
* cell instance $68 m90 *1 55.175,241.735
X$68 5 9 M2_M1_CDNS_40661956134152
* cell instance $69 m90 *1 55.175,246.02
X$69 5 9 M2_M1_CDNS_40661956134251
* cell instance $70 m90 *1 56.06,243.5
X$70 5 9 M3_M2_CDNS_40661956134221
* cell instance $71 m90 *1 58.425,243.685
X$71 5 30 M1_PSUB_CDNS_40661956134199
* cell instance $72 m90 *1 59.195,250.69
X$72 5 30 M1_PSUB_CDNS_40661956134203
* cell instance $73 r0 *1 19.715,255.36
X$73 5 6 M2_M1_CDNS_40661956134251
* cell instance $74 r0 *1 19.715,250.69
X$74 5 6 M2_M1_CDNS_40661956134251
* cell instance $75 r0 *1 37.445,250.69
X$75 5 30 M1_PSUB_CDNS_40661956134201
* cell instance $76 r0 *1 37.445,246.02
X$76 5 30 M1_PSUB_CDNS_40661956134201
* cell instance $77 r0 *1 37.445,251.46
X$77 5 30 M1_PSUB_CDNS_40661956134200
* cell instance $78 r0 *1 37.445,249.92
X$78 5 30 M1_PSUB_CDNS_40661956134200
* cell instance $79 r0 *1 37.445,254.59
X$79 5 30 M1_PSUB_CDNS_40661956134200
* cell instance $80 r0 *1 37.445,246.79
X$80 5 30 M1_PSUB_CDNS_40661956134200
* cell instance $81 r0 *1 30.68,250.69
X$81 5 7 M2_M1_CDNS_40661956134247
* cell instance $82 r0 *1 30.68,255.36
X$82 5 7 M2_M1_CDNS_40661956134247
* cell instance $83 r0 *1 44.21,255.36
X$83 5 8 M2_M1_CDNS_40661956134247
* cell instance $84 r0 *1 44.21,250.69
X$84 5 8 M2_M1_CDNS_40661956134247
* cell instance $85 m90 *1 55.175,255.36
X$85 5 9 M2_M1_CDNS_40661956134251
* cell instance $86 m90 *1 55.175,250.69
X$86 5 9 M2_M1_CDNS_40661956134251
* cell instance $87 r0 *1 37.445,255.36
X$87 5 30 M1_PSUB_CDNS_40661956134201
* cell instance $88 r0 *1 37.445,256.13
X$88 5 30 M1_PSUB_CDNS_40661956134200
* cell instance $89 r0 *1 19.715,259.645
X$89 5 6 M2_M1_CDNS_40661956134152
* cell instance $90 r0 *1 18.83,259.5
X$90 5 6 M3_M2_CDNS_40661956134221
* cell instance $91 m0 *1 37.445,260.03
X$91 5 30 M1_PSUB_CDNS_40661956134202
* cell instance $92 r0 *1 16.465,257.695
X$92 5 30 M1_PSUB_CDNS_40661956134199
* cell instance $93 m0 *1 37.445,259.26
X$93 5 30 M1_PSUB_CDNS_40661956134200
* cell instance $94 r0 *1 30.68,259.645
X$94 5 7 M2_M1_CDNS_40661956134255
* cell instance $95 r0 *1 30.68,259.5
X$95 5 7 M3_M2_CDNS_40661956134221
* cell instance $96 r0 *1 44.21,259.645
X$96 5 8 M2_M1_CDNS_40661956134255
* cell instance $97 m90 *1 44.21,259.5
X$97 5 8 M3_M2_CDNS_40661956134221
* cell instance $98 m90 *1 55.175,259.645
X$98 5 9 M2_M1_CDNS_40661956134152
* cell instance $99 m90 *1 56.06,259.5
X$99 5 9 M3_M2_CDNS_40661956134221
* cell instance $100 m90 *1 58.425,257.695
X$100 5 30 M1_PSUB_CDNS_40661956134199
* cell instance $101 r0 *1 18.83,15.5
X$101 5 6 M3_M2_CDNS_40661956134222
* cell instance $102 r0 *1 30.68,15.5
X$102 5 7 M3_M2_CDNS_40661956134222
* cell instance $103 m90 *1 44.21,15.5
X$103 5 8 M3_M2_CDNS_40661956134222
* cell instance $104 m90 *1 56.06,15.5
X$104 5 9 M3_M2_CDNS_40661956134222
* cell instance $105 m90 *1 68.835,15.5
X$105 5 10 M3_M2_CDNS_40661956134156
* cell instance $106 r0 *1 18.83,31.5
X$106 5 6 M3_M2_CDNS_40661956134222
* cell instance $107 r0 *1 30.68,31.5
X$107 5 7 M3_M2_CDNS_40661956134222
* cell instance $108 m90 *1 44.21,31.5
X$108 5 8 M3_M2_CDNS_40661956134222
* cell instance $109 m90 *1 56.06,31.5
X$109 5 9 M3_M2_CDNS_40661956134222
* cell instance $110 m90 *1 68.835,31.5
X$110 5 10 M3_M2_CDNS_40661956134156
* cell instance $111 r0 *1 18.83,47.5
X$111 5 6 M3_M2_CDNS_40661956134222
* cell instance $112 r0 *1 30.68,47.5
X$112 5 7 M3_M2_CDNS_40661956134222
* cell instance $113 m90 *1 44.21,47.5
X$113 5 8 M3_M2_CDNS_40661956134222
* cell instance $114 m90 *1 56.06,47.5
X$114 5 9 M3_M2_CDNS_40661956134222
* cell instance $115 m90 *1 68.835,47.5
X$115 5 10 M3_M2_CDNS_40661956134156
* cell instance $116 r0 *1 18.83,67.5
X$116 5 6 M3_M2_CDNS_40661956134221
* cell instance $117 r0 *1 30.68,67.5
X$117 5 7 M3_M2_CDNS_40661956134221
* cell instance $118 m90 *1 44.21,67.5
X$118 5 8 M3_M2_CDNS_40661956134221
* cell instance $119 m90 *1 56.06,67.5
X$119 5 9 M3_M2_CDNS_40661956134221
* cell instance $120 m90 *1 68.835,67.5
X$120 5 10 M3_M2_CDNS_40661956134119
* cell instance $121 r0 *1 18.83,139.5
X$121 5 6 M3_M2_CDNS_40661956134221
* cell instance $122 r0 *1 30.68,139.5
X$122 5 7 M3_M2_CDNS_40661956134221
* cell instance $123 m90 *1 44.21,139.5
X$123 5 8 M3_M2_CDNS_40661956134221
* cell instance $124 m90 *1 56.06,139.5
X$124 5 9 M3_M2_CDNS_40661956134221
* cell instance $125 m90 *1 68.835,139.5
X$125 5 10 M3_M2_CDNS_40661956134119
* cell instance $126 r0 *1 18.83,175.5
X$126 5 6 M3_M2_CDNS_40661956134222
* cell instance $127 r0 *1 30.68,175.5
X$127 5 7 M3_M2_CDNS_40661956134222
* cell instance $128 m90 *1 44.21,175.5
X$128 5 8 M3_M2_CDNS_40661956134222
* cell instance $129 m90 *1 56.06,175.5
X$129 5 9 M3_M2_CDNS_40661956134222
* cell instance $130 m90 *1 68.835,175.5
X$130 5 10 M3_M2_CDNS_40661956134156
* cell instance $131 r0 *1 18.83,187.5
X$131 5 6 M3_M2_CDNS_40661956134221
* cell instance $132 r0 *1 30.68,187.5
X$132 5 7 M3_M2_CDNS_40661956134221
* cell instance $133 m90 *1 44.21,187.5
X$133 5 8 M3_M2_CDNS_40661956134221
* cell instance $134 m90 *1 56.06,187.5
X$134 5 9 M3_M2_CDNS_40661956134221
* cell instance $135 m90 *1 68.835,187.5
X$135 5 10 M3_M2_CDNS_40661956134119
* cell instance $136 r0 *1 18.83,227.5
X$136 5 6 M3_M2_CDNS_40661956134221
* cell instance $137 r0 *1 30.68,227.5
X$137 5 7 M3_M2_CDNS_40661956134221
* cell instance $138 m90 *1 44.21,227.5
X$138 5 8 M3_M2_CDNS_40661956134221
* cell instance $139 m90 *1 56.06,227.5
X$139 5 9 M3_M2_CDNS_40661956134221
* cell instance $140 m90 *1 68.835,227.5
X$140 5 10 M3_M2_CDNS_40661956134119
* cell instance $141 m90 *1 68.835,259.5
X$141 5 10 M3_M2_CDNS_40661956134119
* cell instance $142 m90 *1 68.835,243.5
X$142 5 10 M3_M2_CDNS_40661956134119
* cell instance $143 r0 *1 37.445,266.14
X$143 5 44 M1_PSUB_CDNS_40661956134198
* cell instance $144 r0 *1 16.375,266.745
X$144 5 6 M2_M1_CDNS_40661956134145
* cell instance $145 r0 *1 18.83,267.5
X$145 5 6 M3_M2_CDNS_40661956134221
* cell instance $146 m90 *1 30.68,266.745
X$146 5 7 M2_M1_CDNS_40661956134247
* cell instance $147 r0 *1 30.68,267.5
X$147 5 7 M3_M2_CDNS_40661956134221
* cell instance $148 m90 *1 44.21,266.745
X$148 5 8 M2_M1_CDNS_40661956134247
* cell instance $149 m90 *1 44.21,267.5
X$149 5 8 M3_M2_CDNS_40661956134221
* cell instance $150 m90 *1 58.515,266.745
X$150 5 9 M2_M1_CDNS_40661956134145
* cell instance $151 m90 *1 56.06,267.5
X$151 5 9 M3_M2_CDNS_40661956134221
* cell instance $152 m90 *1 67.445,266.745
X$152 5 10 M2_M1_CDNS_40661956134253
* cell instance $153 m90 *1 68.835,267.5
X$153 5 10 M3_M2_CDNS_40661956134119
* cell instance $154 r0 *1 1.895,275.775
X$154 5 44 M1_PSUB_CDNS_40661956134197
* cell instance $155 r0 *1 4.175,268.275
X$155 5 38 nmoscap_6p0_CDNS_406619561348
* cell instance $156 r0 *1 20.265,274.715
X$156 5 6 M2_M1_CDNS_40661956134263
* cell instance $157 r0 *1 21.355,268.275
X$157 5 38 nmoscap_6p0_CDNS_406619561348
* cell instance $158 r0 *1 38.535,268.275
X$158 5 38 nmoscap_6p0_CDNS_406619561348
* cell instance $159 m90 *1 54.625,274.715
X$159 5 9 M2_M1_CDNS_40661956134263
* cell instance $160 r0 *1 55.715,268.275
X$160 5 38 nmoscap_6p0_CDNS_406619561348
* cell instance $161 m90 *1 71.985,274.715
X$161 5 10 M2_M1_CDNS_40661956134264
* cell instance $162 r0 *1 72.995,275.775
X$162 5 44 M1_PSUB_CDNS_40661956134197
* cell instance $163 r0 *1 37.445,285.41
X$163 5 44 M1_PSUB_CDNS_40661956134198
* cell instance $164 r0 *1 18.83,285.39
X$164 5 6 M2_M1_CDNS_40661956134249
* cell instance $165 r0 *1 18.83,283.195
X$165 5 6 M3_M2_CDNS_40661956134262
* cell instance $166 m90 *1 30.68,285.39
X$166 5 7 M2_M1_CDNS_40661956134249
* cell instance $167 r0 *1 30.68,283.195
X$167 5 7 M3_M2_CDNS_40661956134262
* cell instance $168 m90 *1 44.21,285.39
X$168 5 8 M2_M1_CDNS_40661956134249
* cell instance $169 m90 *1 44.21,283.195
X$169 5 8 M3_M2_CDNS_40661956134262
* cell instance $170 m90 *1 56.06,285.39
X$170 5 9 M2_M1_CDNS_40661956134249
* cell instance $171 m90 *1 56.06,283.195
X$171 5 9 M3_M2_CDNS_40661956134262
* cell instance $172 m90 *1 68.835,285.39
X$172 5 10 M2_M1_CDNS_40661956134252
* cell instance $173 m90 *1 68.835,283.195
X$173 5 10 M3_M2_CDNS_40661956134257
* cell instance $174 r0 *1 56.06,3.96
X$174 5 9 M2_M1_CDNS_40661956134140
* cell instance $175 r0 *1 68.835,3.96
X$175 5 10 M2_M1_CDNS_40661956134140
* cell instance $176 r0 *1 44.21,3.96
X$176 5 8 M2_M1_CDNS_40661956134140
* cell instance $177 r0 *1 30.68,287.365
X$177 5 7 M2_M1_CDNS_40661956134140
* cell instance $178 r0 *1 18.83,287.365
X$178 5 6 M2_M1_CDNS_40661956134140
* cell instance $179 r0 *1 30.68,3.96
X$179 5 7 M2_M1_CDNS_40661956134140
* cell instance $180 r0 *1 18.83,3.96
X$180 5 6 M2_M1_CDNS_40661956134140
* cell instance $181 r0 *1 68.835,287.365
X$181 5 10 M2_M1_CDNS_40661956134140
* cell instance $182 r0 *1 44.21,287.365
X$182 5 8 M2_M1_CDNS_40661956134140
* cell instance $183 r0 *1 56.06,287.365
X$183 5 9 M2_M1_CDNS_40661956134140
* cell instance $184 r0 *1 0.24,227.5
X$184 26 27 M2_M1_CDNS_40661956134115
* cell instance $185 r0 *1 0.24,227.5
X$185 26 27 M3_M2_CDNS_40661956134114
* cell instance $186 r0 *1 74.65,227.5
X$186 28 29 M3_M2_CDNS_40661956134114
* cell instance $187 r0 *1 74.65,227.5
X$187 28 29 M2_M1_CDNS_40661956134115
* cell instance $188 r0 *1 6.205,250.69
X$188 31 M1_PSUB_CDNS_40661956134230
* cell instance $189 r0 *1 0.24,243.5
X$189 31 32 M2_M1_CDNS_40661956134115
* cell instance $190 r0 *1 0.24,243.5
X$190 31 32 M3_M2_CDNS_40661956134114
* cell instance $191 r0 *1 0.24,259.5
X$191 31 41 M2_M1_CDNS_40661956134115
* cell instance $192 r0 *1 0.24,259.5
X$192 31 41 M3_M2_CDNS_40661956134114
* cell instance $193 r0 *1 74.65,243.5
X$193 34 33 M2_M1_CDNS_40661956134115
* cell instance $194 r0 *1 74.65,243.5
X$194 34 33 M3_M2_CDNS_40661956134114
* cell instance $195 m90 *1 68.685,250.69
X$195 34 M1_PSUB_CDNS_40661956134230
* cell instance $196 r0 *1 74.65,259.5
X$196 34 50 M2_M1_CDNS_40661956134115
* cell instance $197 r0 *1 74.65,259.5
X$197 34 50 M3_M2_CDNS_40661956134114
* cell instance $198 r0 *1 37.445,262.19
X$198 38 38 56 35 M1_NWELL_CDNS_40661956134205
* cell instance $199 r0 *1 37.445,239.19
X$199 38 38 56 35 M1_NWELL_CDNS_40661956134205
* cell instance $200 r0 *1 13.675,250.69
X$200 38 35 38 56 M1_NWELL_CDNS_40661956134204
* cell instance $201 r0 *1 61.215,250.69
X$201 38 35 38 56 M1_NWELL_CDNS_40661956134204
* cell instance $202 r0 *1 11.65,251.52
X$202 36 37 M3_M2_CDNS_40661956134219
* cell instance $203 r0 *1 11.65,195.525
X$203 36 37 M3_M2_CDNS_40661956134219
* cell instance $204 r0 *1 50.135,275.775
X$204 38 47 M2_M1_CDNS_40661956134254
* cell instance $205 m90 *1 50.135,275.5
X$205 38 47 M3_M2_CDNS_40661956134223
* cell instance $206 r0 *1 24.755,275.775
X$206 38 46 M2_M1_CDNS_40661956134254
* cell instance $207 r0 *1 24.755,275.5
X$207 38 46 M3_M2_CDNS_40661956134223
* cell instance $208 r0 *1 37.445,275.5
X$208 38 48 M3_M2_CDNS_40661956134225
* cell instance $209 m90 *1 61.985,275.5
X$209 38 49 M3_M2_CDNS_40661956134223
* cell instance $210 r0 *1 12.905,59.5
X$210 38 45 M3_M2_CDNS_40661956134223
* cell instance $211 r0 *1 24.755,59.5
X$211 38 46 M3_M2_CDNS_40661956134223
* cell instance $212 r0 *1 37.445,59.5
X$212 38 48 M3_M2_CDNS_40661956134225
* cell instance $213 m90 *1 50.135,59.5
X$213 38 47 M3_M2_CDNS_40661956134223
* cell instance $214 m90 *1 61.985,59.5
X$214 38 49 M3_M2_CDNS_40661956134223
* cell instance $215 r0 *1 12.905,111.5
X$215 38 45 M3_M2_CDNS_40661956134226
* cell instance $216 r0 *1 12.905,95.5
X$216 38 45 M3_M2_CDNS_40661956134226
* cell instance $217 r0 *1 12.905,79.5
X$217 38 45 M3_M2_CDNS_40661956134226
* cell instance $218 r0 *1 24.755,111.5
X$218 38 46 M3_M2_CDNS_40661956134226
* cell instance $219 r0 *1 24.755,95.5
X$219 38 46 M3_M2_CDNS_40661956134226
* cell instance $220 r0 *1 24.755,79.5
X$220 38 46 M3_M2_CDNS_40661956134226
* cell instance $221 r0 *1 37.445,79.5
X$221 38 48 M3_M2_CDNS_40661956134227
* cell instance $222 r0 *1 37.445,111.5
X$222 38 48 M3_M2_CDNS_40661956134227
* cell instance $223 r0 *1 37.445,95.5
X$223 38 48 M3_M2_CDNS_40661956134227
* cell instance $224 m90 *1 50.135,79.5
X$224 38 47 M3_M2_CDNS_40661956134226
* cell instance $225 m90 *1 50.135,95.5
X$225 38 47 M3_M2_CDNS_40661956134226
* cell instance $226 m90 *1 50.135,111.5
X$226 38 47 M3_M2_CDNS_40661956134226
* cell instance $227 m90 *1 61.985,79.5
X$227 38 49 M3_M2_CDNS_40661956134226
* cell instance $228 m90 *1 61.985,95.5
X$228 38 49 M3_M2_CDNS_40661956134226
* cell instance $229 m90 *1 61.985,111.5
X$229 38 49 M3_M2_CDNS_40661956134226
* cell instance $230 r0 *1 12.905,127.5
X$230 38 45 M3_M2_CDNS_40661956134226
* cell instance $231 r0 *1 24.755,127.5
X$231 38 46 M3_M2_CDNS_40661956134226
* cell instance $232 r0 *1 37.445,127.5
X$232 38 48 M3_M2_CDNS_40661956134227
* cell instance $233 m90 *1 50.135,127.5
X$233 38 47 M3_M2_CDNS_40661956134226
* cell instance $234 m90 *1 61.985,127.5
X$234 38 49 M3_M2_CDNS_40661956134226
* cell instance $235 r0 *1 12.905,147.5
X$235 38 45 M3_M2_CDNS_40661956134223
* cell instance $236 r0 *1 24.755,147.5
X$236 38 46 M3_M2_CDNS_40661956134223
* cell instance $237 r0 *1 37.445,147.5
X$237 38 48 M3_M2_CDNS_40661956134225
* cell instance $238 m90 *1 50.135,147.5
X$238 38 47 M3_M2_CDNS_40661956134223
* cell instance $239 m90 *1 61.985,147.5
X$239 38 49 M3_M2_CDNS_40661956134223
* cell instance $240 r0 *1 12.905,159.5
X$240 38 45 M3_M2_CDNS_40661956134226
* cell instance $241 r0 *1 24.755,159.5
X$241 38 46 M3_M2_CDNS_40661956134226
* cell instance $242 r0 *1 37.445,159.5
X$242 38 48 M3_M2_CDNS_40661956134227
* cell instance $243 m90 *1 50.135,159.5
X$243 38 47 M3_M2_CDNS_40661956134226
* cell instance $244 m90 *1 61.985,159.5
X$244 38 49 M3_M2_CDNS_40661956134226
* cell instance $245 r0 *1 12.905,203.5
X$245 38 45 M3_M2_CDNS_40661956134223
* cell instance $246 r0 *1 24.755,203.5
X$246 38 46 M3_M2_CDNS_40661956134223
* cell instance $247 r0 *1 37.445,203.5
X$247 38 48 M3_M2_CDNS_40661956134225
* cell instance $248 m90 *1 50.135,203.5
X$248 38 47 M3_M2_CDNS_40661956134223
* cell instance $249 m90 *1 61.985,203.5
X$249 38 49 M3_M2_CDNS_40661956134223
* cell instance $250 r0 *1 12.905,219.5
X$250 38 45 M3_M2_CDNS_40661956134223
* cell instance $251 r0 *1 12.905,211.5
X$251 38 45 M3_M2_CDNS_40661956134223
* cell instance $252 r0 *1 24.755,219.5
X$252 38 46 M3_M2_CDNS_40661956134223
* cell instance $253 r0 *1 24.755,211.5
X$253 38 46 M3_M2_CDNS_40661956134223
* cell instance $254 r0 *1 37.445,219.5
X$254 38 48 M3_M2_CDNS_40661956134225
* cell instance $255 r0 *1 37.445,211.5
X$255 38 48 M3_M2_CDNS_40661956134225
* cell instance $256 m90 *1 50.135,211.5
X$256 38 47 M3_M2_CDNS_40661956134223
* cell instance $257 m90 *1 50.135,219.5
X$257 38 47 M3_M2_CDNS_40661956134223
* cell instance $258 m90 *1 61.985,211.5
X$258 38 49 M3_M2_CDNS_40661956134223
* cell instance $259 m90 *1 61.985,219.5
X$259 38 49 M3_M2_CDNS_40661956134223
* cell instance $260 r0 *1 12.905,235.5
X$260 38 45 M3_M2_CDNS_40661956134223
* cell instance $261 r0 *1 13.08,250.69
X$261 38 45 M2_M1_CDNS_40661956134256
* cell instance $262 r0 *1 24.755,235.5
X$262 38 46 M3_M2_CDNS_40661956134223
* cell instance $263 r0 *1 37.445,235.5
X$263 38 48 M3_M2_CDNS_40661956134225
* cell instance $264 m90 *1 50.135,235.5
X$264 38 47 M3_M2_CDNS_40661956134223
* cell instance $265 m90 *1 61.985,235.5
X$265 38 49 M3_M2_CDNS_40661956134223
* cell instance $266 r0 *1 61.81,250.69
X$266 38 49 M2_M1_CDNS_40661956134256
* cell instance $267 r0 *1 24.755,239.19
X$267 38 46 M2_M1_CDNS_40661956134206
* cell instance $268 r0 *1 37.445,239.19
X$268 38 48 M2_M1_CDNS_40661956134207
* cell instance $269 r0 *1 50.135,239.19
X$269 38 47 M2_M1_CDNS_40661956134206
* cell instance $270 r0 *1 12.905,275.5
X$270 38 45 M3_M2_CDNS_40661956134223
* cell instance $271 r0 *1 24.755,257.695
X$271 38 46 M2_M1_CDNS_40661956134126
* cell instance $272 r0 *1 17.445,257.195
X$272 38 np_6p0_CDNS_406619561349
* cell instance $273 r0 *1 37.445,257.695
X$273 38 48 M2_M1_CDNS_40661956134250
* cell instance $274 r0 *1 50.135,257.695
X$274 38 47 M2_M1_CDNS_40661956134126
* cell instance $275 r0 *1 24.755,248.355
X$275 38 46 M2_M1_CDNS_40661956134126
* cell instance $276 r0 *1 17.445,247.855
X$276 38 np_6p0_CDNS_406619561349
* cell instance $277 r0 *1 37.445,248.355
X$277 38 48 M2_M1_CDNS_40661956134250
* cell instance $278 r0 *1 50.135,248.355
X$278 38 47 M2_M1_CDNS_40661956134126
* cell instance $279 r0 *1 24.755,243.685
X$279 38 46 M2_M1_CDNS_40661956134126
* cell instance $280 r0 *1 17.445,243.185
X$280 38 np_6p0_CDNS_406619561349
* cell instance $281 r0 *1 37.445,243.685
X$281 38 48 M2_M1_CDNS_40661956134250
* cell instance $282 r0 *1 50.135,243.685
X$282 38 47 M2_M1_CDNS_40661956134126
* cell instance $283 r0 *1 24.755,253.025
X$283 38 46 M2_M1_CDNS_40661956134126
* cell instance $284 r0 *1 17.445,252.525
X$284 38 np_6p0_CDNS_406619561349
* cell instance $285 r0 *1 37.445,253.025
X$285 38 48 M2_M1_CDNS_40661956134250
* cell instance $286 r0 *1 50.135,253.025
X$286 38 47 M2_M1_CDNS_40661956134126
* cell instance $287 r0 *1 61.985,267.975
X$287 38 49 M2_M1_CDNS_40661956134218
* cell instance $288 r0 *1 61.985,283.575
X$288 38 49 M2_M1_CDNS_40661956134218
* cell instance $289 r0 *1 12.905,267.975
X$289 38 45 M2_M1_CDNS_40661956134218
* cell instance $290 r0 *1 12.905,283.575
X$290 38 45 M2_M1_CDNS_40661956134218
* cell instance $291 r0 *1 24.755,262.19
X$291 38 46 M2_M1_CDNS_40661956134206
* cell instance $292 r0 *1 37.445,262.19
X$292 38 48 M2_M1_CDNS_40661956134207
* cell instance $293 r0 *1 50.135,262.19
X$293 38 47 M2_M1_CDNS_40661956134206
* cell instance $294 r0 *1 0.24,267.5
X$294 39 40 M3_M2_CDNS_40661956134114
* cell instance $295 r0 *1 0.24,267.5
X$295 39 40 M2_M1_CDNS_40661956134115
* cell instance $296 r0 *1 0.24,283.195
X$296 42 43 M2_M1_CDNS_40661956134261
* cell instance $297 r0 *1 0.24,283.195
X$297 42 43 M3_M2_CDNS_40661956134260
* cell instance $298 r0 *1 74.65,283.195
X$298 51 54 M3_M2_CDNS_40661956134260
* cell instance $299 r0 *1 74.65,283.195
X$299 51 54 M2_M1_CDNS_40661956134261
* cell instance $300 r0 *1 74.65,267.5
X$300 53 52 M3_M2_CDNS_40661956134114
* cell instance $301 r0 *1 74.65,267.5
X$301 53 52 M2_M1_CDNS_40661956134115
.ENDS GF_NI_DVSS_BASE

* cell GF_NI_COR_BASE
* pin DVSS
* pin DVDD
* pin
* pin
* pin VDD
* pin
* pin gf180mcu_gnd
* pin
* pin VSS
* pin
* pin
* pin
* pin
* pin
* pin
* pin
* pin
* pin
* pin
* pin
* pin
* pin
* pin
* pin
.SUBCKT GF_NI_COR_BASE 1 2 3 4 5 6 7 8 9 10 11 12 13 14 15 16 17 18 19 20 21 24
+ 26 28
* net 1 DVSS
* net 2 DVDD
* net 5 VDD
* net 7 gf180mcu_gnd
* net 9 VSS
* cell instance $1 r0 *1 302.78,344.52
X$1 4 28 27 4 4 4 4 17 3 26 25 3 25 25 3 3 3 25 24 3 20 18 6 6 6 19 6 19 21 6 6
+ 18 18 18 3 20 3 3 20 18 18 20 3 24 3 3 3 4 3 3 26 24 24 24 26 26 24 24 4 4 4
+ 3 4 3 3 4 4 4 3 3 3 4 4 4 moscap_routing
* cell instance $2 r0 *1 106.05,215.665
X$2 25 3 20 18 moscap_corner
* cell instance $3 r0 *1 157.75,215.665
X$3 25 3 20 18 moscap_corner
* cell instance $4 r0 *1 209.45,215.665
X$4 25 3 20 18 moscap_corner
* cell instance $5 r0 *1 54.35,215.665
X$5 25 3 20 18 moscap_corner_1
* cell instance $6 r0 *1 126.49,143.515
X$6 3 25 26 24 moscap_corner_2
* cell instance $7 r0 *1 178.19,143.515
X$7 25 3 26 24 moscap_corner
* cell instance $8 r0 *1 229.89,143.515
X$8 25 3 26 24 moscap_corner
* cell instance $9 r0 *1 176.85,81.755
X$9 4 27 28 28 moscap_corner_3
* cell instance $10 r0 *1 229.89,81.755
X$10 23 4 28 28 moscap_corner
* cell instance $11 r0 *1 67.5,67.5
X$11 7 16 15 14 13 8 9 11 10 12 5 ESD_CLAMP_COR
* cell instance $12 r0 *1 299.385,283.635
X$12 22 6 21 19 moscap_corner
* cell instance $13 r0 *1 324.195,348.715
X$13 6 22 M1_PSUB_CDNS_406619561348
.ENDS GF_NI_COR_BASE

* cell POWER_RAIL_COR
* pin
* pin
* pin DVSS
* pin DVDD
* pin VSS
* pin VDD
.SUBCKT POWER_RAIL_COR 1 2 3 4 5 6
* net 3 DVSS
* net 4 DVDD
* net 5 VSS
* net 6 VDD
* cell instance $1 r90 *1 354.495,208.245
X$1 1 2 M1_PSUB_CDNS_406619561343
* cell instance $2 r0 *1 224.365,66.165
X$2 1 2 M1_PSUB_CDNS_406619561345
* cell instance $3 r180 *1 290.035,65.97
X$3 1 2 M1_PSUB_CDNS_406619561340
* cell instance $4 r90 *1 65.97,290.02
X$4 1 2 M1_PSUB_CDNS_406619561344
* cell instance $5 r0 *1 351.175,349.355
X$5 1 2 M1_PSUB_CDNS_406619561342
* cell instance $6 r90 *1 349.355,351.925
X$6 1 2 M1_PSUB_CDNS_406619561341
* cell instance $7 r0 *1 208.18,354.5
X$7 1 2 M1_PSUB_CDNS_406619561343
* cell instance $8 r0 *1 126.445,163.945
X$8 1 2 M1_PSUB_CDNS_406619561345
* cell instance $9 r0 *1 105.985,184.405
X$9 1 2 M1_PSUB_CDNS_406619561345
* cell instance $10 r0 *1 127.105,163.285
X$10 1 2 M1_PSUB_CDNS_406619561345
* cell instance $11 r0 *1 127.765,162.625
X$11 1 2 M1_PSUB_CDNS_406619561345
* cell instance $12 r0 *1 128.425,161.965
X$12 1 2 M1_PSUB_CDNS_406619561345
* cell instance $13 r0 *1 129.745,160.645
X$13 1 2 M1_PSUB_CDNS_406619561345
* cell instance $14 r0 *1 130.405,159.985
X$14 1 2 M1_PSUB_CDNS_406619561345
* cell instance $15 r0 *1 131.065,159.325
X$15 1 2 M1_PSUB_CDNS_406619561345
* cell instance $16 r0 *1 131.725,158.665
X$16 1 2 M1_PSUB_CDNS_406619561345
* cell instance $17 r0 *1 132.385,158.005
X$17 1 2 M1_PSUB_CDNS_406619561345
* cell instance $18 r0 *1 133.045,157.345
X$18 1 2 M1_PSUB_CDNS_406619561345
* cell instance $19 r0 *1 133.705,156.685
X$19 1 2 M1_PSUB_CDNS_406619561345
* cell instance $20 r0 *1 129.085,161.305
X$20 1 2 M1_PSUB_CDNS_406619561345
* cell instance $21 r0 *1 125.785,164.605
X$21 1 2 M1_PSUB_CDNS_406619561345
* cell instance $22 r0 *1 135.025,155.365
X$22 1 2 M1_PSUB_CDNS_406619561345
* cell instance $23 r0 *1 85.525,204.865
X$23 1 2 M1_PSUB_CDNS_406619561345
* cell instance $24 r0 *1 84.205,206.185
X$24 1 2 M1_PSUB_CDNS_406619561345
* cell instance $25 r0 *1 83.545,206.845
X$25 1 2 M1_PSUB_CDNS_406619561345
* cell instance $26 r0 *1 82.885,207.505
X$26 1 2 M1_PSUB_CDNS_406619561345
* cell instance $27 r0 *1 82.225,208.165
X$27 1 2 M1_PSUB_CDNS_406619561345
* cell instance $28 r0 *1 81.565,208.825
X$28 1 2 M1_PSUB_CDNS_406619561345
* cell instance $29 r0 *1 80.905,209.485
X$29 1 2 M1_PSUB_CDNS_406619561345
* cell instance $30 r0 *1 95.425,194.965
X$30 1 2 M1_PSUB_CDNS_406619561345
* cell instance $31 r0 *1 104.665,185.725
X$31 1 2 M1_PSUB_CDNS_406619561345
* cell instance $32 r0 *1 104.005,186.385
X$32 1 2 M1_PSUB_CDNS_406619561345
* cell instance $33 r0 *1 103.345,187.045
X$33 1 2 M1_PSUB_CDNS_406619561345
* cell instance $34 r0 *1 102.685,187.705
X$34 1 2 M1_PSUB_CDNS_406619561345
* cell instance $35 r0 *1 101.365,189.025
X$35 1 2 M1_PSUB_CDNS_406619561345
* cell instance $36 r0 *1 134.365,156.025
X$36 1 2 M1_PSUB_CDNS_406619561345
* cell instance $37 r0 *1 114.565,175.825
X$37 1 2 M1_PSUB_CDNS_406619561345
* cell instance $38 r0 *1 113.245,177.145
X$38 1 2 M1_PSUB_CDNS_406619561345
* cell instance $39 r0 *1 112.585,177.805
X$39 1 2 M1_PSUB_CDNS_406619561345
* cell instance $40 r0 *1 111.925,178.465
X$40 1 2 M1_PSUB_CDNS_406619561345
* cell instance $41 r0 *1 111.265,179.125
X$41 1 2 M1_PSUB_CDNS_406619561345
* cell instance $42 r0 *1 110.605,179.785
X$42 1 2 M1_PSUB_CDNS_406619561345
* cell instance $43 r0 *1 109.945,180.445
X$43 1 2 M1_PSUB_CDNS_406619561345
* cell instance $44 r0 *1 109.285,181.105
X$44 1 2 M1_PSUB_CDNS_406619561345
* cell instance $45 r0 *1 108.625,181.765
X$45 1 2 M1_PSUB_CDNS_406619561345
* cell instance $46 r0 *1 107.965,182.425
X$46 1 2 M1_PSUB_CDNS_406619561345
* cell instance $47 r0 *1 107.305,183.085
X$47 1 2 M1_PSUB_CDNS_406619561345
* cell instance $48 r0 *1 106.645,183.745
X$48 1 2 M1_PSUB_CDNS_406619561345
* cell instance $49 r0 *1 105.325,185.065
X$49 1 2 M1_PSUB_CDNS_406619561345
* cell instance $50 r0 *1 102.025,188.365
X$50 1 2 M1_PSUB_CDNS_406619561345
* cell instance $51 r0 *1 92.785,197.605
X$51 1 2 M1_PSUB_CDNS_406619561345
* cell instance $52 r0 *1 92.125,198.265
X$52 1 2 M1_PSUB_CDNS_406619561345
* cell instance $53 r0 *1 91.465,198.925
X$53 1 2 M1_PSUB_CDNS_406619561345
* cell instance $54 r0 *1 90.805,199.585
X$54 1 2 M1_PSUB_CDNS_406619561345
* cell instance $55 r0 *1 84.865,205.525
X$55 1 2 M1_PSUB_CDNS_406619561345
* cell instance $56 r0 *1 90.145,200.245
X$56 1 2 M1_PSUB_CDNS_406619561345
* cell instance $57 r0 *1 89.485,200.905
X$57 1 2 M1_PSUB_CDNS_406619561345
* cell instance $58 r0 *1 88.825,201.565
X$58 1 2 M1_PSUB_CDNS_406619561345
* cell instance $59 r0 *1 88.165,202.225
X$59 1 2 M1_PSUB_CDNS_406619561345
* cell instance $60 r0 *1 87.505,202.885
X$60 1 2 M1_PSUB_CDNS_406619561345
* cell instance $61 r0 *1 86.845,203.545
X$61 1 2 M1_PSUB_CDNS_406619561345
* cell instance $62 r0 *1 137.005,153.385
X$62 1 2 M1_PSUB_CDNS_406619561345
* cell instance $63 r0 *1 136.345,154.045
X$63 1 2 M1_PSUB_CDNS_406619561345
* cell instance $64 r0 *1 135.685,154.705
X$64 1 2 M1_PSUB_CDNS_406619561345
* cell instance $65 r0 *1 124.465,165.925
X$65 1 2 M1_PSUB_CDNS_406619561345
* cell instance $66 r0 *1 148.885,141.505
X$66 1 2 M1_PSUB_CDNS_406619561345
* cell instance $67 r0 *1 148.225,142.165
X$67 1 2 M1_PSUB_CDNS_406619561345
* cell instance $68 r0 *1 147.565,142.825
X$68 1 2 M1_PSUB_CDNS_406619561345
* cell instance $69 r0 *1 146.905,143.485
X$69 1 2 M1_PSUB_CDNS_406619561345
* cell instance $70 r0 *1 137.665,152.725
X$70 1 2 M1_PSUB_CDNS_406619561345
* cell instance $71 r0 *1 152.845,137.545
X$71 1 2 M1_PSUB_CDNS_406619561345
* cell instance $72 r0 *1 68.365,222.025
X$72 1 2 M1_PSUB_CDNS_406619561345
* cell instance $73 r0 *1 67.705,222.685
X$73 1 2 M1_PSUB_CDNS_406619561345
* cell instance $74 r0 *1 67.045,223.345
X$74 1 2 M1_PSUB_CDNS_406619561345
* cell instance $75 r0 *1 66.385,224.005
X$75 1 2 M1_PSUB_CDNS_406619561345
* cell instance $76 r0 *1 75.625,214.765
X$76 1 2 M1_PSUB_CDNS_406619561345
* cell instance $77 r0 *1 79.585,210.805
X$77 1 2 M1_PSUB_CDNS_406619561345
* cell instance $78 r0 *1 78.925,211.465
X$78 1 2 M1_PSUB_CDNS_406619561345
* cell instance $79 r0 *1 113.905,176.485
X$79 1 2 M1_PSUB_CDNS_406619561345
* cell instance $80 r0 *1 77.605,212.785
X$80 1 2 M1_PSUB_CDNS_406619561345
* cell instance $81 r0 *1 76.945,213.445
X$81 1 2 M1_PSUB_CDNS_406619561345
* cell instance $82 r0 *1 76.285,214.105
X$82 1 2 M1_PSUB_CDNS_406619561345
* cell instance $83 r0 *1 74.965,215.425
X$83 1 2 M1_PSUB_CDNS_406619561345
* cell instance $84 r0 *1 74.305,216.085
X$84 1 2 M1_PSUB_CDNS_406619561345
* cell instance $85 r0 *1 73.645,216.745
X$85 1 2 M1_PSUB_CDNS_406619561345
* cell instance $86 r0 *1 72.985,217.405
X$86 1 2 M1_PSUB_CDNS_406619561345
* cell instance $87 r0 *1 72.325,218.065
X$87 1 2 M1_PSUB_CDNS_406619561345
* cell instance $88 r0 *1 71.665,218.725
X$88 1 2 M1_PSUB_CDNS_406619561345
* cell instance $89 r0 *1 71.005,219.385
X$89 1 2 M1_PSUB_CDNS_406619561345
* cell instance $90 r0 *1 70.345,220.045
X$90 1 2 M1_PSUB_CDNS_406619561345
* cell instance $91 r0 *1 69.685,220.705
X$91 1 2 M1_PSUB_CDNS_406619561345
* cell instance $92 r0 *1 69.025,221.365
X$92 1 2 M1_PSUB_CDNS_406619561345
* cell instance $93 r0 *1 80.245,210.145
X$93 1 2 M1_PSUB_CDNS_406619561345
* cell instance $94 r0 *1 78.265,212.125
X$94 1 2 M1_PSUB_CDNS_406619561345
* cell instance $95 r0 *1 100.705,189.685
X$95 1 2 M1_PSUB_CDNS_406619561345
* cell instance $96 r0 *1 100.045,190.345
X$96 1 2 M1_PSUB_CDNS_406619561345
* cell instance $97 r0 *1 99.385,191.005
X$97 1 2 M1_PSUB_CDNS_406619561345
* cell instance $98 r0 *1 98.725,191.665
X$98 1 2 M1_PSUB_CDNS_406619561345
* cell instance $99 r0 *1 98.065,192.325
X$99 1 2 M1_PSUB_CDNS_406619561345
* cell instance $100 r0 *1 97.405,192.985
X$100 1 2 M1_PSUB_CDNS_406619561345
* cell instance $101 r0 *1 96.745,193.645
X$101 1 2 M1_PSUB_CDNS_406619561345
* cell instance $102 r0 *1 96.085,194.305
X$102 1 2 M1_PSUB_CDNS_406619561345
* cell instance $103 r0 *1 86.185,204.205
X$103 1 2 M1_PSUB_CDNS_406619561345
* cell instance $104 r0 *1 94.765,195.625
X$104 1 2 M1_PSUB_CDNS_406619561345
* cell instance $105 r0 *1 94.105,196.285
X$105 1 2 M1_PSUB_CDNS_406619561345
* cell instance $106 r0 *1 93.445,196.945
X$106 1 2 M1_PSUB_CDNS_406619561345
* cell instance $107 r0 *1 145.585,144.805
X$107 1 2 M1_PSUB_CDNS_406619561345
* cell instance $108 r0 *1 144.265,146.125
X$108 1 2 M1_PSUB_CDNS_406619561345
* cell instance $109 r0 *1 149.545,140.845
X$109 1 2 M1_PSUB_CDNS_406619561345
* cell instance $110 r0 *1 142.285,148.105
X$110 1 2 M1_PSUB_CDNS_406619561345
* cell instance $111 r0 *1 141.625,148.765
X$111 1 2 M1_PSUB_CDNS_406619561345
* cell instance $112 r0 *1 140.965,149.425
X$112 1 2 M1_PSUB_CDNS_406619561345
* cell instance $113 r0 *1 140.305,150.085
X$113 1 2 M1_PSUB_CDNS_406619561345
* cell instance $114 r0 *1 139.645,150.745
X$114 1 2 M1_PSUB_CDNS_406619561345
* cell instance $115 r0 *1 138.985,151.405
X$115 1 2 M1_PSUB_CDNS_406619561345
* cell instance $116 r0 *1 138.325,152.065
X$116 1 2 M1_PSUB_CDNS_406619561345
* cell instance $117 r0 *1 143.605,146.785
X$117 1 2 M1_PSUB_CDNS_406619561345
* cell instance $118 r0 *1 144.925,145.465
X$118 1 2 M1_PSUB_CDNS_406619561345
* cell instance $119 r0 *1 146.245,144.145
X$119 1 2 M1_PSUB_CDNS_406619561345
* cell instance $120 r0 *1 152.185,138.205
X$120 1 2 M1_PSUB_CDNS_406619561345
* cell instance $121 r0 *1 151.525,138.865
X$121 1 2 M1_PSUB_CDNS_406619561345
* cell instance $122 r0 *1 150.865,139.525
X$122 1 2 M1_PSUB_CDNS_406619561345
* cell instance $123 r0 *1 150.205,140.185
X$123 1 2 M1_PSUB_CDNS_406619561345
* cell instance $124 r0 *1 142.945,147.445
X$124 1 2 M1_PSUB_CDNS_406619561345
* cell instance $125 r0 *1 172.645,117.745
X$125 1 2 M1_PSUB_CDNS_406619561345
* cell instance $126 r0 *1 173.305,117.085
X$126 1 2 M1_PSUB_CDNS_406619561345
* cell instance $127 r0 *1 173.965,116.425
X$127 1 2 M1_PSUB_CDNS_406619561345
* cell instance $128 r0 *1 166.045,124.345
X$128 1 2 M1_PSUB_CDNS_406619561345
* cell instance $129 r0 *1 206.305,84.085
X$129 1 2 M1_PSUB_CDNS_406619561345
* cell instance $130 r0 *1 181.225,109.165
X$130 1 2 M1_PSUB_CDNS_406619561345
* cell instance $131 r0 *1 186.505,103.885
X$131 1 2 M1_PSUB_CDNS_406619561345
* cell instance $132 r0 *1 185.845,104.545
X$132 1 2 M1_PSUB_CDNS_406619561345
* cell instance $133 r0 *1 185.185,105.205
X$133 1 2 M1_PSUB_CDNS_406619561345
* cell instance $134 r0 *1 184.525,105.865
X$134 1 2 M1_PSUB_CDNS_406619561345
* cell instance $135 r0 *1 183.865,106.525
X$135 1 2 M1_PSUB_CDNS_406619561345
* cell instance $136 r0 *1 183.205,107.185
X$136 1 2 M1_PSUB_CDNS_406619561345
* cell instance $137 r0 *1 182.545,107.845
X$137 1 2 M1_PSUB_CDNS_406619561345
* cell instance $138 r0 *1 181.885,108.505
X$138 1 2 M1_PSUB_CDNS_406619561345
* cell instance $139 r0 *1 154.825,135.565
X$139 1 2 M1_PSUB_CDNS_406619561345
* cell instance $140 r0 *1 164.065,126.325
X$140 1 2 M1_PSUB_CDNS_406619561345
* cell instance $141 r0 *1 163.405,126.985
X$141 1 2 M1_PSUB_CDNS_406619561345
* cell instance $142 r0 *1 162.745,127.645
X$142 1 2 M1_PSUB_CDNS_406619561345
* cell instance $143 r0 *1 162.085,128.305
X$143 1 2 M1_PSUB_CDNS_406619561345
* cell instance $144 r0 *1 161.425,128.965
X$144 1 2 M1_PSUB_CDNS_406619561345
* cell instance $145 r0 *1 160.765,129.625
X$145 1 2 M1_PSUB_CDNS_406619561345
* cell instance $146 r0 *1 160.105,130.285
X$146 1 2 M1_PSUB_CDNS_406619561345
* cell instance $147 r0 *1 159.445,130.945
X$147 1 2 M1_PSUB_CDNS_406619561345
* cell instance $148 r0 *1 158.785,131.605
X$148 1 2 M1_PSUB_CDNS_406619561345
* cell instance $149 r0 *1 158.125,132.265
X$149 1 2 M1_PSUB_CDNS_406619561345
* cell instance $150 r0 *1 157.465,132.925
X$150 1 2 M1_PSUB_CDNS_406619561345
* cell instance $151 r0 *1 156.805,133.585
X$151 1 2 M1_PSUB_CDNS_406619561345
* cell instance $152 r0 *1 156.145,134.245
X$152 1 2 M1_PSUB_CDNS_406619561345
* cell instance $153 r0 *1 165.385,125.005
X$153 1 2 M1_PSUB_CDNS_406619561345
* cell instance $154 r0 *1 164.725,125.665
X$154 1 2 M1_PSUB_CDNS_406619561345
* cell instance $155 r0 *1 223.465,66.925
X$155 1 2 M1_PSUB_CDNS_406619561345
* cell instance $156 r0 *1 222.805,67.585
X$156 1 2 M1_PSUB_CDNS_406619561345
* cell instance $157 r0 *1 222.145,68.245
X$157 1 2 M1_PSUB_CDNS_406619561345
* cell instance $158 r0 *1 221.485,68.905
X$158 1 2 M1_PSUB_CDNS_406619561345
* cell instance $159 r0 *1 220.825,69.565
X$159 1 2 M1_PSUB_CDNS_406619561345
* cell instance $160 r0 *1 220.165,70.225
X$160 1 2 M1_PSUB_CDNS_406619561345
* cell instance $161 r0 *1 219.505,70.885
X$161 1 2 M1_PSUB_CDNS_406619561345
* cell instance $162 r0 *1 218.845,71.545
X$162 1 2 M1_PSUB_CDNS_406619561345
* cell instance $163 r0 *1 218.185,72.205
X$163 1 2 M1_PSUB_CDNS_406619561345
* cell instance $164 r0 *1 217.525,72.865
X$164 1 2 M1_PSUB_CDNS_406619561345
* cell instance $165 r0 *1 216.865,73.525
X$165 1 2 M1_PSUB_CDNS_406619561345
* cell instance $166 r0 *1 216.205,74.185
X$166 1 2 M1_PSUB_CDNS_406619561345
* cell instance $167 r0 *1 215.545,74.845
X$167 1 2 M1_PSUB_CDNS_406619561345
* cell instance $168 r0 *1 214.225,76.165
X$168 1 2 M1_PSUB_CDNS_406619561345
* cell instance $169 r0 *1 171.985,118.405
X$169 1 2 M1_PSUB_CDNS_406619561345
* cell instance $170 r0 *1 212.905,77.485
X$170 1 2 M1_PSUB_CDNS_406619561345
* cell instance $171 r0 *1 212.245,78.145
X$171 1 2 M1_PSUB_CDNS_406619561345
* cell instance $172 r0 *1 211.585,78.805
X$172 1 2 M1_PSUB_CDNS_406619561345
* cell instance $173 r0 *1 210.925,79.465
X$173 1 2 M1_PSUB_CDNS_406619561345
* cell instance $174 r0 *1 214.885,75.505
X$174 1 2 M1_PSUB_CDNS_406619561345
* cell instance $175 r0 *1 194.425,95.965
X$175 1 2 M1_PSUB_CDNS_406619561345
* cell instance $176 r0 *1 193.765,96.625
X$176 1 2 M1_PSUB_CDNS_406619561345
* cell instance $177 r0 *1 193.105,97.285
X$177 1 2 M1_PSUB_CDNS_406619561345
* cell instance $178 r0 *1 192.445,97.945
X$178 1 2 M1_PSUB_CDNS_406619561345
* cell instance $179 r0 *1 191.785,98.605
X$179 1 2 M1_PSUB_CDNS_406619561345
* cell instance $180 r0 *1 169.345,121.045
X$180 1 2 M1_PSUB_CDNS_406619561345
* cell instance $181 r0 *1 170.005,120.385
X$181 1 2 M1_PSUB_CDNS_406619561345
* cell instance $182 r0 *1 170.665,119.725
X$182 1 2 M1_PSUB_CDNS_406619561345
* cell instance $183 r0 *1 171.325,119.065
X$183 1 2 M1_PSUB_CDNS_406619561345
* cell instance $184 r0 *1 213.565,76.825
X$184 1 2 M1_PSUB_CDNS_406619561345
* cell instance $185 r0 *1 197.725,92.665
X$185 1 2 M1_PSUB_CDNS_406619561345
* cell instance $186 r0 *1 191.125,99.265
X$186 1 2 M1_PSUB_CDNS_406619561345
* cell instance $187 r0 *1 190.465,99.925
X$187 1 2 M1_PSUB_CDNS_406619561345
* cell instance $188 r0 *1 189.805,100.585
X$188 1 2 M1_PSUB_CDNS_406619561345
* cell instance $189 r0 *1 189.145,101.245
X$189 1 2 M1_PSUB_CDNS_406619561345
* cell instance $190 r0 *1 188.485,101.905
X$190 1 2 M1_PSUB_CDNS_406619561345
* cell instance $191 r0 *1 187.825,102.565
X$191 1 2 M1_PSUB_CDNS_406619561345
* cell instance $192 r0 *1 187.165,103.225
X$192 1 2 M1_PSUB_CDNS_406619561345
* cell instance $193 r0 *1 197.065,93.325
X$193 1 2 M1_PSUB_CDNS_406619561345
* cell instance $194 r0 *1 175.285,115.105
X$194 1 2 M1_PSUB_CDNS_406619561345
* cell instance $195 r0 *1 195.745,94.645
X$195 1 2 M1_PSUB_CDNS_406619561345
* cell instance $196 r0 *1 166.705,123.685
X$196 1 2 M1_PSUB_CDNS_406619561345
* cell instance $197 r0 *1 167.365,123.025
X$197 1 2 M1_PSUB_CDNS_406619561345
* cell instance $198 r0 *1 168.025,122.365
X$198 1 2 M1_PSUB_CDNS_406619561345
* cell instance $199 r0 *1 198.385,92.005
X$199 1 2 M1_PSUB_CDNS_406619561345
* cell instance $200 r0 *1 115.225,175.165
X$200 1 2 M1_PSUB_CDNS_406619561345
* cell instance $201 r0 *1 116.545,173.845
X$201 1 2 M1_PSUB_CDNS_406619561345
* cell instance $202 r0 *1 117.205,173.185
X$202 1 2 M1_PSUB_CDNS_406619561345
* cell instance $203 r0 *1 117.865,172.525
X$203 1 2 M1_PSUB_CDNS_406619561345
* cell instance $204 r0 *1 118.525,171.865
X$204 1 2 M1_PSUB_CDNS_406619561345
* cell instance $205 r0 *1 119.185,171.205
X$205 1 2 M1_PSUB_CDNS_406619561345
* cell instance $206 r0 *1 119.845,170.545
X$206 1 2 M1_PSUB_CDNS_406619561345
* cell instance $207 r0 *1 120.505,169.885
X$207 1 2 M1_PSUB_CDNS_406619561345
* cell instance $208 r0 *1 121.165,169.225
X$208 1 2 M1_PSUB_CDNS_406619561345
* cell instance $209 r0 *1 121.825,168.565
X$209 1 2 M1_PSUB_CDNS_406619561345
* cell instance $210 r0 *1 122.485,167.905
X$210 1 2 M1_PSUB_CDNS_406619561345
* cell instance $211 r0 *1 123.145,167.245
X$211 1 2 M1_PSUB_CDNS_406619561345
* cell instance $212 r0 *1 123.805,166.585
X$212 1 2 M1_PSUB_CDNS_406619561345
* cell instance $213 r0 *1 125.125,165.265
X$213 1 2 M1_PSUB_CDNS_406619561345
* cell instance $214 r0 *1 210.265,80.125
X$214 1 2 M1_PSUB_CDNS_406619561345
* cell instance $215 r0 *1 168.685,121.705
X$215 1 2 M1_PSUB_CDNS_406619561345
* cell instance $216 r0 *1 115.885,174.505
X$216 1 2 M1_PSUB_CDNS_406619561345
* cell instance $217 r0 *1 153.505,136.885
X$217 1 2 M1_PSUB_CDNS_406619561345
* cell instance $218 r0 *1 195.085,95.305
X$218 1 2 M1_PSUB_CDNS_406619561345
* cell instance $219 r0 *1 155.485,134.905
X$219 1 2 M1_PSUB_CDNS_406619561345
* cell instance $220 r0 *1 180.565,109.825
X$220 1 2 M1_PSUB_CDNS_406619561345
* cell instance $221 r0 *1 179.905,110.485
X$221 1 2 M1_PSUB_CDNS_406619561345
* cell instance $222 r0 *1 179.245,111.145
X$222 1 2 M1_PSUB_CDNS_406619561345
* cell instance $223 r0 *1 178.585,111.805
X$223 1 2 M1_PSUB_CDNS_406619561345
* cell instance $224 r0 *1 177.925,112.465
X$224 1 2 M1_PSUB_CDNS_406619561345
* cell instance $225 r0 *1 177.265,113.125
X$225 1 2 M1_PSUB_CDNS_406619561345
* cell instance $226 r0 *1 176.605,113.785
X$226 1 2 M1_PSUB_CDNS_406619561345
* cell instance $227 r0 *1 175.945,114.445
X$227 1 2 M1_PSUB_CDNS_406619561345
* cell instance $228 r0 *1 174.625,115.765
X$228 1 2 M1_PSUB_CDNS_406619561345
* cell instance $229 r0 *1 209.605,80.785
X$229 1 2 M1_PSUB_CDNS_406619561345
* cell instance $230 r0 *1 208.945,81.445
X$230 1 2 M1_PSUB_CDNS_406619561345
* cell instance $231 r0 *1 208.285,82.105
X$231 1 2 M1_PSUB_CDNS_406619561345
* cell instance $232 r0 *1 154.165,136.225
X$232 1 2 M1_PSUB_CDNS_406619561345
* cell instance $233 r0 *1 199.705,90.685
X$233 1 2 M1_PSUB_CDNS_406619561345
* cell instance $234 r0 *1 200.365,90.025
X$234 1 2 M1_PSUB_CDNS_406619561345
* cell instance $235 r0 *1 201.025,89.365
X$235 1 2 M1_PSUB_CDNS_406619561345
* cell instance $236 r0 *1 201.685,88.705
X$236 1 2 M1_PSUB_CDNS_406619561345
* cell instance $237 r0 *1 202.345,88.045
X$237 1 2 M1_PSUB_CDNS_406619561345
* cell instance $238 r0 *1 203.005,87.385
X$238 1 2 M1_PSUB_CDNS_406619561345
* cell instance $239 r0 *1 203.665,86.725
X$239 1 2 M1_PSUB_CDNS_406619561345
* cell instance $240 r0 *1 204.325,86.065
X$240 1 2 M1_PSUB_CDNS_406619561345
* cell instance $241 r0 *1 204.985,85.405
X$241 1 2 M1_PSUB_CDNS_406619561345
* cell instance $242 r0 *1 205.645,84.745
X$242 1 2 M1_PSUB_CDNS_406619561345
* cell instance $243 r0 *1 196.405,93.985
X$243 1 2 M1_PSUB_CDNS_406619561345
* cell instance $244 r0 *1 206.965,83.425
X$244 1 2 M1_PSUB_CDNS_406619561345
* cell instance $245 r0 *1 199.045,91.345
X$245 1 2 M1_PSUB_CDNS_406619561345
* cell instance $246 r0 *1 207.625,82.765
X$246 1 2 M1_PSUB_CDNS_406619561345
* cell instance $247 r0 *1 353.205,121.53
X$247 4 7 M3_M2_CDNS_406619561346
* cell instance $248 r0 *1 353.205,141.6
X$248 4 7 M3_M2_CDNS_406619561347
* cell instance $249 r0 *1 353.205,173.5
X$249 4 7 M3_M2_CDNS_406619561347
* cell instance $250 r0 *1 353.205,189.5
X$250 4 7 M3_M2_CDNS_406619561347
* cell instance $251 r0 *1 353.205,221.535
X$251 4 7 M3_M2_CDNS_406619561347
* cell instance $252 r0 *1 353.205,157.44
X$252 4 7 M3_M2_CDNS_406619561347
* cell instance $253 r0 *1 353.205,281.55
X$253 4 7 M3_M2_CDNS_406619561346
* cell instance $254 r0 *1 353.205,273.51
X$254 4 7 M3_M2_CDNS_406619561346
* cell instance $255 r0 *1 353.205,265.61
X$255 4 7 M3_M2_CDNS_406619561346
* cell instance $256 r0 *1 353.205,337.58
X$256 4 7 M3_M2_CDNS_406619561346
* cell instance $257 r0 *1 353.205,297.6
X$257 4 7 M3_M2_CDNS_406619561346
* cell instance $258 r0 *1 353.205,209.485
X$258 4 7 M3_M2_CDNS_406619561346
.ENDS POWER_RAIL_COR

* cell M2_M1_CDNS_40661956134168
* pin
* pin
.SUBCKT M2_M1_CDNS_40661956134168 1 2
.ENDS M2_M1_CDNS_40661956134168

* cell M2_M1_CDNS_40661956134169
* pin
* pin
.SUBCKT M2_M1_CDNS_40661956134169 1 2
.ENDS M2_M1_CDNS_40661956134169

* cell M3_M2_CDNS_40661956134170
* pin
* pin
.SUBCKT M3_M2_CDNS_40661956134170 1 2
.ENDS M3_M2_CDNS_40661956134170

* cell M3_M2_CDNS_40661956134171
* pin
* pin
.SUBCKT M3_M2_CDNS_40661956134171 1 2
.ENDS M3_M2_CDNS_40661956134171

* cell M1_PSUB_CDNS_40661956134167
* pin
* pin
.SUBCKT M1_PSUB_CDNS_40661956134167 1 2
.ENDS M1_PSUB_CDNS_40661956134167

* cell GF_NI_ASIG_5P0_BASE
* pin
* pin
* pin
* pin
* pin
* pin
* pin
* pin
* pin
* pin
* pin
* pin
* pin
* pin
* pin
* pin
* pin
* pin
* pin
.SUBCKT GF_NI_ASIG_5P0_BASE 1 2 3 7 18 19 25 29 32 33 34 35 36 37 38 39 40 41 42
* cell instance $1 r0 *1 3.42,53.17
X$1 1 M1_PSUB_CDNS_40661956134499
* cell instance $2 r0 *1 0.42,185.985
X$2 1 19 M2_M1_CDNS_40661956134115
* cell instance $3 r0 *1 0.42,185.985
X$3 1 19 M3_M2_CDNS_40661956134114
* cell instance $4 r0 *1 0.42,257.985
X$4 1 18 M2_M1_CDNS_40661956134115
* cell instance $5 r0 *1 0.42,257.985
X$5 1 18 M3_M2_CDNS_40661956134114
* cell instance $6 m90 *1 71.9,53.17
X$6 2 M1_PSUB_CDNS_40661956134499
* cell instance $7 r0 *1 74.9,257.985
X$7 2 32 M3_M2_CDNS_40661956134114
* cell instance $8 r0 *1 74.9,257.985
X$8 2 32 M2_M1_CDNS_40661956134115
* cell instance $9 r0 *1 74.9,185.985
X$9 2 33 M3_M2_CDNS_40661956134114
* cell instance $10 r0 *1 74.9,185.985
X$10 2 33 M2_M1_CDNS_40661956134115
* cell instance $11 r0 *1 15.805,90.98
X$11 3 5 M1_PSUB_CDNS_40661956134484
* cell instance $12 r0 *1 59.515,90.98
X$12 3 5 M1_PSUB_CDNS_40661956134484
* cell instance $13 r0 *1 2.89,106.675
X$13 3 20 M2_M1_CDNS_40661956134493
* cell instance $14 r0 *1 2.11,194.78
X$14 3 21 M1_PSUB_CDNS_40661956134482
* cell instance $15 r0 *1 37.66,105.95
X$15 3 21 M1_PSUB_CDNS_40661956134198
* cell instance $16 r0 *1 4.39,108.32
X$16 3 7 nmoscap_6p0_CDNS_406619561348
* cell instance $17 r0 *1 8.25,106.675
X$17 3 23 M2_M1_CDNS_40661956134207
* cell instance $18 r0 *1 13.93,106.675
X$18 3 4 M2_M1_CDNS_40661956134207
* cell instance $19 r0 *1 21.57,108.32
X$19 3 7 nmoscap_6p0_CDNS_406619561348
* cell instance $20 r0 *1 25.29,106.675
X$20 3 8 M2_M1_CDNS_40661956134207
* cell instance $21 r0 *1 36.445,106.675
X$21 3 10 M2_M1_CDNS_40661956134489
* cell instance $22 r0 *1 38.75,108.32
X$22 3 7 nmoscap_6p0_CDNS_406619561348
* cell instance $23 r0 *1 38.875,106.675
X$23 3 11 M2_M1_CDNS_40661956134489
* cell instance $24 r0 *1 50.03,106.675
X$24 3 13 M2_M1_CDNS_40661956134207
* cell instance $25 r0 *1 55.93,108.32
X$25 3 7 nmoscap_6p0_CDNS_406619561348
* cell instance $26 r0 *1 61.39,106.675
X$26 3 15 M2_M1_CDNS_40661956134207
* cell instance $27 r0 *1 67.07,106.675
X$27 3 17 M2_M1_CDNS_40661956134207
* cell instance $28 m90 *1 72.43,106.675
X$28 3 31 M2_M1_CDNS_40661956134493
* cell instance $29 r0 *1 73.21,194.78
X$29 3 21 M1_PSUB_CDNS_40661956134482
* cell instance $30 r0 *1 2.89,125.69
X$30 3 20 M2_M1_CDNS_40661956134497
* cell instance $31 r0 *1 37.07,115.82
X$31 3 10 M2_M1_CDNS_40661956134258
* cell instance $32 m90 *1 38.25,115.82
X$32 3 11 M2_M1_CDNS_40661956134258
* cell instance $33 m90 *1 72.43,125.69
X$33 3 31 M2_M1_CDNS_40661956134497
* cell instance $34 r0 *1 37.66,125.69
X$34 3 48 M1_PSUB_CDNS_40661956134198
* cell instance $35 r0 *1 4.39,128.06
X$35 3 7 nmoscap_6p0_CDNS_406619561348
* cell instance $36 r0 *1 8.25,125.69
X$36 3 23 M2_M1_CDNS_40661956134496
* cell instance $37 r0 *1 13.93,125.69
X$37 3 4 M2_M1_CDNS_40661956134496
* cell instance $38 r0 *1 21.57,128.06
X$38 3 7 nmoscap_6p0_CDNS_406619561348
* cell instance $39 r0 *1 25.29,125.69
X$39 3 8 M2_M1_CDNS_40661956134496
* cell instance $40 r0 *1 36.445,125.69
X$40 3 10 M2_M1_CDNS_40661956134462
* cell instance $41 r0 *1 37.07,135.56
X$41 3 10 M2_M1_CDNS_40661956134258
* cell instance $42 r0 *1 36.445,137.985
X$42 3 10 M3_M2_CDNS_40661956134490
* cell instance $43 r0 *1 38.75,128.06
X$43 3 7 nmoscap_6p0_CDNS_406619561348
* cell instance $44 m90 *1 38.25,135.56
X$44 3 11 M2_M1_CDNS_40661956134258
* cell instance $45 m90 *1 38.875,137.985
X$45 3 11 M3_M2_CDNS_40661956134490
* cell instance $46 r0 *1 38.875,125.69
X$46 3 11 M2_M1_CDNS_40661956134462
* cell instance $47 r0 *1 50.03,125.69
X$47 3 13 M2_M1_CDNS_40661956134496
* cell instance $48 r0 *1 55.93,128.06
X$48 3 7 nmoscap_6p0_CDNS_406619561348
* cell instance $49 r0 *1 61.39,125.69
X$49 3 15 M2_M1_CDNS_40661956134496
* cell instance $50 r0 *1 67.07,125.69
X$50 3 17 M2_M1_CDNS_40661956134496
* cell instance $51 r0 *1 2.89,145.43
X$51 3 20 M2_M1_CDNS_40661956134497
* cell instance $52 r0 *1 37.66,145.43
X$52 3 49 M1_PSUB_CDNS_40661956134198
* cell instance $53 r0 *1 4.39,147.8
X$53 3 7 nmoscap_6p0_CDNS_406619561348
* cell instance $54 r0 *1 8.25,145.43
X$54 3 23 M2_M1_CDNS_40661956134496
* cell instance $55 r0 *1 13.93,145.43
X$55 3 4 M2_M1_CDNS_40661956134496
* cell instance $56 r0 *1 21.57,147.8
X$56 3 7 nmoscap_6p0_CDNS_406619561348
* cell instance $57 r0 *1 25.29,145.43
X$57 3 8 M2_M1_CDNS_40661956134496
* cell instance $58 r0 *1 36.445,145.43
X$58 3 10 M2_M1_CDNS_40661956134462
* cell instance $59 r0 *1 38.75,147.8
X$59 3 7 nmoscap_6p0_CDNS_406619561348
* cell instance $60 r0 *1 38.875,145.43
X$60 3 11 M2_M1_CDNS_40661956134462
* cell instance $61 r0 *1 50.03,145.43
X$61 3 13 M2_M1_CDNS_40661956134496
* cell instance $62 r0 *1 55.93,147.8
X$62 3 7 nmoscap_6p0_CDNS_406619561348
* cell instance $63 r0 *1 61.39,145.43
X$63 3 15 M2_M1_CDNS_40661956134496
* cell instance $64 r0 *1 67.07,145.43
X$64 3 17 M2_M1_CDNS_40661956134496
* cell instance $65 m90 *1 72.43,145.43
X$65 3 31 M2_M1_CDNS_40661956134497
* cell instance $66 r0 *1 37.07,155.3
X$66 3 10 M2_M1_CDNS_40661956134258
* cell instance $67 m90 *1 38.25,155.3
X$67 3 11 M2_M1_CDNS_40661956134258
* cell instance $68 r0 *1 2.89,165.17
X$68 3 20 M2_M1_CDNS_40661956134497
* cell instance $69 r0 *1 37.66,165.17
X$69 3 51 M1_PSUB_CDNS_40661956134198
* cell instance $70 r0 *1 4.39,167.54
X$70 3 7 nmoscap_6p0_CDNS_406619561348
* cell instance $71 r0 *1 8.25,165.17
X$71 3 23 M2_M1_CDNS_40661956134496
* cell instance $72 r0 *1 13.93,165.17
X$72 3 4 M2_M1_CDNS_40661956134496
* cell instance $73 r0 *1 21.57,167.54
X$73 3 7 nmoscap_6p0_CDNS_406619561348
* cell instance $74 r0 *1 25.29,165.17
X$74 3 8 M2_M1_CDNS_40661956134496
* cell instance $75 r0 *1 36.445,165.17
X$75 3 10 M2_M1_CDNS_40661956134462
* cell instance $76 r0 *1 38.75,167.54
X$76 3 7 nmoscap_6p0_CDNS_406619561348
* cell instance $77 r0 *1 38.875,165.17
X$77 3 11 M2_M1_CDNS_40661956134462
* cell instance $78 r0 *1 50.03,165.17
X$78 3 13 M2_M1_CDNS_40661956134496
* cell instance $79 r0 *1 55.93,167.54
X$79 3 7 nmoscap_6p0_CDNS_406619561348
* cell instance $80 r0 *1 61.39,165.17
X$80 3 15 M2_M1_CDNS_40661956134496
* cell instance $81 r0 *1 67.07,165.17
X$81 3 17 M2_M1_CDNS_40661956134496
* cell instance $82 m90 *1 72.43,165.17
X$82 3 31 M2_M1_CDNS_40661956134497
* cell instance $83 r0 *1 37.07,175.04
X$83 3 10 M2_M1_CDNS_40661956134258
* cell instance $84 r0 *1 36.445,173.985
X$84 3 10 M3_M2_CDNS_40661956134491
* cell instance $85 m90 *1 38.25,175.04
X$85 3 11 M2_M1_CDNS_40661956134258
* cell instance $86 m90 *1 38.875,173.985
X$86 3 11 M3_M2_CDNS_40661956134491
* cell instance $87 r0 *1 2.89,184.91
X$87 3 20 M2_M1_CDNS_40661956134497
* cell instance $88 r0 *1 37.66,184.91
X$88 3 50 M1_PSUB_CDNS_40661956134198
* cell instance $89 r0 *1 4.39,187.28
X$89 3 7 nmoscap_6p0_CDNS_406619561348
* cell instance $90 r0 *1 8.25,184.91
X$90 3 23 M2_M1_CDNS_40661956134496
* cell instance $91 r0 *1 13.93,184.91
X$91 3 4 M2_M1_CDNS_40661956134496
* cell instance $92 r0 *1 21.57,187.28
X$92 3 7 nmoscap_6p0_CDNS_406619561348
* cell instance $93 r0 *1 25.29,184.91
X$93 3 8 M2_M1_CDNS_40661956134496
* cell instance $94 r0 *1 36.445,184.91
X$94 3 10 M2_M1_CDNS_40661956134462
* cell instance $95 r0 *1 37.07,194.78
X$95 3 10 M2_M1_CDNS_40661956134258
* cell instance $96 r0 *1 38.75,187.28
X$96 3 7 nmoscap_6p0_CDNS_406619561348
* cell instance $97 m90 *1 38.25,194.78
X$97 3 11 M2_M1_CDNS_40661956134258
* cell instance $98 r0 *1 38.875,184.91
X$98 3 11 M2_M1_CDNS_40661956134462
* cell instance $99 r0 *1 50.03,184.91
X$99 3 13 M2_M1_CDNS_40661956134496
* cell instance $100 r0 *1 55.93,187.28
X$100 3 7 nmoscap_6p0_CDNS_406619561348
* cell instance $101 r0 *1 61.39,184.91
X$101 3 15 M2_M1_CDNS_40661956134496
* cell instance $102 r0 *1 67.84,184.91
X$102 3 17 M2_M1_CDNS_40661956134498
* cell instance $103 m90 *1 72.43,184.91
X$103 3 31 M2_M1_CDNS_40661956134497
* cell instance $104 r0 *1 2.89,204.65
X$104 3 20 M2_M1_CDNS_40661956134497
* cell instance $105 r0 *1 37.66,204.65
X$105 3 47 M1_PSUB_CDNS_40661956134198
* cell instance $106 r0 *1 4.39,207.02
X$106 3 7 nmoscap_6p0_CDNS_406619561348
* cell instance $107 r0 *1 8.25,204.65
X$107 3 23 M2_M1_CDNS_40661956134496
* cell instance $108 r0 *1 13.93,204.65
X$108 3 4 M2_M1_CDNS_40661956134496
* cell instance $109 r0 *1 21.57,207.02
X$109 3 7 nmoscap_6p0_CDNS_406619561348
* cell instance $110 r0 *1 25.29,204.65
X$110 3 8 M2_M1_CDNS_40661956134496
* cell instance $111 r0 *1 36.445,204.65
X$111 3 10 M2_M1_CDNS_40661956134462
* cell instance $112 r0 *1 38.75,207.02
X$112 3 7 nmoscap_6p0_CDNS_406619561348
* cell instance $113 r0 *1 38.875,204.65
X$113 3 11 M2_M1_CDNS_40661956134462
* cell instance $114 r0 *1 50.03,204.65
X$114 3 13 M2_M1_CDNS_40661956134496
* cell instance $115 r0 *1 55.93,207.02
X$115 3 7 nmoscap_6p0_CDNS_406619561348
* cell instance $116 r0 *1 61.39,204.65
X$116 3 15 M2_M1_CDNS_40661956134496
* cell instance $117 r0 *1 67.84,204.65
X$117 3 17 M2_M1_CDNS_40661956134498
* cell instance $118 m90 *1 72.43,204.65
X$118 3 31 M2_M1_CDNS_40661956134497
* cell instance $119 r0 *1 37.07,214.52
X$119 3 10 M2_M1_CDNS_40661956134258
* cell instance $120 m90 *1 38.25,214.52
X$120 3 11 M2_M1_CDNS_40661956134258
* cell instance $121 r0 *1 2.89,224.39
X$121 3 20 M2_M1_CDNS_40661956134497
* cell instance $122 r0 *1 2.57,225.985
X$122 3 20 M3_M2_CDNS_40661956134225
* cell instance $123 r0 *1 37.66,224.39
X$123 3 45 M1_PSUB_CDNS_40661956134198
* cell instance $124 r0 *1 4.39,226.76
X$124 3 7 nmoscap_6p0_CDNS_406619561348
* cell instance $125 r0 *1 8.25,225.985
X$125 3 23 M3_M2_CDNS_40661956134225
* cell instance $126 r0 *1 8.25,224.39
X$126 3 23 M2_M1_CDNS_40661956134496
* cell instance $127 r0 *1 13.93,224.39
X$127 3 4 M2_M1_CDNS_40661956134496
* cell instance $128 r0 *1 13.93,225.985
X$128 3 4 M3_M2_CDNS_40661956134225
* cell instance $129 r0 *1 21.57,226.76
X$129 3 7 nmoscap_6p0_CDNS_406619561348
* cell instance $130 r0 *1 25.29,225.985
X$130 3 8 M3_M2_CDNS_40661956134225
* cell instance $131 r0 *1 25.29,224.39
X$131 3 8 M2_M1_CDNS_40661956134496
* cell instance $132 r0 *1 36.445,225.985
X$132 3 10 M3_M2_CDNS_40661956134490
* cell instance $133 r0 *1 36.445,224.39
X$133 3 10 M2_M1_CDNS_40661956134462
* cell instance $134 r0 *1 37.07,234.26
X$134 3 10 M2_M1_CDNS_40661956134258
* cell instance $135 r0 *1 38.75,226.76
X$135 3 7 nmoscap_6p0_CDNS_406619561348
* cell instance $136 m90 *1 38.25,234.26
X$136 3 11 M2_M1_CDNS_40661956134258
* cell instance $137 m90 *1 38.875,225.985
X$137 3 11 M3_M2_CDNS_40661956134490
* cell instance $138 r0 *1 38.875,224.39
X$138 3 11 M2_M1_CDNS_40661956134462
* cell instance $139 r0 *1 50.03,224.39
X$139 3 13 M2_M1_CDNS_40661956134496
* cell instance $140 m90 *1 50.03,225.985
X$140 3 13 M3_M2_CDNS_40661956134225
* cell instance $141 r0 *1 55.93,226.76
X$141 3 7 nmoscap_6p0_CDNS_406619561348
* cell instance $142 m90 *1 61.39,225.985
X$142 3 15 M3_M2_CDNS_40661956134225
* cell instance $143 r0 *1 61.39,224.39
X$143 3 15 M2_M1_CDNS_40661956134496
* cell instance $144 r0 *1 67.84,224.39
X$144 3 17 M2_M1_CDNS_40661956134498
* cell instance $145 m90 *1 67.84,225.985
X$145 3 17 M3_M2_CDNS_40661956134223
* cell instance $146 m90 *1 72.43,224.39
X$146 3 31 M2_M1_CDNS_40661956134497
* cell instance $147 m90 *1 72.75,225.985
X$147 3 31 M3_M2_CDNS_40661956134225
* cell instance $148 r0 *1 2.89,244.13
X$148 3 20 M2_M1_CDNS_40661956134497
* cell instance $149 r0 *1 2.57,241.985
X$149 3 20 M3_M2_CDNS_40661956134225
* cell instance $150 r0 *1 37.66,244.13
X$150 3 44 M1_PSUB_CDNS_40661956134198
* cell instance $151 r0 *1 4.39,246.5
X$151 3 7 nmoscap_6p0_CDNS_406619561348
* cell instance $152 r0 *1 8.25,244.13
X$152 3 23 M2_M1_CDNS_40661956134496
* cell instance $153 r0 *1 8.25,241.985
X$153 3 23 M3_M2_CDNS_40661956134225
* cell instance $154 r0 *1 13.93,244.13
X$154 3 4 M2_M1_CDNS_40661956134496
* cell instance $155 r0 *1 13.93,241.985
X$155 3 4 M3_M2_CDNS_40661956134225
* cell instance $156 r0 *1 21.57,246.5
X$156 3 7 nmoscap_6p0_CDNS_406619561348
* cell instance $157 r0 *1 25.29,244.13
X$157 3 8 M2_M1_CDNS_40661956134496
* cell instance $158 r0 *1 25.29,241.985
X$158 3 8 M3_M2_CDNS_40661956134225
* cell instance $159 r0 *1 36.445,244.13
X$159 3 10 M2_M1_CDNS_40661956134462
* cell instance $160 r0 *1 36.445,241.985
X$160 3 10 M3_M2_CDNS_40661956134490
* cell instance $161 r0 *1 38.75,246.5
X$161 3 7 nmoscap_6p0_CDNS_406619561348
* cell instance $162 m90 *1 38.875,241.985
X$162 3 11 M3_M2_CDNS_40661956134490
* cell instance $163 r0 *1 38.875,244.13
X$163 3 11 M2_M1_CDNS_40661956134462
* cell instance $164 r0 *1 50.03,244.13
X$164 3 13 M2_M1_CDNS_40661956134496
* cell instance $165 m90 *1 50.03,241.985
X$165 3 13 M3_M2_CDNS_40661956134225
* cell instance $166 r0 *1 55.93,246.5
X$166 3 7 nmoscap_6p0_CDNS_406619561348
* cell instance $167 r0 *1 61.39,244.13
X$167 3 15 M2_M1_CDNS_40661956134496
* cell instance $168 m90 *1 61.39,241.985
X$168 3 15 M3_M2_CDNS_40661956134225
* cell instance $169 r0 *1 67.84,244.13
X$169 3 17 M2_M1_CDNS_40661956134498
* cell instance $170 m90 *1 67.84,241.985
X$170 3 17 M3_M2_CDNS_40661956134223
* cell instance $171 m90 *1 72.43,244.13
X$171 3 31 M2_M1_CDNS_40661956134497
* cell instance $172 m90 *1 72.75,241.985
X$172 3 31 M3_M2_CDNS_40661956134225
* cell instance $173 r0 *1 2.89,263.87
X$173 3 20 M2_M1_CDNS_40661956134497
* cell instance $174 r0 *1 2.57,265.985
X$174 3 20 M3_M2_CDNS_40661956134225
* cell instance $175 r0 *1 37.07,254
X$175 3 10 M2_M1_CDNS_40661956134258
* cell instance $176 m90 *1 38.25,254
X$176 3 11 M2_M1_CDNS_40661956134258
* cell instance $177 m90 *1 72.43,263.87
X$177 3 31 M2_M1_CDNS_40661956134497
* cell instance $178 m90 *1 72.75,265.985
X$178 3 31 M3_M2_CDNS_40661956134225
* cell instance $179 r0 *1 37.66,263.87
X$179 3 46 M1_PSUB_CDNS_40661956134198
* cell instance $180 r0 *1 4.39,266.24
X$180 3 7 nmoscap_6p0_CDNS_406619561348
* cell instance $181 r0 *1 8.25,263.87
X$181 3 23 M2_M1_CDNS_40661956134496
* cell instance $182 r0 *1 8.25,265.985
X$182 3 23 M3_M2_CDNS_40661956134225
* cell instance $183 r0 *1 13.93,265.985
X$183 3 4 M3_M2_CDNS_40661956134225
* cell instance $184 r0 *1 13.93,263.87
X$184 3 4 M2_M1_CDNS_40661956134496
* cell instance $185 r0 *1 21.57,266.24
X$185 3 7 nmoscap_6p0_CDNS_406619561348
* cell instance $186 r0 *1 25.29,265.985
X$186 3 8 M3_M2_CDNS_40661956134225
* cell instance $187 r0 *1 25.29,263.87
X$187 3 8 M2_M1_CDNS_40661956134496
* cell instance $188 r0 *1 36.445,265.985
X$188 3 10 M3_M2_CDNS_40661956134490
* cell instance $189 r0 *1 36.445,263.87
X$189 3 10 M2_M1_CDNS_40661956134462
* cell instance $190 r0 *1 37.07,273.74
X$190 3 10 M2_M1_CDNS_40661956134258
* cell instance $191 r0 *1 36.445,281.68
X$191 3 10 M3_M2_CDNS_4066195613427
* cell instance $192 r0 *1 38.75,266.24
X$192 3 7 nmoscap_6p0_CDNS_406619561348
* cell instance $193 m90 *1 38.25,273.74
X$193 3 11 M2_M1_CDNS_40661956134258
* cell instance $194 m90 *1 38.875,281.68
X$194 3 11 M3_M2_CDNS_4066195613427
* cell instance $195 m90 *1 38.875,265.985
X$195 3 11 M3_M2_CDNS_40661956134490
* cell instance $196 r0 *1 38.875,263.87
X$196 3 11 M2_M1_CDNS_40661956134462
* cell instance $197 r0 *1 50.03,263.87
X$197 3 13 M2_M1_CDNS_40661956134496
* cell instance $198 m90 *1 50.03,265.985
X$198 3 13 M3_M2_CDNS_40661956134225
* cell instance $199 r0 *1 55.93,266.24
X$199 3 7 nmoscap_6p0_CDNS_406619561348
* cell instance $200 r0 *1 61.39,263.87
X$200 3 15 M2_M1_CDNS_40661956134496
* cell instance $201 m90 *1 61.39,265.985
X$201 3 15 M3_M2_CDNS_40661956134225
* cell instance $202 m90 *1 67.07,265.985
X$202 3 17 M3_M2_CDNS_40661956134225
* cell instance $203 r0 *1 67.07,263.87
X$203 3 17 M2_M1_CDNS_40661956134496
* cell instance $204 r0 *1 2.89,282.885
X$204 3 20 M2_M1_CDNS_40661956134493
* cell instance $205 r0 *1 2.57,281.68
X$205 3 20 M3_M2_CDNS_40661956134224
* cell instance $206 r0 *1 37.66,283.61
X$206 3 21 M1_PSUB_CDNS_40661956134198
* cell instance $207 r0 *1 8.25,282.885
X$207 3 23 M2_M1_CDNS_40661956134207
* cell instance $208 r0 *1 8.25,281.68
X$208 3 23 M3_M2_CDNS_40661956134224
* cell instance $209 r0 *1 13.93,282.885
X$209 3 4 M2_M1_CDNS_40661956134207
* cell instance $210 r0 *1 13.93,281.68
X$210 3 4 M3_M2_CDNS_40661956134224
* cell instance $211 r0 *1 25.29,282.885
X$211 3 8 M2_M1_CDNS_40661956134207
* cell instance $212 r0 *1 25.29,281.68
X$212 3 8 M3_M2_CDNS_40661956134224
* cell instance $213 r0 *1 36.445,282.885
X$213 3 10 M2_M1_CDNS_40661956134489
* cell instance $214 r0 *1 38.875,282.885
X$214 3 11 M2_M1_CDNS_40661956134489
* cell instance $215 r0 *1 50.03,282.885
X$215 3 13 M2_M1_CDNS_40661956134207
* cell instance $216 m90 *1 50.03,281.68
X$216 3 13 M3_M2_CDNS_40661956134224
* cell instance $217 r0 *1 61.39,282.885
X$217 3 15 M2_M1_CDNS_40661956134207
* cell instance $218 m90 *1 61.39,281.68
X$218 3 15 M3_M2_CDNS_40661956134224
* cell instance $219 r0 *1 67.07,282.885
X$219 3 17 M2_M1_CDNS_40661956134207
* cell instance $220 m90 *1 67.07,281.68
X$220 3 17 M3_M2_CDNS_40661956134224
* cell instance $221 m90 *1 72.43,282.885
X$221 3 31 M2_M1_CDNS_40661956134493
* cell instance $222 m90 *1 72.75,281.68
X$222 3 31 M3_M2_CDNS_40661956134224
* cell instance $223 r0 *1 58.745,84.44
X$223 3 5 M1_PSUB_CDNS_40661956134199
* cell instance $224 r0 *1 58.745,97.52
X$224 3 5 M1_PSUB_CDNS_40661956134199
* cell instance $225 r0 *1 58.745,93.16
X$225 3 5 M1_PSUB_CDNS_40661956134199
* cell instance $226 r0 *1 58.745,88.8
X$226 3 5 M1_PSUB_CDNS_40661956134199
* cell instance $227 r0 *1 16.575,93.16
X$227 3 5 M1_PSUB_CDNS_40661956134199
* cell instance $228 r0 *1 16.575,88.8
X$228 3 5 M1_PSUB_CDNS_40661956134199
* cell instance $229 r0 *1 16.575,97.52
X$229 3 5 M1_PSUB_CDNS_40661956134199
* cell instance $230 r0 *1 16.575,84.44
X$230 3 5 M1_PSUB_CDNS_40661956134199
* cell instance $231 m90 *1 50.03,137.985
X$231 3 13 M3_M2_CDNS_40661956134225
* cell instance $232 m90 *1 61.39,137.985
X$232 3 15 M3_M2_CDNS_40661956134225
* cell instance $233 m90 *1 72.75,65.985
X$233 3 31 M3_M2_CDNS_40661956134225
* cell instance $234 m90 *1 72.75,137.985
X$234 3 31 M3_M2_CDNS_40661956134225
* cell instance $235 m90 *1 67.07,137.985
X$235 3 17 M3_M2_CDNS_40661956134225
* cell instance $236 r0 *1 25.29,137.985
X$236 3 8 M3_M2_CDNS_40661956134225
* cell instance $237 r0 *1 13.93,137.985
X$237 3 4 M3_M2_CDNS_40661956134225
* cell instance $238 r0 *1 8.25,137.985
X$238 3 23 M3_M2_CDNS_40661956134225
* cell instance $239 r0 *1 2.57,137.985
X$239 3 20 M3_M2_CDNS_40661956134225
* cell instance $240 r0 *1 2.57,65.985
X$240 3 20 M3_M2_CDNS_40661956134225
* cell instance $241 m90 *1 72.75,29.985
X$241 3 31 M3_M2_CDNS_40661956134227
* cell instance $242 m90 *1 50.03,173.985
X$242 3 13 M3_M2_CDNS_40661956134227
* cell instance $243 m90 *1 61.39,173.985
X$243 3 15 M3_M2_CDNS_40661956134227
* cell instance $244 m90 *1 67.07,173.985
X$244 3 17 M3_M2_CDNS_40661956134227
* cell instance $245 m90 *1 72.75,173.985
X$245 3 31 M3_M2_CDNS_40661956134227
* cell instance $246 m90 *1 72.75,13.985
X$246 3 31 M3_M2_CDNS_40661956134227
* cell instance $247 m90 *1 72.75,45.985
X$247 3 31 M3_M2_CDNS_40661956134227
* cell instance $248 r0 *1 25.29,173.985
X$248 3 8 M3_M2_CDNS_40661956134227
* cell instance $249 r0 *1 8.25,173.985
X$249 3 23 M3_M2_CDNS_40661956134227
* cell instance $250 r0 *1 2.57,173.985
X$250 3 20 M3_M2_CDNS_40661956134227
* cell instance $251 r0 *1 13.93,173.985
X$251 3 4 M3_M2_CDNS_40661956134227
* cell instance $252 r0 *1 8.25,13.985
X$252 3 23 M3_M2_CDNS_40661956134227
* cell instance $253 r0 *1 7.005,4.285
X$253 7 3 4 30 22 17 23 15 41 6 8 40 11 39 9 38 10 37 12 36 13 35 14 34 42
+ comp018green_esd_hbm
* cell instance $254 r0 *1 13.93,13.985
X$254 3 4 M3_M2_CDNS_40661956134227
* cell instance $255 r0 *1 25.29,13.985
X$255 3 8 M3_M2_CDNS_40661956134227
* cell instance $256 r0 *1 36.445,13.985
X$256 3 10 M3_M2_CDNS_40661956134491
* cell instance $257 m90 *1 38.875,13.985
X$257 3 11 M3_M2_CDNS_40661956134491
* cell instance $258 m90 *1 50.03,13.985
X$258 3 13 M3_M2_CDNS_40661956134227
* cell instance $259 m90 *1 61.39,13.985
X$259 3 15 M3_M2_CDNS_40661956134227
* cell instance $260 m90 *1 67.07,13.985
X$260 3 17 M3_M2_CDNS_40661956134227
* cell instance $261 r0 *1 8.25,45.985
X$261 3 23 M3_M2_CDNS_40661956134227
* cell instance $262 r0 *1 8.25,29.985
X$262 3 23 M3_M2_CDNS_40661956134227
* cell instance $263 r0 *1 13.93,45.985
X$263 3 4 M3_M2_CDNS_40661956134227
* cell instance $264 r0 *1 13.93,29.985
X$264 3 4 M3_M2_CDNS_40661956134227
* cell instance $265 r0 *1 25.29,45.985
X$265 3 8 M3_M2_CDNS_40661956134227
* cell instance $266 r0 *1 25.29,29.985
X$266 3 8 M3_M2_CDNS_40661956134227
* cell instance $267 r0 *1 36.445,29.985
X$267 3 10 M3_M2_CDNS_40661956134491
* cell instance $268 r0 *1 36.445,45.985
X$268 3 10 M3_M2_CDNS_40661956134491
* cell instance $269 m90 *1 38.875,45.985
X$269 3 11 M3_M2_CDNS_40661956134491
* cell instance $270 m90 *1 38.875,29.985
X$270 3 11 M3_M2_CDNS_40661956134491
* cell instance $271 m90 *1 50.03,45.985
X$271 3 13 M3_M2_CDNS_40661956134227
* cell instance $272 m90 *1 50.03,29.985
X$272 3 13 M3_M2_CDNS_40661956134227
* cell instance $273 m90 *1 61.39,29.985
X$273 3 15 M3_M2_CDNS_40661956134227
* cell instance $274 m90 *1 61.39,45.985
X$274 3 15 M3_M2_CDNS_40661956134227
* cell instance $275 m90 *1 67.07,29.985
X$275 3 17 M3_M2_CDNS_40661956134227
* cell instance $276 m90 *1 67.07,45.985
X$276 3 17 M3_M2_CDNS_40661956134227
* cell instance $277 r0 *1 8.25,65.985
X$277 3 23 M3_M2_CDNS_40661956134225
* cell instance $278 r0 *1 13.93,65.985
X$278 3 4 M3_M2_CDNS_40661956134225
* cell instance $279 r0 *1 25.29,65.985
X$279 3 8 M3_M2_CDNS_40661956134225
* cell instance $280 r0 *1 36.445,65.985
X$280 3 10 M3_M2_CDNS_40661956134490
* cell instance $281 m90 *1 38.875,65.985
X$281 3 11 M3_M2_CDNS_40661956134490
* cell instance $282 m90 *1 50.03,65.985
X$282 3 13 M3_M2_CDNS_40661956134225
* cell instance $283 m90 *1 61.39,65.985
X$283 3 15 M3_M2_CDNS_40661956134225
* cell instance $284 m90 *1 67.07,65.985
X$284 3 17 M3_M2_CDNS_40661956134225
* cell instance $285 r0 *1 2.57,13.985
X$285 3 20 M3_M2_CDNS_40661956134227
* cell instance $286 r0 *1 2.57,29.985
X$286 3 20 M3_M2_CDNS_40661956134227
* cell instance $287 r0 *1 2.57,45.985
X$287 3 20 M3_M2_CDNS_40661956134227
* cell instance $288 r0 *1 25.29,99.355
X$288 3 8 M2_M1_CDNS_40661956134250
* cell instance $289 r0 *1 37.66,99.74
X$289 3 5 M1_PSUB_CDNS_40661956134486
* cell instance $290 r0 *1 37.66,98.97
X$290 3 5 M1_PSUB_CDNS_40661956134200
* cell instance $291 r0 *1 36.445,99.355
X$291 3 10 M2_M1_CDNS_40661956134488
* cell instance $292 r0 *1 38.875,99.355
X$292 3 11 M2_M1_CDNS_40661956134488
* cell instance $293 r0 *1 50.03,99.355
X$293 3 13 M2_M1_CDNS_40661956134250
* cell instance $294 r0 *1 25.29,82.605
X$294 3 8 M2_M1_CDNS_40661956134250
* cell instance $295 r0 *1 37.66,82.22
X$295 3 5 M1_PSUB_CDNS_40661956134486
* cell instance $296 r0 *1 37.66,82.99
X$296 3 5 M1_PSUB_CDNS_40661956134200
* cell instance $297 r0 *1 36.445,82.605
X$297 3 10 M2_M1_CDNS_40661956134488
* cell instance $298 r0 *1 38.875,82.605
X$298 3 11 M2_M1_CDNS_40661956134488
* cell instance $299 r0 *1 50.03,82.605
X$299 3 13 M2_M1_CDNS_40661956134250
* cell instance $300 r0 *1 25.29,95.34
X$300 3 8 M2_M1_CDNS_40661956134207
* cell instance $301 r0 *1 37.66,95.34
X$301 3 5 M1_PSUB_CDNS_40661956134485
* cell instance $302 r0 *1 37.66,94.57
X$302 3 5 M1_PSUB_CDNS_40661956134200
* cell instance $303 r0 *1 37.66,96.11
X$303 3 5 M1_PSUB_CDNS_40661956134200
* cell instance $304 r0 *1 36.445,95.34
X$304 3 10 M2_M1_CDNS_40661956134489
* cell instance $305 r0 *1 38.875,95.34
X$305 3 11 M2_M1_CDNS_40661956134489
* cell instance $306 r0 *1 50.03,95.34
X$306 3 13 M2_M1_CDNS_40661956134207
* cell instance $307 r0 *1 25.29,86.62
X$307 3 8 M2_M1_CDNS_40661956134207
* cell instance $308 r0 *1 37.66,85.85
X$308 3 5 M1_PSUB_CDNS_40661956134200
* cell instance $309 r0 *1 36.445,86.62
X$309 3 10 M2_M1_CDNS_40661956134489
* cell instance $310 r0 *1 38.875,86.62
X$310 3 11 M2_M1_CDNS_40661956134489
* cell instance $311 r0 *1 50.03,86.62
X$311 3 13 M2_M1_CDNS_40661956134207
* cell instance $312 r0 *1 37.66,86.62
X$312 3 5 M1_PSUB_CDNS_40661956134485
* cell instance $313 r0 *1 37.66,87.39
X$313 3 5 M1_PSUB_CDNS_40661956134200
* cell instance $314 r0 *1 25.29,90.98
X$314 3 8 M2_M1_CDNS_40661956134207
* cell instance $315 r0 *1 37.66,90.98
X$315 3 5 M1_PSUB_CDNS_40661956134485
* cell instance $316 r0 *1 37.66,90.21
X$316 3 5 M1_PSUB_CDNS_40661956134200
* cell instance $317 r0 *1 37.66,91.75
X$317 3 5 M1_PSUB_CDNS_40661956134200
* cell instance $318 r0 *1 36.445,90.98
X$318 3 10 M2_M1_CDNS_40661956134489
* cell instance $319 r0 *1 38.875,90.98
X$319 3 11 M2_M1_CDNS_40661956134489
* cell instance $320 r0 *1 50.03,90.98
X$320 3 13 M2_M1_CDNS_40661956134207
* cell instance $321 r0 *1 18.775,254
X$321 7 6 M2_M1_CDNS_40661956134495
* cell instance $322 r0 *1 18.775,175.04
X$322 7 6 M2_M1_CDNS_40661956134495
* cell instance $323 r0 *1 18.775,194.78
X$323 7 6 M2_M1_CDNS_40661956134495
* cell instance $324 r0 *1 19.61,201.985
X$324 7 6 M3_M2_CDNS_40661956134225
* cell instance $325 r0 *1 18.775,273.74
X$325 7 6 M2_M1_CDNS_40661956134495
* cell instance $326 r0 *1 19.61,273.985
X$326 7 6 M3_M2_CDNS_40661956134225
* cell instance $327 r0 *1 18.775,234.26
X$327 7 6 M2_M1_CDNS_40661956134495
* cell instance $328 r0 *1 19.61,233.985
X$328 7 6 M3_M2_CDNS_40661956134225
* cell instance $329 r0 *1 18.775,214.52
X$329 7 6 M2_M1_CDNS_40661956134495
* cell instance $330 r0 *1 19.61,209.985
X$330 7 6 M3_M2_CDNS_40661956134225
* cell instance $331 r0 *1 19.61,217.985
X$331 7 6 M3_M2_CDNS_40661956134225
* cell instance $332 r0 *1 19.61,57.985
X$332 7 6 M3_M2_CDNS_40661956134225
* cell instance $333 r0 *1 19.61,77.985
X$333 7 6 M3_M2_CDNS_40661956134227
* cell instance $334 r0 *1 19.61,79.745
X$334 7 6 M2_M1_CDNS_40661956134207
* cell instance $335 r0 *1 19.61,84.44
X$335 7 6 M2_M1_CDNS_40661956134250
* cell instance $336 r0 *1 19.61,109.985
X$336 7 6 M3_M2_CDNS_40661956134227
* cell instance $337 r0 *1 19.61,102.215
X$337 7 6 M2_M1_CDNS_40661956134207
* cell instance $338 r0 *1 18.775,115.82
X$338 7 6 M2_M1_CDNS_40661956134495
* cell instance $339 r0 *1 19.61,125.985
X$339 7 6 M3_M2_CDNS_40661956134227
* cell instance $340 r0 *1 18.775,135.56
X$340 7 6 M2_M1_CDNS_40661956134495
* cell instance $341 r0 *1 19.61,145.985
X$341 7 6 M3_M2_CDNS_40661956134225
* cell instance $342 r0 *1 18.775,155.3
X$342 7 6 M2_M1_CDNS_40661956134495
* cell instance $343 r0 *1 19.61,157.985
X$343 7 6 M3_M2_CDNS_40661956134227
* cell instance $344 r0 *1 19.61,93.985
X$344 7 6 M3_M2_CDNS_40661956134227
* cell instance $345 r0 *1 19.61,88.8
X$345 7 6 M2_M1_CDNS_40661956134250
* cell instance $346 r0 *1 19.61,93.16
X$346 7 6 M2_M1_CDNS_40661956134250
* cell instance $347 r0 *1 19.61,97.52
X$347 7 6 M2_M1_CDNS_40661956134250
* cell instance $348 r0 *1 13.39,90.98
X$348 7 16 7 43 M1_NWELL_CDNS_40661956134483
* cell instance $349 r0 *1 61.93,90.98
X$349 7 16 7 43 M1_NWELL_CDNS_40661956134483
* cell instance $350 r0 *1 6.18,234.26
X$350 7 26 M2_M1_CDNS_40661956134492
* cell instance $351 r0 *1 6.18,233.985
X$351 7 26 M3_M2_CDNS_40661956134223
* cell instance $352 r0 *1 6.18,254
X$352 7 26 M2_M1_CDNS_40661956134492
* cell instance $353 r0 *1 6.18,214.52
X$353 7 26 M2_M1_CDNS_40661956134492
* cell instance $354 r0 *1 6.18,209.985
X$354 7 26 M3_M2_CDNS_40661956134223
* cell instance $355 r0 *1 6.18,217.985
X$355 7 26 M3_M2_CDNS_40661956134223
* cell instance $356 m90 *1 43.515,234.26
X$356 7 12 M2_M1_CDNS_40661956134495
* cell instance $357 m90 *1 44.35,233.985
X$357 7 12 M3_M2_CDNS_40661956134225
* cell instance $358 m90 *1 43.515,175.04
X$358 7 12 M2_M1_CDNS_40661956134495
* cell instance $359 m90 *1 56.545,194.78
X$359 7 14 M2_M1_CDNS_40661956134495
* cell instance $360 m90 *1 69.68,194.78
X$360 7 27 M2_M1_CDNS_40661956134494
* cell instance $361 m90 *1 55.71,201.985
X$361 7 14 M3_M2_CDNS_40661956134225
* cell instance $362 m90 *1 69.91,201.985
X$362 7 27 M3_M2_CDNS_40661956134225
* cell instance $363 m90 *1 43.515,254
X$363 7 12 M2_M1_CDNS_40661956134495
* cell instance $364 m90 *1 43.515,273.74
X$364 7 12 M2_M1_CDNS_40661956134495
* cell instance $365 m90 *1 44.35,273.985
X$365 7 12 M3_M2_CDNS_40661956134225
* cell instance $366 m90 *1 43.515,194.78
X$366 7 12 M2_M1_CDNS_40661956134495
* cell instance $367 m90 *1 44.35,201.985
X$367 7 12 M3_M2_CDNS_40661956134225
* cell instance $368 m90 *1 56.545,273.74
X$368 7 14 M2_M1_CDNS_40661956134495
* cell instance $369 m90 *1 55.71,273.985
X$369 7 14 M3_M2_CDNS_40661956134225
* cell instance $370 m90 *1 69.68,273.74
X$370 7 27 M2_M1_CDNS_40661956134494
* cell instance $371 m90 *1 69.91,273.985
X$371 7 27 M3_M2_CDNS_40661956134225
* cell instance $372 m90 *1 56.545,214.52
X$372 7 14 M2_M1_CDNS_40661956134495
* cell instance $373 m90 *1 55.71,209.985
X$373 7 14 M3_M2_CDNS_40661956134225
* cell instance $374 m90 *1 69.68,214.52
X$374 7 27 M2_M1_CDNS_40661956134494
* cell instance $375 m90 *1 69.91,209.985
X$375 7 27 M3_M2_CDNS_40661956134225
* cell instance $376 m90 *1 55.71,217.985
X$376 7 14 M3_M2_CDNS_40661956134225
* cell instance $377 m90 *1 69.91,217.985
X$377 7 27 M3_M2_CDNS_40661956134225
* cell instance $378 m90 *1 43.515,214.52
X$378 7 12 M2_M1_CDNS_40661956134495
* cell instance $379 m90 *1 44.35,209.985
X$379 7 12 M3_M2_CDNS_40661956134225
* cell instance $380 m90 *1 44.35,217.985
X$380 7 12 M3_M2_CDNS_40661956134225
* cell instance $381 m90 *1 56.545,254
X$381 7 14 M2_M1_CDNS_40661956134495
* cell instance $382 m90 *1 69.68,254
X$382 7 27 M2_M1_CDNS_40661956134494
* cell instance $383 m90 *1 56.545,234.26
X$383 7 14 M2_M1_CDNS_40661956134495
* cell instance $384 m90 *1 55.71,233.985
X$384 7 14 M3_M2_CDNS_40661956134225
* cell instance $385 m90 *1 69.68,234.26
X$385 7 27 M2_M1_CDNS_40661956134494
* cell instance $386 m90 *1 69.91,233.985
X$386 7 27 M3_M2_CDNS_40661956134225
* cell instance $387 r0 *1 31.805,273.74
X$387 7 9 M2_M1_CDNS_40661956134495
* cell instance $388 r0 *1 30.97,273.985
X$388 7 9 M3_M2_CDNS_40661956134225
* cell instance $389 r0 *1 31.805,254
X$389 7 9 M2_M1_CDNS_40661956134495
* cell instance $390 r0 *1 31.805,234.26
X$390 7 9 M2_M1_CDNS_40661956134495
* cell instance $391 r0 *1 30.97,233.985
X$391 7 9 M3_M2_CDNS_40661956134225
* cell instance $392 r0 *1 31.805,214.52
X$392 7 9 M2_M1_CDNS_40661956134495
* cell instance $393 r0 *1 30.97,209.985
X$393 7 9 M3_M2_CDNS_40661956134225
* cell instance $394 r0 *1 30.97,217.985
X$394 7 9 M3_M2_CDNS_40661956134225
* cell instance $395 r0 *1 31.805,175.04
X$395 7 9 M2_M1_CDNS_40661956134495
* cell instance $396 r0 *1 31.805,194.78
X$396 7 9 M2_M1_CDNS_40661956134495
* cell instance $397 r0 *1 30.97,201.985
X$397 7 9 M3_M2_CDNS_40661956134225
* cell instance $398 m90 *1 69.68,175.04
X$398 7 27 M2_M1_CDNS_40661956134494
* cell instance $399 m90 *1 56.545,175.04
X$399 7 14 M2_M1_CDNS_40661956134495
* cell instance $400 r0 *1 5.64,175.04
X$400 7 26 M2_M1_CDNS_40661956134494
* cell instance $401 r0 *1 5.64,273.74
X$401 7 26 M2_M1_CDNS_40661956134494
* cell instance $402 r0 *1 5.41,273.985
X$402 7 26 M3_M2_CDNS_40661956134225
* cell instance $403 r0 *1 37.66,79.73
X$403 7 7 43 16 M1_NWELL_CDNS_40661956134487
* cell instance $404 r0 *1 37.66,102.23
X$404 7 7 43 16 M1_NWELL_CDNS_40661956134487
* cell instance $405 r0 *1 6.18,194.78
X$405 7 26 M2_M1_CDNS_40661956134492
* cell instance $406 r0 *1 6.18,201.985
X$406 7 26 M3_M2_CDNS_40661956134223
* cell instance $407 m90 *1 64.23,145.985
X$407 7 30 M3_M2_CDNS_40661956134225
* cell instance $408 m90 *1 64.23,273.985
X$408 7 30 M3_M2_CDNS_40661956134225
* cell instance $409 m90 *1 64.23,217.985
X$409 7 30 M3_M2_CDNS_40661956134225
* cell instance $410 m90 *1 64.23,201.985
X$410 7 30 M3_M2_CDNS_40661956134225
* cell instance $411 m90 *1 69.91,57.985
X$411 7 27 M3_M2_CDNS_40661956134225
* cell instance $412 m90 *1 64.23,209.985
X$412 7 30 M3_M2_CDNS_40661956134225
* cell instance $413 m90 *1 64.23,233.985
X$413 7 30 M3_M2_CDNS_40661956134225
* cell instance $414 r0 *1 11.09,145.985
X$414 7 22 M3_M2_CDNS_40661956134225
* cell instance $415 r0 *1 11.09,201.985
X$415 7 22 M3_M2_CDNS_40661956134225
* cell instance $416 r0 *1 11.09,209.985
X$416 7 22 M3_M2_CDNS_40661956134225
* cell instance $417 r0 *1 11.09,233.985
X$417 7 22 M3_M2_CDNS_40661956134225
* cell instance $418 r0 *1 11.09,273.985
X$418 7 22 M3_M2_CDNS_40661956134225
* cell instance $419 r0 *1 11.09,217.985
X$419 7 22 M3_M2_CDNS_40661956134225
* cell instance $420 r0 *1 11.09,57.985
X$420 7 22 M3_M2_CDNS_40661956134225
* cell instance $421 r0 *1 30.97,57.985
X$421 7 9 M3_M2_CDNS_40661956134225
* cell instance $422 m90 *1 44.35,57.985
X$422 7 12 M3_M2_CDNS_40661956134225
* cell instance $423 m90 *1 55.71,57.985
X$423 7 14 M3_M2_CDNS_40661956134225
* cell instance $424 m90 *1 64.23,57.985
X$424 7 30 M3_M2_CDNS_40661956134225
* cell instance $425 r0 *1 11.09,77.985
X$425 7 22 M3_M2_CDNS_40661956134227
* cell instance $426 r0 *1 30.97,79.745
X$426 7 9 M2_M1_CDNS_40661956134207
* cell instance $427 r0 *1 30.97,77.985
X$427 7 9 M3_M2_CDNS_40661956134227
* cell instance $428 r0 *1 44.35,79.745
X$428 7 12 M2_M1_CDNS_40661956134207
* cell instance $429 m90 *1 44.35,77.985
X$429 7 12 M3_M2_CDNS_40661956134227
* cell instance $430 r0 *1 55.71,79.745
X$430 7 14 M2_M1_CDNS_40661956134207
* cell instance $431 m90 *1 55.71,77.985
X$431 7 14 M3_M2_CDNS_40661956134227
* cell instance $432 m90 *1 64.23,77.985
X$432 7 30 M3_M2_CDNS_40661956134227
* cell instance $433 r0 *1 17.66,83.94
X$433 7 np_6p0_CDNS_406619561349
* cell instance $434 r0 *1 30.97,84.44
X$434 7 9 M2_M1_CDNS_40661956134250
* cell instance $435 r0 *1 44.35,84.44
X$435 7 12 M2_M1_CDNS_40661956134250
* cell instance $436 r0 *1 55.71,84.44
X$436 7 14 M2_M1_CDNS_40661956134250
* cell instance $437 r0 *1 5.41,57.985
X$437 7 26 M3_M2_CDNS_40661956134225
* cell instance $438 m90 *1 69.91,93.985
X$438 7 27 M3_M2_CDNS_40661956134227
* cell instance $439 m90 *1 64.23,109.985
X$439 7 30 M3_M2_CDNS_40661956134227
* cell instance $440 m90 *1 64.23,157.985
X$440 7 30 M3_M2_CDNS_40661956134227
* cell instance $441 m90 *1 64.23,93.985
X$441 7 30 M3_M2_CDNS_40661956134227
* cell instance $442 m90 *1 64.23,125.985
X$442 7 30 M3_M2_CDNS_40661956134227
* cell instance $443 m90 *1 69.91,77.985
X$443 7 27 M3_M2_CDNS_40661956134227
* cell instance $444 r0 *1 5.41,77.985
X$444 7 26 M3_M2_CDNS_40661956134227
* cell instance $445 r0 *1 11.09,125.985
X$445 7 22 M3_M2_CDNS_40661956134227
* cell instance $446 r0 *1 11.09,157.985
X$446 7 22 M3_M2_CDNS_40661956134227
* cell instance $447 r0 *1 11.09,109.985
X$447 7 22 M3_M2_CDNS_40661956134227
* cell instance $448 r0 *1 5.41,93.985
X$448 7 26 M3_M2_CDNS_40661956134227
* cell instance $449 r0 *1 11.09,93.985
X$449 7 22 M3_M2_CDNS_40661956134227
* cell instance $450 r0 *1 17.66,88.3
X$450 7 np_6p0_CDNS_406619561349
* cell instance $451 r0 *1 30.97,88.8
X$451 7 9 M2_M1_CDNS_40661956134250
* cell instance $452 r0 *1 30.97,93.985
X$452 7 9 M3_M2_CDNS_40661956134227
* cell instance $453 r0 *1 44.35,88.8
X$453 7 12 M2_M1_CDNS_40661956134250
* cell instance $454 m90 *1 44.35,93.985
X$454 7 12 M3_M2_CDNS_40661956134227
* cell instance $455 r0 *1 55.71,88.8
X$455 7 14 M2_M1_CDNS_40661956134250
* cell instance $456 m90 *1 55.71,93.985
X$456 7 14 M3_M2_CDNS_40661956134227
* cell instance $457 r0 *1 17.66,92.66
X$457 7 np_6p0_CDNS_406619561349
* cell instance $458 r0 *1 30.97,93.16
X$458 7 9 M2_M1_CDNS_40661956134250
* cell instance $459 r0 *1 44.35,93.16
X$459 7 12 M2_M1_CDNS_40661956134250
* cell instance $460 r0 *1 55.71,93.16
X$460 7 14 M2_M1_CDNS_40661956134250
* cell instance $461 r0 *1 17.66,97.02
X$461 7 np_6p0_CDNS_406619561349
* cell instance $462 r0 *1 30.97,97.52
X$462 7 9 M2_M1_CDNS_40661956134250
* cell instance $463 r0 *1 44.35,97.52
X$463 7 12 M2_M1_CDNS_40661956134250
* cell instance $464 r0 *1 55.71,97.52
X$464 7 14 M2_M1_CDNS_40661956134250
* cell instance $465 r0 *1 30.97,102.215
X$465 7 9 M2_M1_CDNS_40661956134207
* cell instance $466 r0 *1 30.97,109.985
X$466 7 9 M3_M2_CDNS_40661956134227
* cell instance $467 r0 *1 44.35,102.215
X$467 7 12 M2_M1_CDNS_40661956134207
* cell instance $468 m90 *1 44.35,109.985
X$468 7 12 M3_M2_CDNS_40661956134227
* cell instance $469 r0 *1 55.71,102.215
X$469 7 14 M2_M1_CDNS_40661956134207
* cell instance $470 m90 *1 55.71,109.985
X$470 7 14 M3_M2_CDNS_40661956134227
* cell instance $471 r0 *1 5.64,115.82
X$471 7 26 M2_M1_CDNS_40661956134494
* cell instance $472 r0 *1 5.41,125.985
X$472 7 26 M3_M2_CDNS_40661956134227
* cell instance $473 r0 *1 5.41,109.985
X$473 7 26 M3_M2_CDNS_40661956134227
* cell instance $474 r0 *1 31.805,115.82
X$474 7 9 M2_M1_CDNS_40661956134495
* cell instance $475 r0 *1 30.97,125.985
X$475 7 9 M3_M2_CDNS_40661956134227
* cell instance $476 m90 *1 43.515,115.82
X$476 7 12 M2_M1_CDNS_40661956134495
* cell instance $477 m90 *1 44.35,125.985
X$477 7 12 M3_M2_CDNS_40661956134227
* cell instance $478 m90 *1 56.545,115.82
X$478 7 14 M2_M1_CDNS_40661956134495
* cell instance $479 m90 *1 55.71,125.985
X$479 7 14 M3_M2_CDNS_40661956134227
* cell instance $480 m90 *1 69.68,115.82
X$480 7 27 M2_M1_CDNS_40661956134494
* cell instance $481 m90 *1 69.91,109.985
X$481 7 27 M3_M2_CDNS_40661956134227
* cell instance $482 m90 *1 69.91,125.985
X$482 7 27 M3_M2_CDNS_40661956134227
* cell instance $483 r0 *1 5.64,135.56
X$483 7 26 M2_M1_CDNS_40661956134494
* cell instance $484 r0 *1 31.805,135.56
X$484 7 9 M2_M1_CDNS_40661956134495
* cell instance $485 m90 *1 43.515,135.56
X$485 7 12 M2_M1_CDNS_40661956134495
* cell instance $486 m90 *1 56.545,135.56
X$486 7 14 M2_M1_CDNS_40661956134495
* cell instance $487 m90 *1 69.68,135.56
X$487 7 27 M2_M1_CDNS_40661956134494
* cell instance $488 r0 *1 5.64,155.3
X$488 7 26 M2_M1_CDNS_40661956134494
* cell instance $489 r0 *1 5.41,145.985
X$489 7 26 M3_M2_CDNS_40661956134225
* cell instance $490 r0 *1 30.97,145.985
X$490 7 9 M3_M2_CDNS_40661956134225
* cell instance $491 m90 *1 44.35,145.985
X$491 7 12 M3_M2_CDNS_40661956134225
* cell instance $492 m90 *1 55.71,145.985
X$492 7 14 M3_M2_CDNS_40661956134225
* cell instance $493 m90 *1 69.91,145.985
X$493 7 27 M3_M2_CDNS_40661956134225
* cell instance $494 m90 *1 69.68,155.3
X$494 7 27 M2_M1_CDNS_40661956134494
* cell instance $495 r0 *1 5.41,157.985
X$495 7 26 M3_M2_CDNS_40661956134227
* cell instance $496 r0 *1 31.805,155.3
X$496 7 9 M2_M1_CDNS_40661956134495
* cell instance $497 r0 *1 30.97,157.985
X$497 7 9 M3_M2_CDNS_40661956134227
* cell instance $498 m90 *1 43.515,155.3
X$498 7 12 M2_M1_CDNS_40661956134495
* cell instance $499 m90 *1 44.35,157.985
X$499 7 12 M3_M2_CDNS_40661956134227
* cell instance $500 m90 *1 56.545,155.3
X$500 7 14 M2_M1_CDNS_40661956134495
* cell instance $501 m90 *1 55.71,157.985
X$501 7 14 M3_M2_CDNS_40661956134227
* cell instance $502 m90 *1 69.91,157.985
X$502 7 27 M3_M2_CDNS_40661956134227
* cell instance $503 r0 *1 4.64,193.985
X$503 25 24 M3_M2_CDNS_40661956134223
* cell instance $504 r0 *1 4.64,249.985
X$504 25 24 M3_M2_CDNS_40661956134223
* cell instance $505 m90 *1 66.3,257.985
X$505 29 28 M3_M2_CDNS_40661956134223
* cell instance $506 m90 *1 66.3,185.985
X$506 29 28 M3_M2_CDNS_40661956134223
.ENDS GF_NI_ASIG_5P0_BASE

* cell 3LM_METAL_RAIL_PAD_60
* pin
* pin
* pin
* pin
* pin
* pin
* pin
* pin
.SUBCKT 3LM_METAL_RAIL_PAD_60 1 2 3 4 5 6 7 8
* cell instance $1 r0 *1 0,0
X$1 1 8 4 7 6 5 3LM_METAL_RAIL
* cell instance $2 r0 *1 5.5,0
X$2 3 2 Bondpad_3LM
.ENDS 3LM_METAL_RAIL_PAD_60

* cell M3_M2_CDNS_40661956134181
* pin
* pin
.SUBCKT M3_M2_CDNS_40661956134181 1 2
.ENDS M3_M2_CDNS_40661956134181

* cell M2_M1_CDNS_40661956134179
* pin
* pin
.SUBCKT M2_M1_CDNS_40661956134179 1 2
.ENDS M2_M1_CDNS_40661956134179

* cell POLY_SUB_FILL_1
* pin
* pin
* pin
.SUBCKT POLY_SUB_FILL_1 1 2 3
* device instance $1 r0 *1 6.425,4.615 nmoscap_6p0
C$1 2 1 9.66e-14 nmoscap_6p0 A=42P P=26U
* device instance $2 r0 *1 6.425,12.175 nmoscap_6p0
C$2 2 1 9.66e-14 nmoscap_6p0 A=42P P=26U
.ENDS POLY_SUB_FILL_1

* cell M3_M2_CDNS_40661956134172
* pin
* pin
.SUBCKT M3_M2_CDNS_40661956134172 1 2
.ENDS M3_M2_CDNS_40661956134172

* cell M3_M2_CDNS_40661956134175
* pin
* pin
.SUBCKT M3_M2_CDNS_40661956134175 1 2
.ENDS M3_M2_CDNS_40661956134175

* cell M1_PSUB_CDNS_40661956134182
* pin
* pin
.SUBCKT M1_PSUB_CDNS_40661956134182 1 2
.ENDS M1_PSUB_CDNS_40661956134182

* cell M2_M1_CDNS_40661956134208
* pin
* pin
.SUBCKT M2_M1_CDNS_40661956134208 1 2
.ENDS M2_M1_CDNS_40661956134208

* cell M2_M1_CDNS_40661956134209
* pin
* pin
.SUBCKT M2_M1_CDNS_40661956134209 1 2
.ENDS M2_M1_CDNS_40661956134209

* cell M2_M1_CDNS_40661956134210
* pin
* pin
.SUBCKT M2_M1_CDNS_40661956134210 1 2
.ENDS M2_M1_CDNS_40661956134210

* cell M2_M1_CDNS_40661956134211
* pin
* pin
.SUBCKT M2_M1_CDNS_40661956134211 1 2
.ENDS M2_M1_CDNS_40661956134211

* cell M2_M1_CDNS_40661956134212
* pin
* pin
.SUBCKT M2_M1_CDNS_40661956134212 1 2
.ENDS M2_M1_CDNS_40661956134212

* cell M2_M1_CDNS_40661956134213
* pin
* pin
.SUBCKT M2_M1_CDNS_40661956134213 1 2
.ENDS M2_M1_CDNS_40661956134213

* cell M2_M1_CDNS_40661956134214
* pin
* pin
.SUBCKT M2_M1_CDNS_40661956134214 1 2
.ENDS M2_M1_CDNS_40661956134214

* cell M2_M1_CDNS_40661956134216
* pin
* pin
.SUBCKT M2_M1_CDNS_40661956134216 1 2
.ENDS M2_M1_CDNS_40661956134216

* cell M2_M1_CDNS_40661956134215
* pin
* pin
.SUBCKT M2_M1_CDNS_40661956134215 1 2
.ENDS M2_M1_CDNS_40661956134215

* cell M2_M1_CDNS_40661956134220
* pin
* pin
.SUBCKT M2_M1_CDNS_40661956134220 1 2
.ENDS M2_M1_CDNS_40661956134220

* cell comp018green_esd_clamp_v5p0_DVDD
* pin
* pin
* pin
* pin
* pin
* pin
* pin
* pin
* pin
* pin
* pin
* pin
* pin
* pin gf180mcu_gnd
.SUBCKT comp018green_esd_clamp_v5p0_DVDD 1 3 8 9 11 12 13 14 15 16 18 19 20 21
* net 21 gf180mcu_gnd
* cell instance $1 m90 *1 32.405,128.805
X$1 1 14 M2_M1_CDNS_40661956134232
* cell instance $2 r0 *1 0,0
X$2 6 3 1 8 25 9 18 16 15 14 13 11 12 24 19 20 21 nmos_clamp_20_50_4_DVDD
* cell instance $3 m90 *1 19.715,137.29
X$3 1 11 M2_M1_CDNS_40661956134237
* cell instance $4 r0 *1 25.66,137.31
X$4 1 4 M1_PSUB_CDNS_40661956134243
* cell instance $5 m90 *1 31.935,137.29
X$5 1 14 M2_M1_CDNS_40661956134245
* cell instance $6 m90 *1 45.095,137.29
X$6 1 16 M2_M1_CDNS_40661956134237
* cell instance $7 r0 *1 42.775,137.31
X$7 1 4 M1_PSUB_CDNS_40661956134244
* cell instance $8 m90 *1 45.095,128.805
X$8 1 16 M2_M1_CDNS_40661956134237
* cell instance $9 m90 *1 56.945,128.805
X$9 1 19 M2_M1_CDNS_40661956134237
* cell instance $10 m90 *1 19.715,128.805
X$10 1 11 M2_M1_CDNS_40661956134237
* cell instance $11 r0 *1 7.865,128.805
X$11 1 9 M2_M1_CDNS_40661956134237
* cell instance $12 r0 *1 20.645,130.03
X$12 1 5 2 21 nmos_6p0_CDNS_406619561347
* cell instance $13 m0 *1 11.49,132.61
X$13 1 4 M1_PSUB_CDNS_40661956134125
* cell instance $14 m0 *1 53.32,132.61
X$14 1 4 M1_PSUB_CDNS_40661956134125
* cell instance $15 r0 *1 33.275,130.03
X$15 23 1 6 1 6 1 6 1 7 7 7 7 7 7 nmos_6p0_CDNS_406619561346
* cell instance $16 r0 *1 25.955,130.03
X$16 23 1 7 1 7 1 7 1 5 5 5 5 5 5 nmos_6p0_CDNS_406619561346
* cell instance $17 m0 *1 -1.78,232.535
X$17 3 2 1 21 comp018green_esd_rc_v5p0
* cell instance $18 r0 *1 7.865,208.275
X$18 1 9 M2_M1_CDNS_40661956134235
* cell instance $19 r0 *1 7.865,178.31
X$19 1 9 M2_M1_CDNS_40661956134239
* cell instance $20 r0 *1 7.865,147.855
X$20 1 9 M2_M1_CDNS_40661956134235
* cell instance $21 r0 *1 19.715,178.31
X$21 1 11 M2_M1_CDNS_40661956134239
* cell instance $22 r0 *1 19.715,147.855
X$22 1 11 M2_M1_CDNS_40661956134235
* cell instance $23 r0 *1 19.715,208.275
X$23 1 11 M2_M1_CDNS_40661956134235
* cell instance $24 r0 *1 32.405,208.275
X$24 1 14 M2_M1_CDNS_40661956134231
* cell instance $25 r0 *1 32.405,147.855
X$25 1 14 M2_M1_CDNS_40661956134231
* cell instance $26 r0 *1 32.405,178.31
X$26 1 14 M2_M1_CDNS_40661956134241
* cell instance $27 r0 *1 45.095,147.855
X$27 1 16 M2_M1_CDNS_40661956134235
* cell instance $28 r0 *1 45.095,208.275
X$28 1 16 M2_M1_CDNS_40661956134235
* cell instance $29 r0 *1 45.095,178.31
X$29 1 16 M2_M1_CDNS_40661956134239
* cell instance $30 r0 *1 56.945,208.275
X$30 1 19 M2_M1_CDNS_40661956134235
* cell instance $31 r0 *1 56.945,178.31
X$31 1 19 M2_M1_CDNS_40661956134239
* cell instance $32 r0 *1 56.945,147.855
X$32 1 19 M2_M1_CDNS_40661956134235
* cell instance $33 r0 *1 20.71,135.54
X$33 2 M1_POLY2_CDNS_40661956134128
* cell instance $34 r0 *1 15.505,138.435
X$34 2 M1_POLY2_CDNS_40661956134127
* cell instance $35 r0 *1 13.325,139.585
X$35 22 5 3 5 3 3 2 2 2 2 17 3 pmos_6p0_CDNS_406619561344
* cell instance $36 r0 *1 18.205,139.585
X$36 22 7 3 3 7 5 5 5 17 3 pmos_6p0_CDNS_406619561343
* cell instance $37 r0 *1 22.725,139.585
X$37 3 6 3 6 3 6 3 6 3 6 3 6 3 6 3 6 3 6 3 6 3 6 3 6 3 7 7 7 7 7 7 7 7 7 7 7 7
+ 7 7 7 7 7 7 7 7 7 7 7 7 17 3 pmos_6p0_CDNS_406619561342
* cell instance $38 r0 *1 13.065,142.635
X$38 3 12 M2_M1_CDNS_40661956134242
* cell instance $39 r0 *1 11.49,142.235
X$39 3 10 17 3 M1_NWELL_CDNS_40661956134133
* cell instance $40 r0 *1 11.51,142.555
X$40 3 12 M2_M1_CDNS_40661956134240
* cell instance $41 r0 *1 32.405,145.825
X$41 3 10 17 3 M1_NWELL_CDNS_40661956134129
* cell instance $42 r0 *1 15.505,142.635
X$42 3 12 M2_M1_CDNS_40661956134242
* cell instance $43 r0 *1 17.945,142.635
X$43 3 12 M2_M1_CDNS_40661956134242
* cell instance $44 r0 *1 22.465,142.635
X$44 3 13 M2_M1_CDNS_40661956134242
* cell instance $45 r0 *1 24.905,142.635
X$45 3 13 M2_M1_CDNS_40661956134242
* cell instance $46 r0 *1 27.345,142.635
X$46 3 13 M2_M1_CDNS_40661956134242
* cell instance $47 r0 *1 29.785,142.635
X$47 3 13 M2_M1_CDNS_40661956134242
* cell instance $48 r0 *1 34.665,142.635
X$48 3 15 M2_M1_CDNS_40661956134242
* cell instance $49 r0 *1 37.105,142.635
X$49 3 15 M2_M1_CDNS_40661956134242
* cell instance $50 r0 *1 39.545,142.635
X$50 3 15 M2_M1_CDNS_40661956134242
* cell instance $51 r0 *1 41.985,142.635
X$51 3 15 M2_M1_CDNS_40661956134242
* cell instance $52 r0 *1 46.865,142.635
X$52 3 18 M2_M1_CDNS_40661956134242
* cell instance $53 r0 *1 49.305,142.635
X$53 3 18 M2_M1_CDNS_40661956134242
* cell instance $54 r0 *1 51.745,142.635
X$54 3 18 M2_M1_CDNS_40661956134242
* cell instance $55 r0 *1 53.3,142.635
X$55 3 18 M2_M1_CDNS_40661956134242
* cell instance $56 r0 *1 53.32,142.235
X$56 3 10 17 3 M1_NWELL_CDNS_40661956134133
* cell instance $57 r0 *1 -1.415,220.08
X$57 3 8 M2_M1_CDNS_40661956134236
* cell instance $58 r0 *1 2.47,229.44
X$58 3 8 M2_M1_CDNS_40661956134234
* cell instance $59 r0 *1 3.225,210.74
X$59 3 8 M2_M1_CDNS_40661956134233
* cell instance $60 r0 *1 13.79,210.74
X$60 3 12 M2_M1_CDNS_40661956134238
* cell instance $61 r0 *1 13.79,229.44
X$61 3 12 M2_M1_CDNS_40661956134238
* cell instance $62 r0 *1 25.64,210.74
X$62 3 13 M2_M1_CDNS_40661956134238
* cell instance $63 r0 *1 25.64,229.44
X$63 3 13 M2_M1_CDNS_40661956134238
* cell instance $64 r0 *1 39.17,210.74
X$64 3 15 M2_M1_CDNS_40661956134238
* cell instance $65 r0 *1 39.17,229.44
X$65 3 15 M2_M1_CDNS_40661956134238
* cell instance $66 r0 *1 51.02,229.44
X$66 3 18 M2_M1_CDNS_40661956134238
* cell instance $67 r0 *1 51.02,210.74
X$67 3 18 M2_M1_CDNS_40661956134238
* cell instance $68 r0 *1 62.405,210.74
X$68 3 20 M2_M1_CDNS_40661956134234
* cell instance $69 r0 *1 62.405,229.44
X$69 3 20 M2_M1_CDNS_40661956134234
* cell instance $70 r0 *1 66.225,220.08
X$70 3 20 M2_M1_CDNS_40661956134236
* cell instance $71 r0 *1 29.355,136.18
X$71 5 M1_POLY2_CDNS_40661956134131
* cell instance $72 r0 *1 19.775,138.435
X$72 5 M1_POLY2_CDNS_40661956134130
* cell instance $73 r0 *1 6.565,127.585
X$73 6 25 M2_M1_CDNS_40661956134126
* cell instance $74 r0 *1 58.245,127.585
X$74 6 24 M2_M1_CDNS_40661956134126
* cell instance $75 r0 *1 36.675,136.18
X$75 7 M1_POLY2_CDNS_40661956134131
* cell instance $76 r0 *1 37.105,138.435
X$76 7 M1_POLY2_CDNS_40661956134132
* device instance $1 r0 *1 13.675,142.085 pmos_6p0
M$1 5 2 3 3 pmos_6p0 L=0.7U W=5U AS=2.2P AD=1.3P PS=10.88U PD=5.52U
* device instance $2 r0 *1 14.895,142.085 pmos_6p0
M$2 3 2 5 3 pmos_6p0 L=0.7U W=5U AS=1.3P AD=1.3P PS=5.52U PD=5.52U
* device instance $3 r0 *1 16.115,142.085 pmos_6p0
M$3 5 2 3 3 pmos_6p0 L=0.7U W=5U AS=1.3P AD=1.3P PS=5.52U PD=5.52U
* device instance $4 r0 *1 17.335,142.085 pmos_6p0
M$4 3 2 5 3 pmos_6p0 L=0.7U W=5U AS=1.3P AD=1.3P PS=5.52U PD=5.52U
* device instance $5 r0 *1 18.555,142.085 pmos_6p0
M$5 7 5 3 3 pmos_6p0 L=0.7U W=5U AS=1.3P AD=1.3P PS=5.52U PD=5.52U
* device instance $6 r0 *1 19.775,142.085 pmos_6p0
M$6 3 5 7 3 pmos_6p0 L=0.7U W=5U AS=1.3P AD=1.3P PS=5.52U PD=5.52U
* device instance $7 r0 *1 20.995,142.085 pmos_6p0
M$7 7 5 3 3 pmos_6p0 L=0.7U W=5U AS=1.3P AD=2.2P PS=5.52U PD=10.88U
* device instance $8 r0 *1 23.075,142.085 pmos_6p0
M$8 6 7 3 3 pmos_6p0 L=0.7U W=5U AS=2.2P AD=1.3P PS=10.88U PD=5.52U
* device instance $9 r0 *1 24.295,142.085 pmos_6p0
M$9 3 7 6 3 pmos_6p0 L=0.7U W=5U AS=1.3P AD=1.3P PS=5.52U PD=5.52U
* device instance $10 r0 *1 25.515,142.085 pmos_6p0
M$10 6 7 3 3 pmos_6p0 L=0.7U W=5U AS=1.3P AD=1.3P PS=5.52U PD=5.52U
* device instance $11 r0 *1 26.735,142.085 pmos_6p0
M$11 3 7 6 3 pmos_6p0 L=0.7U W=5U AS=1.3P AD=1.3P PS=5.52U PD=5.52U
* device instance $12 r0 *1 27.955,142.085 pmos_6p0
M$12 6 7 3 3 pmos_6p0 L=0.7U W=5U AS=1.3P AD=1.3P PS=5.52U PD=5.52U
* device instance $13 r0 *1 29.175,142.085 pmos_6p0
M$13 3 7 6 3 pmos_6p0 L=0.7U W=5U AS=1.3P AD=1.3P PS=5.52U PD=5.52U
* device instance $14 r0 *1 30.395,142.085 pmos_6p0
M$14 6 7 3 3 pmos_6p0 L=0.7U W=5U AS=1.3P AD=1.3P PS=5.52U PD=5.52U
* device instance $15 r0 *1 31.615,142.085 pmos_6p0
M$15 3 7 6 3 pmos_6p0 L=0.7U W=5U AS=1.3P AD=1.3P PS=5.52U PD=5.52U
* device instance $16 r0 *1 32.835,142.085 pmos_6p0
M$16 6 7 3 3 pmos_6p0 L=0.7U W=5U AS=1.3P AD=1.3P PS=5.52U PD=5.52U
* device instance $17 r0 *1 34.055,142.085 pmos_6p0
M$17 3 7 6 3 pmos_6p0 L=0.7U W=5U AS=1.3P AD=1.3P PS=5.52U PD=5.52U
* device instance $18 r0 *1 35.275,142.085 pmos_6p0
M$18 6 7 3 3 pmos_6p0 L=0.7U W=5U AS=1.3P AD=1.3P PS=5.52U PD=5.52U
* device instance $19 r0 *1 36.495,142.085 pmos_6p0
M$19 3 7 6 3 pmos_6p0 L=0.7U W=5U AS=1.3P AD=1.3P PS=5.52U PD=5.52U
* device instance $20 r0 *1 37.715,142.085 pmos_6p0
M$20 6 7 3 3 pmos_6p0 L=0.7U W=5U AS=1.3P AD=1.3P PS=5.52U PD=5.52U
* device instance $21 r0 *1 38.935,142.085 pmos_6p0
M$21 3 7 6 3 pmos_6p0 L=0.7U W=5U AS=1.3P AD=1.3P PS=5.52U PD=5.52U
* device instance $22 r0 *1 40.155,142.085 pmos_6p0
M$22 6 7 3 3 pmos_6p0 L=0.7U W=5U AS=1.3P AD=1.3P PS=5.52U PD=5.52U
* device instance $23 r0 *1 41.375,142.085 pmos_6p0
M$23 3 7 6 3 pmos_6p0 L=0.7U W=5U AS=1.3P AD=1.3P PS=5.52U PD=5.52U
* device instance $24 r0 *1 42.595,142.085 pmos_6p0
M$24 6 7 3 3 pmos_6p0 L=0.7U W=5U AS=1.3P AD=1.3P PS=5.52U PD=5.52U
* device instance $25 r0 *1 43.815,142.085 pmos_6p0
M$25 3 7 6 3 pmos_6p0 L=0.7U W=5U AS=1.3P AD=1.3P PS=5.52U PD=5.52U
* device instance $26 r0 *1 45.035,142.085 pmos_6p0
M$26 6 7 3 3 pmos_6p0 L=0.7U W=5U AS=1.3P AD=1.3P PS=5.52U PD=5.52U
* device instance $27 r0 *1 46.255,142.085 pmos_6p0
M$27 3 7 6 3 pmos_6p0 L=0.7U W=5U AS=1.3P AD=1.3P PS=5.52U PD=5.52U
* device instance $28 r0 *1 47.475,142.085 pmos_6p0
M$28 6 7 3 3 pmos_6p0 L=0.7U W=5U AS=1.3P AD=1.3P PS=5.52U PD=5.52U
* device instance $29 r0 *1 48.695,142.085 pmos_6p0
M$29 3 7 6 3 pmos_6p0 L=0.7U W=5U AS=1.3P AD=1.3P PS=5.52U PD=5.52U
* device instance $30 r0 *1 49.915,142.085 pmos_6p0
M$30 6 7 3 3 pmos_6p0 L=0.7U W=5U AS=1.3P AD=1.3P PS=5.52U PD=5.52U
* device instance $31 r0 *1 51.135,142.085 pmos_6p0
M$31 3 7 6 3 pmos_6p0 L=0.7U W=5U AS=1.3P AD=2.2P PS=5.52U PD=10.88U
* device instance $32 r0 *1 26.305,132.53 nmos_6p0
M$32 7 5 1 21 nmos_6p0 L=0.7U W=5U AS=2.2P AD=1.3P PS=10.88U PD=5.52U
* device instance $33 r0 *1 27.525,132.53 nmos_6p0
M$33 1 5 7 21 nmos_6p0 L=0.7U W=5U AS=1.3P AD=1.3P PS=5.52U PD=5.52U
* device instance $34 r0 *1 28.745,132.53 nmos_6p0
M$34 7 5 1 21 nmos_6p0 L=0.7U W=5U AS=1.3P AD=1.3P PS=5.52U PD=5.52U
* device instance $35 r0 *1 29.965,132.53 nmos_6p0
M$35 1 5 7 21 nmos_6p0 L=0.7U W=5U AS=1.3P AD=1.3P PS=5.52U PD=5.52U
* device instance $36 r0 *1 31.185,132.53 nmos_6p0
M$36 7 5 1 21 nmos_6p0 L=0.7U W=5U AS=1.3P AD=1.3P PS=5.52U PD=5.52U
* device instance $37 r0 *1 32.405,132.53 nmos_6p0
M$37 1 5 7 21 nmos_6p0 L=0.7U W=5U AS=1.3P AD=1.3P PS=5.52U PD=5.52U
* device instance $38 r0 *1 33.625,132.53 nmos_6p0
M$38 6 7 1 21 nmos_6p0 L=0.7U W=5U AS=1.3P AD=1.3P PS=5.52U PD=5.52U
* device instance $39 r0 *1 34.845,132.53 nmos_6p0
M$39 1 7 6 21 nmos_6p0 L=0.7U W=5U AS=1.3P AD=1.3P PS=5.52U PD=5.52U
* device instance $40 r0 *1 36.065,132.53 nmos_6p0
M$40 6 7 1 21 nmos_6p0 L=0.7U W=5U AS=1.3P AD=1.3P PS=5.52U PD=5.52U
* device instance $41 r0 *1 37.285,132.53 nmos_6p0
M$41 1 7 6 21 nmos_6p0 L=0.7U W=5U AS=1.3P AD=1.3P PS=5.52U PD=5.52U
* device instance $42 r0 *1 38.505,132.53 nmos_6p0
M$42 6 7 1 21 nmos_6p0 L=0.7U W=5U AS=1.3P AD=1.3P PS=5.52U PD=5.52U
* device instance $43 r0 *1 39.725,132.53 nmos_6p0
M$43 1 7 6 21 nmos_6p0 L=0.7U W=5U AS=1.3P AD=2.2P PS=5.52U PD=10.88U
.ENDS comp018green_esd_clamp_v5p0_DVDD

* cell M3_M2_CDNS_40661956134219
* pin
* pin
.SUBCKT M3_M2_CDNS_40661956134219 1 2
.ENDS M3_M2_CDNS_40661956134219

* cell M2_M1_CDNS_40661956134261
* pin
* pin
.SUBCKT M2_M1_CDNS_40661956134261 1 2
.ENDS M2_M1_CDNS_40661956134261

* cell M2_M1_CDNS_40661956134263
* pin
* pin
.SUBCKT M2_M1_CDNS_40661956134263 1 2
.ENDS M2_M1_CDNS_40661956134263

* cell M2_M1_CDNS_40661956134264
* pin
* pin
.SUBCKT M2_M1_CDNS_40661956134264 1 2
.ENDS M2_M1_CDNS_40661956134264

* cell M3_M2_CDNS_40661956134226
* pin
* pin
.SUBCKT M3_M2_CDNS_40661956134226 1 2
.ENDS M3_M2_CDNS_40661956134226

* cell M2_M1_CDNS_40661956134251
* pin
* pin
.SUBCKT M2_M1_CDNS_40661956134251 1 2
.ENDS M2_M1_CDNS_40661956134251

* cell M2_M1_CDNS_40661956134252
* pin
* pin
.SUBCKT M2_M1_CDNS_40661956134252 1 2
.ENDS M2_M1_CDNS_40661956134252

* cell M2_M1_CDNS_40661956134253
* pin
* pin
.SUBCKT M2_M1_CDNS_40661956134253 1 2
.ENDS M2_M1_CDNS_40661956134253

* cell M2_M1_CDNS_40661956134254
* pin
* pin
.SUBCKT M2_M1_CDNS_40661956134254 1 2
.ENDS M2_M1_CDNS_40661956134254

* cell M2_M1_CDNS_40661956134256
* pin
* pin
.SUBCKT M2_M1_CDNS_40661956134256 1 2
.ENDS M2_M1_CDNS_40661956134256

* cell M1_PSUB_CDNS_40661956134197
* pin
* pin
.SUBCKT M1_PSUB_CDNS_40661956134197 1 2
.ENDS M1_PSUB_CDNS_40661956134197

* cell M3_M2_CDNS_40661956134262
* pin
* pin
.SUBCKT M3_M2_CDNS_40661956134262 1 2
.ENDS M3_M2_CDNS_40661956134262

* cell M3_M2_CDNS_40661956134260
* pin
* pin
.SUBCKT M3_M2_CDNS_40661956134260 1 2
.ENDS M3_M2_CDNS_40661956134260

* cell M3_M2_CDNS_40661956134259
* pin
* pin
.SUBCKT M3_M2_CDNS_40661956134259 1 2
.ENDS M3_M2_CDNS_40661956134259

* cell M3_M2_CDNS_40661956134257
* pin
* pin
.SUBCKT M3_M2_CDNS_40661956134257 1 2
.ENDS M3_M2_CDNS_40661956134257

* cell M1_PSUB_CDNS_40661956134230
* pin
.SUBCKT M1_PSUB_CDNS_40661956134230 1
.ENDS M1_PSUB_CDNS_40661956134230

* cell M1_PSUB_CDNS_40661956134203
* pin
* pin
.SUBCKT M1_PSUB_CDNS_40661956134203 1 2
.ENDS M1_PSUB_CDNS_40661956134203

* cell M1_NWELL_CDNS_40661956134204
* pin
* pin
* pin
* pin
.SUBCKT M1_NWELL_CDNS_40661956134204 1 2 3 4
.ENDS M1_NWELL_CDNS_40661956134204

* cell M3_M2_CDNS_40661956134221
* pin
* pin
.SUBCKT M3_M2_CDNS_40661956134221 1 2
.ENDS M3_M2_CDNS_40661956134221

* cell M3_M2_CDNS_40661956134222
* pin
* pin
.SUBCKT M3_M2_CDNS_40661956134222 1 2
.ENDS M3_M2_CDNS_40661956134222

* cell M1_PSUB_CDNS_40661956134201
* pin
* pin
.SUBCKT M1_PSUB_CDNS_40661956134201 1 2
.ENDS M1_PSUB_CDNS_40661956134201

* cell M1_PSUB_CDNS_40661956134202
* pin
* pin
.SUBCKT M1_PSUB_CDNS_40661956134202 1 2
.ENDS M1_PSUB_CDNS_40661956134202

* cell M1_NWELL_CDNS_40661956134205
* pin
* pin
* pin
* pin
.SUBCKT M1_NWELL_CDNS_40661956134205 1 2 3 4
.ENDS M1_NWELL_CDNS_40661956134205

* cell M1_PSUB_CDNS_40661956134228
* pin
.SUBCKT M1_PSUB_CDNS_40661956134228 1
.ENDS M1_PSUB_CDNS_40661956134228

* cell M1_PSUB_CDNS_40661956134229
* pin
.SUBCKT M1_PSUB_CDNS_40661956134229 1
.ENDS M1_PSUB_CDNS_40661956134229

* cell comp018green_esd_clamp_v5p0_DVSS
* pin
* pin
* pin
* pin
* pin
* pin
* pin
* pin
* pin
* pin
* pin
* pin
* pin
* pin gf180mcu_gnd
.SUBCKT comp018green_esd_clamp_v5p0_DVSS 1 3 8 9 11 12 13 14 15 16 17 19 20 21
* net 21 gf180mcu_gnd
* cell instance $1 r0 *1 0,0
X$1 6 3 1 8 24 9 17 16 15 14 13 11 12 25 19 20 21 nmos_clamp_20_50_4_DVSS
* cell instance $2 r0 *1 14.89,128.765
X$2 1 12 M2_M1_CDNS_40661956134265
* cell instance $3 m90 *1 49.92,128.765
X$3 1 17 M2_M1_CDNS_40661956134265
* cell instance $4 r0 *1 25.64,137.29
X$4 1 13 M2_M1_CDNS_40661956134238
* cell instance $5 r0 *1 25.67,137.31
X$5 1 4 M1_PSUB_CDNS_40661956134243
* cell instance $6 r0 *1 25.64,128.765
X$6 1 13 M2_M1_CDNS_40661956134238
* cell instance $7 r0 *1 42.025,128.765
X$7 1 15 M2_M1_CDNS_40661956134233
* cell instance $8 m90 *1 53.3,132.785
X$8 1 17 M2_M1_CDNS_40661956134242
* cell instance $9 m0 *1 53.32,132.61
X$9 1 4 M1_PSUB_CDNS_40661956134125
* cell instance $10 r0 *1 11.51,132.785
X$10 1 12 M2_M1_CDNS_40661956134242
* cell instance $11 m0 *1 11.49,132.61
X$11 1 4 M1_PSUB_CDNS_40661956134125
* cell instance $12 r0 *1 42.785,137.31
X$12 1 4 M1_PSUB_CDNS_40661956134244
* cell instance $13 r0 *1 39.17,137.29
X$13 1 15 M2_M1_CDNS_40661956134238
* cell instance $14 r0 *1 48.65,137.29
X$14 1 17 M2_M1_CDNS_40661956134267
* cell instance $15 r0 *1 37.89,128.765
X$15 1 15 M2_M1_CDNS_40661956134245
* cell instance $16 r0 *1 35.445,128.765
X$16 1 15 M2_M1_CDNS_40661956134245
* cell instance $17 r0 *1 20.645,130.03
X$17 1 5 2 21 nmos_6p0_CDNS_406619561347
* cell instance $18 r0 *1 33.275,130.03
X$18 23 1 6 1 6 1 6 1 7 7 7 7 7 7 nmos_6p0_CDNS_406619561346
* cell instance $19 r0 *1 25.955,130.03
X$19 23 1 7 1 7 1 7 1 5 5 5 5 5 5 nmos_6p0_CDNS_406619561346
* cell instance $20 r0 *1 13.79,208.275
X$20 1 12 M2_M1_CDNS_40661956134255
* cell instance $21 m0 *1 -1.78,232.535
X$21 3 2 1 21 comp018green_esd_rc_v5p0
* cell instance $22 r0 *1 13.79,147.855
X$22 1 12 M2_M1_CDNS_40661956134255
* cell instance $23 r0 *1 13.79,178.31
X$23 1 12 M2_M1_CDNS_40661956134266
* cell instance $24 r0 *1 25.64,208.275
X$24 1 13 M2_M1_CDNS_40661956134255
* cell instance $25 r0 *1 25.64,147.855
X$25 1 13 M2_M1_CDNS_40661956134255
* cell instance $26 r0 *1 25.64,178.31
X$26 1 13 M2_M1_CDNS_40661956134266
* cell instance $27 r0 *1 39.17,208.275
X$27 1 15 M2_M1_CDNS_40661956134255
* cell instance $28 r0 *1 39.17,147.855
X$28 1 15 M2_M1_CDNS_40661956134255
* cell instance $29 r0 *1 39.17,178.31
X$29 1 15 M2_M1_CDNS_40661956134266
* cell instance $30 r0 *1 51.02,147.855
X$30 1 17 M2_M1_CDNS_40661956134255
* cell instance $31 r0 *1 51.02,208.275
X$31 1 17 M2_M1_CDNS_40661956134255
* cell instance $32 r0 *1 51.02,178.31
X$32 1 17 M2_M1_CDNS_40661956134266
* cell instance $33 r0 *1 20.71,135.54
X$33 2 M1_POLY2_CDNS_40661956134128
* cell instance $34 r0 *1 15.505,138.435
X$34 2 M1_POLY2_CDNS_40661956134127
* cell instance $35 r0 *1 13.325,139.585
X$35 22 5 3 5 3 3 2 2 2 2 18 3 pmos_6p0_CDNS_406619561344
* cell instance $36 m90 *1 19.715,145.805
X$36 3 11 M2_M1_CDNS_40661956134237
* cell instance $37 r0 *1 32.405,145.825
X$37 3 10 18 3 M1_NWELL_CDNS_40661956134129
* cell instance $38 m90 *1 32.405,145.805
X$38 3 14 M2_M1_CDNS_40661956134232
* cell instance $39 m90 *1 45.095,145.805
X$39 3 16 M2_M1_CDNS_40661956134237
* cell instance $40 m90 *1 56.945,145.805
X$40 3 19 M2_M1_CDNS_40661956134237
* cell instance $41 r0 *1 7.865,145.805
X$41 3 9 M2_M1_CDNS_40661956134237
* cell instance $42 r0 *1 53.32,142.235
X$42 3 10 18 3 M1_NWELL_CDNS_40661956134133
* cell instance $43 r0 *1 11.49,142.235
X$43 3 10 18 3 M1_NWELL_CDNS_40661956134133
* cell instance $44 r0 *1 22.725,139.585
X$44 3 6 3 6 3 6 3 6 3 6 3 6 3 6 3 6 3 6 3 6 3 6 3 6 3 7 7 7 7 7 7 7 7 7 7 7 7
+ 7 7 7 7 7 7 7 7 7 7 7 7 18 3 pmos_6p0_CDNS_406619561342
* cell instance $45 r0 *1 18.205,139.585
X$45 22 7 3 3 7 5 5 5 18 3 pmos_6p0_CDNS_406619561343
* cell instance $46 r0 *1 7.865,210.74
X$46 3 9 M2_M1_CDNS_40661956134218
* cell instance $47 r0 *1 7.865,229.44
X$47 3 9 M2_M1_CDNS_40661956134218
* cell instance $48 r0 *1 19.715,210.74
X$48 3 11 M2_M1_CDNS_40661956134218
* cell instance $49 r0 *1 19.715,229.44
X$49 3 11 M2_M1_CDNS_40661956134218
* cell instance $50 r0 *1 32.405,210.74
X$50 3 14 M2_M1_CDNS_40661956134217
* cell instance $51 r0 *1 32.405,229.44
X$51 3 14 M2_M1_CDNS_40661956134217
* cell instance $52 r0 *1 45.095,210.74
X$52 3 16 M2_M1_CDNS_40661956134218
* cell instance $53 r0 *1 45.095,229.44
X$53 3 16 M2_M1_CDNS_40661956134218
* cell instance $54 r0 *1 56.945,210.74
X$54 3 19 M2_M1_CDNS_40661956134218
* cell instance $55 r0 *1 56.945,229.44
X$55 3 19 M2_M1_CDNS_40661956134218
* cell instance $56 r0 *1 29.355,136.18
X$56 5 M1_POLY2_CDNS_40661956134131
* cell instance $57 r0 *1 19.775,138.435
X$57 5 M1_POLY2_CDNS_40661956134130
* cell instance $58 r0 *1 6.565,127.585
X$58 6 24 M2_M1_CDNS_40661956134126
* cell instance $59 r0 *1 58.245,127.585
X$59 6 25 M2_M1_CDNS_40661956134126
* cell instance $60 r0 *1 36.675,136.18
X$60 7 M1_POLY2_CDNS_40661956134131
* cell instance $61 r0 *1 37.105,138.435
X$61 7 M1_POLY2_CDNS_40661956134132
* device instance $1 r0 *1 13.675,142.085 pmos_6p0
M$1 5 2 3 3 pmos_6p0 L=0.7U W=5U AS=2.2P AD=1.3P PS=10.88U PD=5.52U
* device instance $2 r0 *1 14.895,142.085 pmos_6p0
M$2 3 2 5 3 pmos_6p0 L=0.7U W=5U AS=1.3P AD=1.3P PS=5.52U PD=5.52U
* device instance $3 r0 *1 16.115,142.085 pmos_6p0
M$3 5 2 3 3 pmos_6p0 L=0.7U W=5U AS=1.3P AD=1.3P PS=5.52U PD=5.52U
* device instance $4 r0 *1 17.335,142.085 pmos_6p0
M$4 3 2 5 3 pmos_6p0 L=0.7U W=5U AS=1.3P AD=1.3P PS=5.52U PD=5.52U
* device instance $5 r0 *1 18.555,142.085 pmos_6p0
M$5 7 5 3 3 pmos_6p0 L=0.7U W=5U AS=1.3P AD=1.3P PS=5.52U PD=5.52U
* device instance $6 r0 *1 19.775,142.085 pmos_6p0
M$6 3 5 7 3 pmos_6p0 L=0.7U W=5U AS=1.3P AD=1.3P PS=5.52U PD=5.52U
* device instance $7 r0 *1 20.995,142.085 pmos_6p0
M$7 7 5 3 3 pmos_6p0 L=0.7U W=5U AS=1.3P AD=2.2P PS=5.52U PD=10.88U
* device instance $8 r0 *1 23.075,142.085 pmos_6p0
M$8 6 7 3 3 pmos_6p0 L=0.7U W=5U AS=2.2P AD=1.3P PS=10.88U PD=5.52U
* device instance $9 r0 *1 24.295,142.085 pmos_6p0
M$9 3 7 6 3 pmos_6p0 L=0.7U W=5U AS=1.3P AD=1.3P PS=5.52U PD=5.52U
* device instance $10 r0 *1 25.515,142.085 pmos_6p0
M$10 6 7 3 3 pmos_6p0 L=0.7U W=5U AS=1.3P AD=1.3P PS=5.52U PD=5.52U
* device instance $11 r0 *1 26.735,142.085 pmos_6p0
M$11 3 7 6 3 pmos_6p0 L=0.7U W=5U AS=1.3P AD=1.3P PS=5.52U PD=5.52U
* device instance $12 r0 *1 27.955,142.085 pmos_6p0
M$12 6 7 3 3 pmos_6p0 L=0.7U W=5U AS=1.3P AD=1.3P PS=5.52U PD=5.52U
* device instance $13 r0 *1 29.175,142.085 pmos_6p0
M$13 3 7 6 3 pmos_6p0 L=0.7U W=5U AS=1.3P AD=1.3P PS=5.52U PD=5.52U
* device instance $14 r0 *1 30.395,142.085 pmos_6p0
M$14 6 7 3 3 pmos_6p0 L=0.7U W=5U AS=1.3P AD=1.3P PS=5.52U PD=5.52U
* device instance $15 r0 *1 31.615,142.085 pmos_6p0
M$15 3 7 6 3 pmos_6p0 L=0.7U W=5U AS=1.3P AD=1.3P PS=5.52U PD=5.52U
* device instance $16 r0 *1 32.835,142.085 pmos_6p0
M$16 6 7 3 3 pmos_6p0 L=0.7U W=5U AS=1.3P AD=1.3P PS=5.52U PD=5.52U
* device instance $17 r0 *1 34.055,142.085 pmos_6p0
M$17 3 7 6 3 pmos_6p0 L=0.7U W=5U AS=1.3P AD=1.3P PS=5.52U PD=5.52U
* device instance $18 r0 *1 35.275,142.085 pmos_6p0
M$18 6 7 3 3 pmos_6p0 L=0.7U W=5U AS=1.3P AD=1.3P PS=5.52U PD=5.52U
* device instance $19 r0 *1 36.495,142.085 pmos_6p0
M$19 3 7 6 3 pmos_6p0 L=0.7U W=5U AS=1.3P AD=1.3P PS=5.52U PD=5.52U
* device instance $20 r0 *1 37.715,142.085 pmos_6p0
M$20 6 7 3 3 pmos_6p0 L=0.7U W=5U AS=1.3P AD=1.3P PS=5.52U PD=5.52U
* device instance $21 r0 *1 38.935,142.085 pmos_6p0
M$21 3 7 6 3 pmos_6p0 L=0.7U W=5U AS=1.3P AD=1.3P PS=5.52U PD=5.52U
* device instance $22 r0 *1 40.155,142.085 pmos_6p0
M$22 6 7 3 3 pmos_6p0 L=0.7U W=5U AS=1.3P AD=1.3P PS=5.52U PD=5.52U
* device instance $23 r0 *1 41.375,142.085 pmos_6p0
M$23 3 7 6 3 pmos_6p0 L=0.7U W=5U AS=1.3P AD=1.3P PS=5.52U PD=5.52U
* device instance $24 r0 *1 42.595,142.085 pmos_6p0
M$24 6 7 3 3 pmos_6p0 L=0.7U W=5U AS=1.3P AD=1.3P PS=5.52U PD=5.52U
* device instance $25 r0 *1 43.815,142.085 pmos_6p0
M$25 3 7 6 3 pmos_6p0 L=0.7U W=5U AS=1.3P AD=1.3P PS=5.52U PD=5.52U
* device instance $26 r0 *1 45.035,142.085 pmos_6p0
M$26 6 7 3 3 pmos_6p0 L=0.7U W=5U AS=1.3P AD=1.3P PS=5.52U PD=5.52U
* device instance $27 r0 *1 46.255,142.085 pmos_6p0
M$27 3 7 6 3 pmos_6p0 L=0.7U W=5U AS=1.3P AD=1.3P PS=5.52U PD=5.52U
* device instance $28 r0 *1 47.475,142.085 pmos_6p0
M$28 6 7 3 3 pmos_6p0 L=0.7U W=5U AS=1.3P AD=1.3P PS=5.52U PD=5.52U
* device instance $29 r0 *1 48.695,142.085 pmos_6p0
M$29 3 7 6 3 pmos_6p0 L=0.7U W=5U AS=1.3P AD=1.3P PS=5.52U PD=5.52U
* device instance $30 r0 *1 49.915,142.085 pmos_6p0
M$30 6 7 3 3 pmos_6p0 L=0.7U W=5U AS=1.3P AD=1.3P PS=5.52U PD=5.52U
* device instance $31 r0 *1 51.135,142.085 pmos_6p0
M$31 3 7 6 3 pmos_6p0 L=0.7U W=5U AS=1.3P AD=2.2P PS=5.52U PD=10.88U
* device instance $32 r0 *1 26.305,132.53 nmos_6p0
M$32 7 5 1 21 nmos_6p0 L=0.7U W=5U AS=2.2P AD=1.3P PS=10.88U PD=5.52U
* device instance $33 r0 *1 27.525,132.53 nmos_6p0
M$33 1 5 7 21 nmos_6p0 L=0.7U W=5U AS=1.3P AD=1.3P PS=5.52U PD=5.52U
* device instance $34 r0 *1 28.745,132.53 nmos_6p0
M$34 7 5 1 21 nmos_6p0 L=0.7U W=5U AS=1.3P AD=1.3P PS=5.52U PD=5.52U
* device instance $35 r0 *1 29.965,132.53 nmos_6p0
M$35 1 5 7 21 nmos_6p0 L=0.7U W=5U AS=1.3P AD=1.3P PS=5.52U PD=5.52U
* device instance $36 r0 *1 31.185,132.53 nmos_6p0
M$36 7 5 1 21 nmos_6p0 L=0.7U W=5U AS=1.3P AD=1.3P PS=5.52U PD=5.52U
* device instance $37 r0 *1 32.405,132.53 nmos_6p0
M$37 1 5 7 21 nmos_6p0 L=0.7U W=5U AS=1.3P AD=1.3P PS=5.52U PD=5.52U
* device instance $38 r0 *1 33.625,132.53 nmos_6p0
M$38 6 7 1 21 nmos_6p0 L=0.7U W=5U AS=1.3P AD=1.3P PS=5.52U PD=5.52U
* device instance $39 r0 *1 34.845,132.53 nmos_6p0
M$39 1 7 6 21 nmos_6p0 L=0.7U W=5U AS=1.3P AD=1.3P PS=5.52U PD=5.52U
* device instance $40 r0 *1 36.065,132.53 nmos_6p0
M$40 6 7 1 21 nmos_6p0 L=0.7U W=5U AS=1.3P AD=1.3P PS=5.52U PD=5.52U
* device instance $41 r0 *1 37.285,132.53 nmos_6p0
M$41 1 7 6 21 nmos_6p0 L=0.7U W=5U AS=1.3P AD=1.3P PS=5.52U PD=5.52U
* device instance $42 r0 *1 38.505,132.53 nmos_6p0
M$42 6 7 1 21 nmos_6p0 L=0.7U W=5U AS=1.3P AD=1.3P PS=5.52U PD=5.52U
* device instance $43 r0 *1 39.725,132.53 nmos_6p0
M$43 1 7 6 21 nmos_6p0 L=0.7U W=5U AS=1.3P AD=2.2P PS=5.52U PD=10.88U
.ENDS comp018green_esd_clamp_v5p0_DVSS

* cell M1_PSUB_CDNS_406619561348
* pin
* pin
.SUBCKT M1_PSUB_CDNS_406619561348 1 2
.ENDS M1_PSUB_CDNS_406619561348

* cell moscap_corner_1
* pin
* pin
* pin
* pin
.SUBCKT moscap_corner_1 1 2 3 4
* cell instance $1 r90 *1 38.74,61.09
X$1 2 1 M1_PSUB_CDNS_4066195613410
* cell instance $2 r90 *1 38.725,30.635
X$2 2 1 M1_PSUB_CDNS_4066195613410
* cell instance $3 r90 *1 38.765,0.67
X$3 2 1 M1_PSUB_CDNS_4066195613410
* cell instance $4 r0 *1 52.37,30.88
X$4 2 1 M1_PSUB_CDNS_406619561349
* cell instance $5 m0 *1 27.595,28.105
X$5 2 3 nmoscap_6p0_CDNS_406619561340
* cell instance $6 m0 *1 39.775,28.105
X$6 2 3 nmoscap_6p0_CDNS_406619561340
* cell instance $7 r0 *1 27.595,33.165
X$7 2 4 nmoscap_6p0_CDNS_406619561340
* cell instance $8 r0 *1 39.775,33.165
X$8 2 4 nmoscap_6p0_CDNS_406619561340
.ENDS moscap_corner_1

* cell moscap_corner
* pin
* pin VMINUS
* pin
* pin
.SUBCKT moscap_corner 1 2 3 4
* net 2 VMINUS
* cell instance $1 r90 *1 26.52,61.09
X$1 2 1 M1_PSUB_CDNS_4066195613411
* cell instance $2 r90 *1 26.52,30.635
X$2 2 1 M1_PSUB_CDNS_4066195613411
* cell instance $3 r90 *1 26.52,0.67
X$3 2 1 M1_PSUB_CDNS_4066195613411
* cell instance $4 r0 *1 52.37,30.88
X$4 2 1 M1_PSUB_CDNS_406619561349
* cell instance $5 m0 *1 3.235,28.105
X$5 2 3 nmoscap_6p0_CDNS_406619561340
* cell instance $6 m0 *1 15.415,28.105
X$6 2 3 nmoscap_6p0_CDNS_406619561340
* cell instance $7 m0 *1 27.595,28.105
X$7 2 3 nmoscap_6p0_CDNS_406619561340
* cell instance $8 m0 *1 39.775,28.105
X$8 2 3 nmoscap_6p0_CDNS_406619561340
* cell instance $9 r0 *1 3.235,33.165
X$9 2 4 nmoscap_6p0_CDNS_406619561340
* cell instance $10 r0 *1 15.415,33.165
X$10 2 4 nmoscap_6p0_CDNS_406619561340
* cell instance $11 r0 *1 27.595,33.165
X$11 2 4 nmoscap_6p0_CDNS_406619561340
* cell instance $12 r0 *1 39.775,33.165
X$12 2 4 nmoscap_6p0_CDNS_406619561340
.ENDS moscap_corner

* cell moscap_corner_2
* pin VMINUS
* pin
* pin
* pin
.SUBCKT moscap_corner_2 1 2 3 4
* net 1 VMINUS
* cell instance $1 r90 *1 39.14,0.67
X$1 1 2 M1_PSUB_CDNS_4066195613412
* cell instance $2 r0 *1 25.215,15.07
X$2 1 2 M1_PSUB_CDNS_4066195613413
* cell instance $3 r90 *1 26.52,61.09
X$3 1 2 M1_PSUB_CDNS_4066195613411
* cell instance $4 r90 *1 26.52,30.635
X$4 1 2 M1_PSUB_CDNS_4066195613411
* cell instance $5 r0 *1 52.37,30.88
X$5 1 2 M1_PSUB_CDNS_406619561349
* cell instance $6 m0 *1 27.595,28.105
X$6 1 3 nmoscap_6p0_CDNS_406619561340
* cell instance $7 m0 *1 39.775,28.105
X$7 1 3 nmoscap_6p0_CDNS_406619561340
* cell instance $8 r0 *1 3.235,33.165
X$8 1 4 nmoscap_6p0_CDNS_406619561340
* cell instance $9 r0 *1 15.415,33.165
X$9 1 4 nmoscap_6p0_CDNS_406619561340
* cell instance $10 r0 *1 27.595,33.165
X$10 1 4 nmoscap_6p0_CDNS_406619561340
* cell instance $11 r0 *1 39.775,33.165
X$11 1 4 nmoscap_6p0_CDNS_406619561340
.ENDS moscap_corner_2

* cell moscap_corner_3
* pin VMINUS
* pin
* pin
* pin
.SUBCKT moscap_corner_3 1 2 3 4
* net 1 VMINUS
* cell instance $1 r90 *1 32.085,61.09
X$1 1 2 M1_PSUB_CDNS_4066195613414
* cell instance $2 r90 *1 44.73,0.67
X$2 1 2 M1_PSUB_CDNS_4066195613415
* cell instance $3 r0 *1 36.835,15.07
X$3 1 2 M1_PSUB_CDNS_4066195613416
* cell instance $4 r90 *1 32.195,30.635
X$4 1 2 M1_PSUB_CDNS_4066195613417
* cell instance $5 r0 *1 52.37,30.88
X$5 1 2 M1_PSUB_CDNS_406619561349
* cell instance $6 m0 *1 39.775,28.105
X$6 1 3 nmoscap_6p0_CDNS_406619561340
* cell instance $7 r0 *1 15.415,33.165
X$7 1 4 nmoscap_6p0_CDNS_406619561340
* cell instance $8 r0 *1 27.595,33.165
X$8 1 4 nmoscap_6p0_CDNS_406619561340
* cell instance $9 r0 *1 39.775,33.165
X$9 1 4 nmoscap_6p0_CDNS_406619561340
.ENDS moscap_corner_3

* cell ESD_CLAMP_COR
* pin gf180mcu_gnd
* pin
* pin
* pin
* pin
* pin
* pin
* pin
* pin
* pin
* pin
.SUBCKT ESD_CLAMP_COR 1 2 3 4 5 6 7 8 17 18 27
* net 1 gf180mcu_gnd
* cell instance $1 m45 *1 0.255,217.825
X$1 18 17 1 16 15 14 13 12 11 10 9 comp018green_esd_clamp_v5p0_2
* cell instance $2 r0 *1 217.82,0.255
X$2 7 27 1 26 25 24 23 22 21 20 19 comp018green_esd_clamp_v5p0_1
* cell instance $3 m45 *1 2.54,212.785
X$3 10 9 18 17 10 18 10 10 18 18 10 18 10 18 10 18 9 9 9 10 10 10 10 9 9 9 9 10
+ 10 10 17 17 17 18 18 18 18 17 17 17 17 18 18 18 9 9 17 17 9 9 9 9 9 9 9 9 9
+ 17 17 17 17 17 17 17 17 17 15 13 13 13 15 13 15 15 12 12 12 10 10 10 12 15 12
+ 17 18 18 18 17 18 17 17 17 17 17 18 18 18 17 17 17 16 16 14 14 16 14 14 14 16
+ 11 11 11 9 9 9 9 11 18 18 17 17 18 17 17 17 18 18 18 18 17 17 17 17 18 12 12
+ 12 17 17 17 9 9 17 17 12 12 12 12 11 11 11 12 12 12 11 12 12 12 12 12 12 12
+ 12 12 12 12 12 12 12 12 9 11 12 12 12 12 11 12 11 12 12 12 12 11 12 12 12 12
+ 12 12 12 12 17 17 17 17 18 18 18 17 17 17 18 17 17 17 17 17 17 17 17 17 17 17
+ 17 17 17 17 17 18 17 17 17 17 18 17 18 17 17 17 17 18 17 17 17 17 17 17 17 17
+ 9 17 9 17 18 18 18 17 17 17 17 17 18 18 17 18 17 18 18 17 17 17 17 18 17 18
+ 17 16 16 11 14 14 14 14 14 16 11 9 10 12 10 13 12 15 15 15 13 15 13 15 3 2
+ power_via_cor_5
* cell instance $4 r0 *1 212.78,2.54
X$4 25 26 23 27 7 7 24 27 22 27 21 7 20 22 19 7 27 27 22 22 22 27 27 27 22 20
+ 20 20 20 19 19 19 19 19 19 19 22 22 20 20 20 22 20 20 20 22 22 22 22 20 20 20
+ 27 7 7 7 7 27 27 27 27 27 27 27 27 27 7 7 7 27 7 7 7 27 27 27 27 7 7 7 22 27
+ 22 27 7 27 7 27 7 26 24 21 25 23 5 4 power_via_cor_3
* cell instance $5 r0 *1 -6.5,283.255
X$5 8 6 27 7 top_routing_cor
.ENDS ESD_CLAMP_COR

* cell moscap_routing
* pin
* pin
* pin
* pin
* pin
* pin
* pin
* pin
* pin
* pin
* pin
* pin
* pin
* pin
* pin
* pin
* pin
* pin
* pin
* pin
* pin
* pin
* pin
* pin
* pin
* pin
* pin
* pin
* pin
* pin
* pin
* pin
* pin
* pin
* pin
* pin
* pin
* pin
* pin
* pin
* pin
* pin
* pin
* pin
* pin
* pin
* pin
* pin
* pin
* pin
* pin
* pin
* pin
* pin
* pin
* pin
* pin
* pin
* pin
* pin
* pin
* pin
* pin
* pin
* pin
* pin
* pin
* pin
* pin
* pin
* pin
* pin
* pin
* pin
.SUBCKT moscap_routing 2 4 6 7 8 11 13 14 17 18 20 21 22 23 24 25 26 28 29 31
+ 33 35 39 40 41 43 45 47 49 52 53 55 59 61 64 65 68 69 75 76 77 78 93 95 102
+ 103 104 105 167 168 175 176 177 178 179 183 184 185 187 189 207 208 209 210
+ 211 212 213 214 215 216 217 218 219 220
* cell instance $1 r0 *1 -80.03,-273.665
X$1 2 1 M1_PSUB_CDNS_4066195613434
* cell instance $2 r0 *1 -80.96,-271.805
X$2 2 1 M1_PSUB_CDNS_4066195613445
* cell instance $3 r0 *1 -80.65,-272.425
X$3 2 1 M1_PSUB_CDNS_4066195613446
* cell instance $4 r0 *1 -80.34,-273.045
X$4 2 1 M1_PSUB_CDNS_4066195613447
* cell instance $5 r0 *1 -83.13,-267.465
X$5 2 1 M1_PSUB_CDNS_4066195613438
* cell instance $6 r0 *1 -82.82,-268.085
X$6 2 1 M1_PSUB_CDNS_4066195613439
* cell instance $7 r0 *1 -82.51,-268.705
X$7 2 1 M1_PSUB_CDNS_4066195613440
* cell instance $8 r0 *1 -82.2,-269.325
X$8 2 1 M1_PSUB_CDNS_4066195613441
* cell instance $9 r0 *1 -81.89,-269.945
X$9 2 1 M1_PSUB_CDNS_4066195613442
* cell instance $10 r0 *1 -81.58,-270.565
X$10 2 1 M1_PSUB_CDNS_4066195613443
* cell instance $11 r0 *1 -81.27,-271.185
X$11 2 1 M1_PSUB_CDNS_4066195613444
* cell instance $12 r0 *1 -84.37,-264.985
X$12 2 1 M1_PSUB_CDNS_4066195613433
* cell instance $13 r0 *1 -84.06,-265.605
X$13 2 1 M1_PSUB_CDNS_4066195613435
* cell instance $14 r0 *1 -83.75,-266.225
X$14 2 1 M1_PSUB_CDNS_4066195613436
* cell instance $15 r0 *1 -83.44,-266.845
X$15 2 1 M1_PSUB_CDNS_4066195613437
* cell instance $16 r0 *1 -92.625,-259.83
X$16 2 3 M1_PSUB_CDNS_4066195613444
* cell instance $17 r0 *1 -92.935,-259.21
X$17 2 3 M1_PSUB_CDNS_4066195613443
* cell instance $18 r0 *1 -93.245,-258.59
X$18 2 3 M1_PSUB_CDNS_4066195613442
* cell instance $19 r0 *1 -93.555,-257.97
X$19 2 3 M1_PSUB_CDNS_4066195613441
* cell instance $20 r0 *1 -93.865,-257.35
X$20 2 3 M1_PSUB_CDNS_4066195613440
* cell instance $21 r0 *1 -94.175,-256.73
X$21 2 3 M1_PSUB_CDNS_4066195613439
* cell instance $22 r0 *1 -94.485,-256.11
X$22 2 3 M1_PSUB_CDNS_4066195613438
* cell instance $23 r0 *1 -91.695,-261.69
X$23 2 3 M1_PSUB_CDNS_4066195613447
* cell instance $24 r0 *1 -92.005,-261.07
X$24 2 3 M1_PSUB_CDNS_4066195613446
* cell instance $25 r0 *1 -92.315,-260.45
X$25 2 3 M1_PSUB_CDNS_4066195613445
* cell instance $26 r0 *1 -91.385,-262.31
X$26 2 3 M1_PSUB_CDNS_4066195613434
* cell instance $27 r0 *1 -95.105,-254.87
X$27 2 3 M1_PSUB_CDNS_4066195613436
* cell instance $28 r0 *1 -95.415,-254.25
X$28 2 3 M1_PSUB_CDNS_4066195613435
* cell instance $29 r0 *1 -95.725,-253.63
X$29 2 3 M1_PSUB_CDNS_4066195613433
* cell instance $30 r0 *1 -94.795,-255.49
X$30 2 3 M1_PSUB_CDNS_4066195613437
* cell instance $31 r0 *1 -45.87,-268.96
X$31 2 221 M2_M1_CDNS_40661956134110
* cell instance $32 r0 *1 -47.34,-270.46
X$32 2 M1_PSUB_CDNS_4066195613418
* cell instance $33 r0 *1 -45.87,-268.96
X$33 2 221 M3_M2_CDNS_40661956134111
* cell instance $34 r0 *1 -81.405,-260.315
X$34 4 5 M2_M1_CDNS_4066195613470
* cell instance $35 r0 *1 -92.45,-203.825
X$35 4 5 M2_M1_CDNS_4066195613467
* cell instance $36 r0 *1 -46.07,-203.825
X$36 4 5 M2_M1_CDNS_4066195613468
* cell instance $37 r0 *1 -71.495,-203.95
X$37 4 5 M3_M2_CDNS_4066195613474
* cell instance $38 r0 *1 -46.07,-260.315
X$38 4 5 M2_M1_CDNS_4066195613468
* cell instance $39 r0 *1 -94.575,-247.89
X$39 7 6 M1_PSUB_CDNS_4066195613453
* cell instance $40 r0 *1 -99.845,-237.625
X$40 8 6 M1_PSUB_CDNS_4066195613452
* cell instance $41 r0 *1 -114.53,-235.215
X$41 8 6 M1_PSUB_CDNS_4066195613437
* cell instance $42 r0 *1 -104.01,-245.42
X$42 7 6 M1_PSUB_CDNS_4066195613437
* cell instance $43 r0 *1 -114.84,-234.595
X$43 8 6 M1_PSUB_CDNS_4066195613436
* cell instance $44 r0 *1 -104.32,-244.8
X$44 7 6 M1_PSUB_CDNS_4066195613436
* cell instance $45 r0 *1 -115.15,-233.975
X$45 8 6 M1_PSUB_CDNS_4066195613435
* cell instance $46 r0 *1 -104.63,-244.18
X$46 7 6 M1_PSUB_CDNS_4066195613435
* cell instance $47 r0 *1 -104.94,-243.56
X$47 7 6 M1_PSUB_CDNS_4066195613433
* cell instance $48 r0 *1 -115.46,-233.355
X$48 105 6 M1_PSUB_CDNS_4066195613433
* cell instance $49 r0 *1 -101.84,-249.76
X$49 7 6 M1_PSUB_CDNS_4066195613444
* cell instance $50 r0 *1 -112.36,-239.555
X$50 8 6 M1_PSUB_CDNS_4066195613444
* cell instance $51 r0 *1 -102.15,-249.14
X$51 7 6 M1_PSUB_CDNS_4066195613443
* cell instance $52 r0 *1 -112.67,-238.935
X$52 8 6 M1_PSUB_CDNS_4066195613443
* cell instance $53 r0 *1 -102.46,-248.52
X$53 7 6 M1_PSUB_CDNS_4066195613442
* cell instance $54 r0 *1 -112.98,-238.315
X$54 8 6 M1_PSUB_CDNS_4066195613442
* cell instance $55 r0 *1 -113.29,-237.695
X$55 8 6 M1_PSUB_CDNS_4066195613441
* cell instance $56 r0 *1 -102.77,-247.9
X$56 7 6 M1_PSUB_CDNS_4066195613441
* cell instance $57 r0 *1 -113.6,-237.075
X$57 8 6 M1_PSUB_CDNS_4066195613440
* cell instance $58 r0 *1 -103.08,-247.28
X$58 7 6 M1_PSUB_CDNS_4066195613440
* cell instance $59 r0 *1 -103.39,-246.66
X$59 7 6 M1_PSUB_CDNS_4066195613439
* cell instance $60 r0 *1 -113.91,-236.455
X$60 8 6 M1_PSUB_CDNS_4066195613439
* cell instance $61 r0 *1 -114.22,-235.835
X$61 8 6 M1_PSUB_CDNS_4066195613438
* cell instance $62 r0 *1 -103.7,-246.04
X$62 7 6 M1_PSUB_CDNS_4066195613438
* cell instance $63 r0 *1 -100.91,-251.62
X$63 7 6 M1_PSUB_CDNS_4066195613447
* cell instance $64 r0 *1 -111.43,-241.415
X$64 8 6 M1_PSUB_CDNS_4066195613447
* cell instance $65 r0 *1 -111.74,-240.795
X$65 8 6 M1_PSUB_CDNS_4066195613446
* cell instance $66 r0 *1 -101.22,-251
X$66 7 6 M1_PSUB_CDNS_4066195613446
* cell instance $67 r0 *1 -101.53,-250.38
X$67 7 6 M1_PSUB_CDNS_4066195613445
* cell instance $68 r0 *1 -112.05,-240.175
X$68 8 6 M1_PSUB_CDNS_4066195613445
* cell instance $69 r0 *1 -100.6,-252.24
X$69 7 6 M1_PSUB_CDNS_4066195613434
* cell instance $70 r0 *1 -111.12,-242.035
X$70 8 6 M1_PSUB_CDNS_4066195613434
* cell instance $71 r0 *1 -98.635,-237.095
X$71 8 190 M2_M1_CDNS_4066195613480
* cell instance $72 r0 *1 -98.635,-237.095
X$72 8 190 M3_M2_CDNS_4066195613481
* cell instance $73 r0 *1 -117.705,-227.215
X$73 11 9 M1_PSUB_CDNS_4066195613456
* cell instance $74 r0 *1 -125.54,-224.745
X$74 11 9 M1_PSUB_CDNS_4066195613437
* cell instance $75 r0 *1 -125.85,-224.125
X$75 11 9 M1_PSUB_CDNS_4066195613436
* cell instance $76 r0 *1 -126.16,-223.505
X$76 11 9 M1_PSUB_CDNS_4066195613435
* cell instance $77 r0 *1 -126.47,-222.885
X$77 11 9 M1_PSUB_CDNS_4066195613433
* cell instance $78 r0 *1 -123.37,-229.085
X$78 11 9 M1_PSUB_CDNS_4066195613444
* cell instance $79 r0 *1 -123.68,-228.465
X$79 11 9 M1_PSUB_CDNS_4066195613443
* cell instance $80 r0 *1 -123.99,-227.845
X$80 11 9 M1_PSUB_CDNS_4066195613442
* cell instance $81 r0 *1 -124.3,-227.225
X$81 11 9 M1_PSUB_CDNS_4066195613441
* cell instance $82 r0 *1 -124.61,-226.605
X$82 11 9 M1_PSUB_CDNS_4066195613440
* cell instance $83 r0 *1 -124.92,-225.985
X$83 11 9 M1_PSUB_CDNS_4066195613439
* cell instance $84 r0 *1 -125.23,-225.365
X$84 11 9 M1_PSUB_CDNS_4066195613438
* cell instance $85 r0 *1 -122.44,-230.945
X$85 11 9 M1_PSUB_CDNS_4066195613447
* cell instance $86 r0 *1 -122.75,-230.325
X$86 11 9 M1_PSUB_CDNS_4066195613446
* cell instance $87 r0 *1 -123.06,-229.705
X$87 11 9 M1_PSUB_CDNS_4066195613445
* cell instance $88 r0 *1 -122.13,-231.565
X$88 11 9 M1_PSUB_CDNS_4066195613434
* cell instance $89 r0 *1 -134.755,-214.675
X$89 13 10 M1_PSUB_CDNS_4066195613437
* cell instance $90 r0 *1 -135.065,-214.055
X$90 13 10 M1_PSUB_CDNS_4066195613436
* cell instance $91 r0 *1 -135.375,-213.435
X$91 13 10 M1_PSUB_CDNS_4066195613435
* cell instance $92 r0 *1 -135.685,-212.815
X$92 13 10 M1_PSUB_CDNS_4066195613433
* cell instance $93 r0 *1 -132.585,-219.015
X$93 13 10 M1_PSUB_CDNS_4066195613444
* cell instance $94 r0 *1 -132.895,-218.395
X$94 13 10 M1_PSUB_CDNS_4066195613443
* cell instance $95 r0 *1 -133.205,-217.775
X$95 13 10 M1_PSUB_CDNS_4066195613442
* cell instance $96 r0 *1 -133.515,-217.155
X$96 13 10 M1_PSUB_CDNS_4066195613441
* cell instance $97 r0 *1 -133.825,-216.535
X$97 13 10 M1_PSUB_CDNS_4066195613440
* cell instance $98 r0 *1 -134.135,-215.915
X$98 13 10 M1_PSUB_CDNS_4066195613439
* cell instance $99 r0 *1 -134.445,-215.295
X$99 13 10 M1_PSUB_CDNS_4066195613438
* cell instance $100 r0 *1 -131.655,-220.875
X$100 13 10 M1_PSUB_CDNS_4066195613447
* cell instance $101 r0 *1 -131.965,-220.255
X$101 13 10 M1_PSUB_CDNS_4066195613446
* cell instance $102 r0 *1 -132.275,-219.635
X$102 13 10 M1_PSUB_CDNS_4066195613445
* cell instance $103 r0 *1 -131.345,-221.495
X$103 13 10 M1_PSUB_CDNS_4066195613434
* cell instance $104 r0 *1 -127.45,-206.88
X$104 14 12 M1_PSUB_CDNS_4066195613451
* cell instance $105 r0 *1 -145.275,-204.47
X$105 14 12 M1_PSUB_CDNS_4066195613437
* cell instance $106 r0 *1 -145.585,-203.85
X$106 14 12 M1_PSUB_CDNS_4066195613436
* cell instance $107 r0 *1 -145.895,-203.23
X$107 14 12 M1_PSUB_CDNS_4066195613435
* cell instance $108 r0 *1 -146.205,-202.61
X$108 14 12 M1_PSUB_CDNS_4066195613433
* cell instance $109 r0 *1 -143.105,-208.81
X$109 14 12 M1_PSUB_CDNS_4066195613444
* cell instance $110 r0 *1 -143.415,-208.19
X$110 14 12 M1_PSUB_CDNS_4066195613443
* cell instance $111 r0 *1 -143.725,-207.57
X$111 14 12 M1_PSUB_CDNS_4066195613442
* cell instance $112 r0 *1 -144.035,-206.95
X$112 14 12 M1_PSUB_CDNS_4066195613441
* cell instance $113 r0 *1 -144.345,-206.33
X$113 14 12 M1_PSUB_CDNS_4066195613440
* cell instance $114 r0 *1 -144.655,-205.71
X$114 14 12 M1_PSUB_CDNS_4066195613439
* cell instance $115 r0 *1 -144.965,-205.09
X$115 14 12 M1_PSUB_CDNS_4066195613438
* cell instance $116 r0 *1 -142.175,-210.67
X$116 14 12 M1_PSUB_CDNS_4066195613447
* cell instance $117 r0 *1 -142.485,-210.05
X$117 14 12 M1_PSUB_CDNS_4066195613446
* cell instance $118 r0 *1 -142.795,-209.43
X$118 14 12 M1_PSUB_CDNS_4066195613445
* cell instance $119 r0 *1 -141.865,-211.29
X$119 14 12 M1_PSUB_CDNS_4066195613434
* cell instance $120 r0 *1 -118.905,-216.825
X$120 13 192 M2_M1_CDNS_4066195613480
* cell instance $121 r0 *1 -122.18,-217.145
X$121 13 M1_PSUB_CDNS_4066195613455
* cell instance $122 r0 *1 -118.905,-216.825
X$122 13 192 M3_M2_CDNS_4066195613481
* cell instance $123 r0 *1 -129.395,-206.335
X$123 14 191 M2_M1_CDNS_4066195613480
* cell instance $124 r0 *1 -129.395,-206.335
X$124 14 191 M3_M2_CDNS_4066195613481
* cell instance $125 r0 *1 -156.185,-186.28
X$125 17 15 M1_PSUB_CDNS_4066195613453
* cell instance $126 r0 *1 -165.62,-183.81
X$126 17 15 M1_PSUB_CDNS_4066195613437
* cell instance $127 r0 *1 -165.93,-183.19
X$127 17 15 M1_PSUB_CDNS_4066195613436
* cell instance $128 r0 *1 -166.24,-182.57
X$128 17 15 M1_PSUB_CDNS_4066195613435
* cell instance $129 r0 *1 -166.55,-181.95
X$129 17 15 M1_PSUB_CDNS_4066195613433
* cell instance $130 r0 *1 -163.45,-188.15
X$130 17 15 M1_PSUB_CDNS_4066195613444
* cell instance $131 r0 *1 -163.76,-187.53
X$131 17 15 M1_PSUB_CDNS_4066195613443
* cell instance $132 r0 *1 -164.07,-186.91
X$132 17 15 M1_PSUB_CDNS_4066195613442
* cell instance $133 r0 *1 -164.38,-186.29
X$133 17 15 M1_PSUB_CDNS_4066195613441
* cell instance $134 r0 *1 -164.69,-185.67
X$134 17 15 M1_PSUB_CDNS_4066195613440
* cell instance $135 r0 *1 -165,-185.05
X$135 17 15 M1_PSUB_CDNS_4066195613439
* cell instance $136 r0 *1 -165.31,-184.43
X$136 17 15 M1_PSUB_CDNS_4066195613438
* cell instance $137 r0 *1 -162.52,-190.01
X$137 17 15 M1_PSUB_CDNS_4066195613447
* cell instance $138 r0 *1 -162.83,-189.39
X$138 17 15 M1_PSUB_CDNS_4066195613446
* cell instance $139 r0 *1 -163.14,-188.77
X$139 17 15 M1_PSUB_CDNS_4066195613445
* cell instance $140 r0 *1 -162.21,-190.63
X$140 17 15 M1_PSUB_CDNS_4066195613434
* cell instance $141 r0 *1 -156.405,-193.88
X$141 17 16 M1_PSUB_CDNS_4066195613437
* cell instance $142 r0 *1 -156.715,-193.26
X$142 17 16 M1_PSUB_CDNS_4066195613436
* cell instance $143 r0 *1 -157.025,-192.64
X$143 17 16 M1_PSUB_CDNS_4066195613435
* cell instance $144 r0 *1 -157.335,-192.02
X$144 17 16 M1_PSUB_CDNS_4066195613433
* cell instance $145 r0 *1 -154.235,-198.22
X$145 17 16 M1_PSUB_CDNS_4066195613444
* cell instance $146 r0 *1 -154.545,-197.6
X$146 17 16 M1_PSUB_CDNS_4066195613443
* cell instance $147 r0 *1 -154.855,-196.98
X$147 17 16 M1_PSUB_CDNS_4066195613442
* cell instance $148 r0 *1 -155.165,-196.36
X$148 17 16 M1_PSUB_CDNS_4066195613441
* cell instance $149 r0 *1 -155.475,-195.74
X$149 17 16 M1_PSUB_CDNS_4066195613440
* cell instance $150 r0 *1 -155.785,-195.12
X$150 17 16 M1_PSUB_CDNS_4066195613439
* cell instance $151 r0 *1 -156.095,-194.5
X$151 17 16 M1_PSUB_CDNS_4066195613438
* cell instance $152 r0 *1 -153.305,-200.08
X$152 17 16 M1_PSUB_CDNS_4066195613447
* cell instance $153 r0 *1 -153.615,-199.46
X$153 17 16 M1_PSUB_CDNS_4066195613446
* cell instance $154 r0 *1 -153.925,-198.84
X$154 17 16 M1_PSUB_CDNS_4066195613445
* cell instance $155 r0 *1 -152.995,-200.7
X$155 17 16 M1_PSUB_CDNS_4066195613434
* cell instance $156 r0 *1 -155.37,-184.955
X$156 17 169 M2_M1_CDNS_4066195613478
* cell instance $157 r0 *1 -155.37,-184.955
X$157 17 169 M3_M2_CDNS_4066195613479
* cell instance $158 r0 *1 -137.985,-198.59
X$158 18 19 M2_M1_CDNS_4066195613469
* cell instance $159 r0 *1 -52.435,-191.625
X$159 18 19 M2_M1_CDNS_40661956134109
* cell instance $160 r0 *1 -52.435,-191.625
X$160 18 19 M3_M2_CDNS_40661956134108
* cell instance $161 r0 *1 -76.87,-198.575
X$161 18 19 M3_M2_CDNS_4066195613474
* cell instance $162 r0 *1 -97.73,-198.59
X$162 18 19 M2_M1_CDNS_4066195613468
* cell instance $163 r0 *1 -46.07,-198.59
X$163 18 19 M2_M1_CDNS_4066195613468
* cell instance $164 r0 *1 -161.455,-176.015
X$164 21 20 M1_PSUB_CDNS_4066195613452
* cell instance $165 r0 *1 -176.14,-173.605
X$165 21 20 M1_PSUB_CDNS_4066195613437
* cell instance $166 r0 *1 -176.45,-172.985
X$166 21 20 M1_PSUB_CDNS_4066195613436
* cell instance $167 r0 *1 -176.76,-172.365
X$167 21 20 M1_PSUB_CDNS_4066195613435
* cell instance $168 r0 *1 -177.07,-171.745
X$168 21 20 M1_PSUB_CDNS_4066195613433
* cell instance $169 r0 *1 -173.97,-177.945
X$169 21 20 M1_PSUB_CDNS_4066195613444
* cell instance $170 r0 *1 -174.28,-177.325
X$170 21 20 M1_PSUB_CDNS_4066195613443
* cell instance $171 r0 *1 -174.59,-176.705
X$171 21 20 M1_PSUB_CDNS_4066195613442
* cell instance $172 r0 *1 -174.9,-176.085
X$172 21 20 M1_PSUB_CDNS_4066195613441
* cell instance $173 r0 *1 -175.21,-175.465
X$173 21 20 M1_PSUB_CDNS_4066195613440
* cell instance $174 r0 *1 -175.52,-174.845
X$174 21 20 M1_PSUB_CDNS_4066195613439
* cell instance $175 r0 *1 -175.83,-174.225
X$175 21 20 M1_PSUB_CDNS_4066195613438
* cell instance $176 r0 *1 -173.04,-179.805
X$176 21 20 M1_PSUB_CDNS_4066195613447
* cell instance $177 r0 *1 -173.35,-179.185
X$177 21 20 M1_PSUB_CDNS_4066195613446
* cell instance $178 r0 *1 -173.66,-178.565
X$178 21 20 M1_PSUB_CDNS_4066195613445
* cell instance $179 r0 *1 -172.73,-180.425
X$179 21 20 M1_PSUB_CDNS_4066195613434
* cell instance $180 r0 *1 -158.895,-177.595
X$180 21 106 M2_M1_CDNS_4066195613475
* cell instance $181 r0 *1 -158.895,-177.595
X$181 21 106 M3_M2_CDNS_4066195613476
* cell instance $182 r0 *1 -161.175,-175.315
X$182 21 113 M2_M1_CDNS_4066195613475
* cell instance $183 r0 *1 -161.175,-175.315
X$183 21 113 M3_M2_CDNS_4066195613476
* cell instance $184 r0 *1 -160.415,-176.075
X$184 21 114 M2_M1_CDNS_4066195613475
* cell instance $185 r0 *1 -160.415,-176.075
X$185 21 114 M3_M2_CDNS_4066195613476
* cell instance $186 r0 *1 -159.655,-176.835
X$186 21 163 M2_M1_CDNS_4066195613475
* cell instance $187 r0 *1 -159.655,-176.835
X$187 21 163 M3_M2_CDNS_4066195613476
* cell instance $188 r0 *1 -163.455,-173.035
X$188 21 154 M3_M2_CDNS_4066195613476
* cell instance $189 r0 *1 -163.455,-173.035
X$189 21 154 M2_M1_CDNS_4066195613475
* cell instance $190 r0 *1 -162.695,-173.795
X$190 21 111 M2_M1_CDNS_4066195613475
* cell instance $191 r0 *1 -162.695,-173.795
X$191 21 111 M3_M2_CDNS_4066195613476
* cell instance $192 r0 *1 -161.935,-174.555
X$192 21 112 M2_M1_CDNS_4066195613475
* cell instance $193 r0 *1 -161.935,-174.555
X$193 21 112 M3_M2_CDNS_4066195613476
* cell instance $194 r0 *1 -164.975,-171.515
X$194 21 164 M2_M1_CDNS_4066195613475
* cell instance $195 r0 *1 -164.975,-171.515
X$195 21 164 M3_M2_CDNS_4066195613476
* cell instance $196 r0 *1 -164.215,-172.275
X$196 21 155 M2_M1_CDNS_4066195613475
* cell instance $197 r0 *1 -164.215,-172.275
X$197 21 155 M3_M2_CDNS_4066195613476
* cell instance $198 r0 *1 -183.375,-169.77
X$198 24 22 M1_PSUB_CDNS_4066195613458
* cell instance $199 r0 *1 -179.21,-165.42
X$199 24 22 M1_PSUB_CDNS_4066195613456
* cell instance $200 r0 *1 -187.095,-162.95
X$200 24 22 M1_PSUB_CDNS_4066195613437
* cell instance $201 r0 *1 -187.405,-162.33
X$201 24 22 M1_PSUB_CDNS_4066195613436
* cell instance $202 r0 *1 -187.715,-161.71
X$202 24 22 M1_PSUB_CDNS_4066195613435
* cell instance $203 r0 *1 -188.025,-161.09
X$203 24 22 M1_PSUB_CDNS_4066195613433
* cell instance $204 r0 *1 -184.925,-167.29
X$204 24 22 M1_PSUB_CDNS_4066195613444
* cell instance $205 r0 *1 -185.235,-166.67
X$205 24 22 M1_PSUB_CDNS_4066195613443
* cell instance $206 r0 *1 -185.545,-166.05
X$206 24 22 M1_PSUB_CDNS_4066195613442
* cell instance $207 r0 *1 -185.855,-165.43
X$207 24 22 M1_PSUB_CDNS_4066195613441
* cell instance $208 r0 *1 -186.165,-164.81
X$208 24 22 M1_PSUB_CDNS_4066195613440
* cell instance $209 r0 *1 -186.475,-164.19
X$209 24 22 M1_PSUB_CDNS_4066195613439
* cell instance $210 r0 *1 -186.785,-163.57
X$210 24 22 M1_PSUB_CDNS_4066195613438
* cell instance $211 r0 *1 -183.995,-169.15
X$211 24 22 M1_PSUB_CDNS_4066195613447
* cell instance $212 r0 *1 -184.305,-168.53
X$212 24 22 M1_PSUB_CDNS_4066195613446
* cell instance $213 r0 *1 -184.615,-167.91
X$213 24 22 M1_PSUB_CDNS_4066195613445
* cell instance $214 r0 *1 -184.735,-154.71
X$214 25 23 M1_PSUB_CDNS_4066195613450
* cell instance $215 r0 *1 -194.36,-159.06
X$215 25 23 M1_PSUB_CDNS_4066195613458
* cell instance $216 r0 *1 -198.08,-152.24
X$216 25 23 M1_PSUB_CDNS_4066195613437
* cell instance $217 r0 *1 -198.39,-151.62
X$217 25 23 M1_PSUB_CDNS_4066195613436
* cell instance $218 r0 *1 -198.7,-151
X$218 25 23 M1_PSUB_CDNS_4066195613435
* cell instance $219 r0 *1 -199.01,-150.38
X$219 25 23 M1_PSUB_CDNS_4066195613433
* cell instance $220 r0 *1 -195.91,-156.58
X$220 25 23 M1_PSUB_CDNS_4066195613444
* cell instance $221 r0 *1 -196.22,-155.96
X$221 25 23 M1_PSUB_CDNS_4066195613443
* cell instance $222 r0 *1 -196.53,-155.34
X$222 25 23 M1_PSUB_CDNS_4066195613442
* cell instance $223 r0 *1 -196.84,-154.72
X$223 25 23 M1_PSUB_CDNS_4066195613441
* cell instance $224 r0 *1 -197.15,-154.1
X$224 25 23 M1_PSUB_CDNS_4066195613440
* cell instance $225 r0 *1 -197.46,-153.48
X$225 25 23 M1_PSUB_CDNS_4066195613439
* cell instance $226 r0 *1 -197.77,-152.86
X$226 25 23 M1_PSUB_CDNS_4066195613438
* cell instance $227 r0 *1 -194.98,-158.44
X$227 25 23 M1_PSUB_CDNS_4066195613447
* cell instance $228 r0 *1 -195.29,-157.82
X$228 25 23 M1_PSUB_CDNS_4066195613446
* cell instance $229 r0 *1 -195.6,-157.2
X$229 25 23 M1_PSUB_CDNS_4066195613445
* cell instance $230 r0 *1 -167.255,-169.235
X$230 24 97 M2_M1_CDNS_4066195613469
* cell instance $231 r0 *1 -167.255,-169.235
X$231 24 97 M3_M2_CDNS_4066195613477
* cell instance $232 r0 *1 -174.61,-160.57
X$232 25 96 M2_M1_CDNS_4066195613471
* cell instance $233 r0 *1 -174.61,-160.57
X$233 25 96 M3_M2_CDNS_4066195613472
* cell instance $234 r0 *1 -206.22,-146.15
X$234 26 27 M1_PSUB_CDNS_4066195613444
* cell instance $235 r0 *1 -206.53,-145.53
X$235 26 27 M1_PSUB_CDNS_4066195613443
* cell instance $236 r0 *1 -206.84,-144.91
X$236 26 27 M1_PSUB_CDNS_4066195613442
* cell instance $237 r0 *1 -207.15,-144.29
X$237 26 27 M1_PSUB_CDNS_4066195613441
* cell instance $238 r0 *1 -207.46,-143.67
X$238 26 27 M1_PSUB_CDNS_4066195613440
* cell instance $239 r0 *1 -207.77,-143.05
X$239 26 27 M1_PSUB_CDNS_4066195613439
* cell instance $240 r0 *1 -208.08,-142.43
X$240 26 27 M1_PSUB_CDNS_4066195613438
* cell instance $241 r0 *1 -205.29,-148.01
X$241 26 27 M1_PSUB_CDNS_4066195613447
* cell instance $242 r0 *1 -205.6,-147.39
X$242 26 27 M1_PSUB_CDNS_4066195613446
* cell instance $243 r0 *1 -205.91,-146.77
X$243 26 27 M1_PSUB_CDNS_4066195613445
* cell instance $244 r0 *1 -204.98,-148.63
X$244 26 27 M1_PSUB_CDNS_4066195613434
* cell instance $245 r0 *1 -188.77,-147.72
X$245 26 156 M2_M1_CDNS_4066195613475
* cell instance $246 r0 *1 -189.695,-144.28
X$246 26 28 M1_PSUB_CDNS_4066195613448
* cell instance $247 r0 *1 -188.77,-147.72
X$247 26 156 M3_M2_CDNS_4066195613476
* cell instance $248 r0 *1 -188.01,-148.48
X$248 26 128 M2_M1_CDNS_4066195613475
* cell instance $249 r0 *1 -188.01,-148.48
X$249 26 128 M3_M2_CDNS_4066195613476
* cell instance $250 r0 *1 -193.33,-143.16
X$250 26 157 M2_M1_CDNS_4066195613475
* cell instance $251 r0 *1 -193.33,-143.16
X$251 26 157 M3_M2_CDNS_4066195613476
* cell instance $252 r0 *1 -192.57,-143.92
X$252 26 132 M2_M1_CDNS_4066195613475
* cell instance $253 r0 *1 -192.57,-143.92
X$253 26 132 M3_M2_CDNS_4066195613476
* cell instance $254 r0 *1 -191.81,-144.68
X$254 26 161 M2_M1_CDNS_4066195613475
* cell instance $255 r0 *1 -191.81,-144.68
X$255 26 161 M3_M2_CDNS_4066195613476
* cell instance $256 r0 *1 -191.05,-145.44
X$256 26 160 M2_M1_CDNS_4066195613475
* cell instance $257 r0 *1 -191.05,-145.44
X$257 26 160 M3_M2_CDNS_4066195613476
* cell instance $258 r0 *1 -190.29,-146.2
X$258 26 159 M2_M1_CDNS_4066195613475
* cell instance $259 r0 *1 -190.29,-146.2
X$259 26 159 M3_M2_CDNS_4066195613476
* cell instance $260 r0 *1 -189.53,-146.96
X$260 26 158 M2_M1_CDNS_4066195613475
* cell instance $261 r0 *1 -189.53,-146.96
X$261 26 158 M3_M2_CDNS_4066195613476
* cell instance $262 r0 *1 -194.09,-142.4
X$262 26 116 M2_M1_CDNS_4066195613475
* cell instance $263 r0 *1 -194.09,-142.4
X$263 26 116 M3_M2_CDNS_4066195613476
* cell instance $264 r0 *1 -196.37,-140.12
X$264 26 100 M3_M2_CDNS_4066195613477
* cell instance $265 r0 *1 -196.37,-140.12
X$265 26 100 M2_M1_CDNS_4066195613469
* cell instance $266 r0 *1 -195.61,-140.88
X$266 26 138 M2_M1_CDNS_4066195613475
* cell instance $267 r0 *1 -209.01,-140.57
X$267 26 27 M1_PSUB_CDNS_4066195613435
* cell instance $268 r0 *1 -208.7,-141.19
X$268 26 27 M1_PSUB_CDNS_4066195613436
* cell instance $269 r0 *1 -195.61,-140.88
X$269 26 138 M3_M2_CDNS_4066195613476
* cell instance $270 r0 *1 -194.85,-141.64
X$270 26 133 M2_M1_CDNS_4066195613475
* cell instance $271 r0 *1 -208.39,-141.81
X$271 26 27 M1_PSUB_CDNS_4066195613437
* cell instance $272 r0 *1 -194.85,-141.64
X$272 26 133 M3_M2_CDNS_4066195613476
* cell instance $273 r0 *1 -209.32,-139.95
X$273 26 27 M1_PSUB_CDNS_4066195613433
* cell instance $274 r0 *1 -127.31,-133.88
X$274 31 28 M1_PSUB_CDNS_4066195613449
* cell instance $275 r0 *1 -229.615,-89.65
X$275 31 28 M1_PSUB_CDNS_4066195613431
* cell instance $276 r0 *1 -132.125,-63.61
X$276 31 28 M1_PSUB_CDNS_4066195613429
* cell instance $277 r0 *1 -218.99,-131.1
X$277 31 28 M1_PSUB_CDNS_4066195613437
* cell instance $278 r0 *1 -228.685,-121.42
X$278 31 28 M1_PSUB_CDNS_4066195613437
* cell instance $279 r0 *1 -228.995,-120.8
X$279 31 28 M1_PSUB_CDNS_4066195613436
* cell instance $280 r0 *1 -219.3,-130.48
X$280 31 28 M1_PSUB_CDNS_4066195613436
* cell instance $281 r0 *1 -219.61,-129.86
X$281 31 28 M1_PSUB_CDNS_4066195613435
* cell instance $282 r0 *1 -229.305,-120.18
X$282 31 28 M1_PSUB_CDNS_4066195613435
* cell instance $283 r0 *1 -229.615,-119.56
X$283 31 28 M1_PSUB_CDNS_4066195613433
* cell instance $284 r0 *1 -219.92,-129.24
X$284 31 28 M1_PSUB_CDNS_4066195613433
* cell instance $285 r0 *1 -226.515,-125.76
X$285 31 28 M1_PSUB_CDNS_4066195613444
* cell instance $286 r0 *1 -216.82,-135.44
X$286 31 28 M1_PSUB_CDNS_4066195613444
* cell instance $287 r0 *1 -226.825,-125.14
X$287 31 28 M1_PSUB_CDNS_4066195613443
* cell instance $288 r0 *1 -217.13,-134.82
X$288 31 28 M1_PSUB_CDNS_4066195613443
* cell instance $289 r0 *1 -227.135,-124.52
X$289 31 28 M1_PSUB_CDNS_4066195613442
* cell instance $290 r0 *1 -217.44,-134.2
X$290 31 28 M1_PSUB_CDNS_4066195613442
* cell instance $291 r0 *1 -227.445,-123.9
X$291 31 28 M1_PSUB_CDNS_4066195613441
* cell instance $292 r0 *1 -217.75,-133.58
X$292 31 28 M1_PSUB_CDNS_4066195613441
* cell instance $293 r0 *1 -227.755,-123.28
X$293 31 28 M1_PSUB_CDNS_4066195613440
* cell instance $294 r0 *1 -218.06,-132.96
X$294 31 28 M1_PSUB_CDNS_4066195613440
* cell instance $295 r0 *1 -228.065,-122.66
X$295 31 28 M1_PSUB_CDNS_4066195613439
* cell instance $296 r0 *1 -218.37,-132.34
X$296 31 28 M1_PSUB_CDNS_4066195613439
* cell instance $297 r0 *1 -228.375,-122.04
X$297 31 28 M1_PSUB_CDNS_4066195613438
* cell instance $298 r0 *1 -218.68,-131.72
X$298 31 28 M1_PSUB_CDNS_4066195613438
* cell instance $299 r0 *1 -225.585,-127.62
X$299 31 28 M1_PSUB_CDNS_4066195613447
* cell instance $300 r0 *1 -215.89,-137.3
X$300 31 28 M1_PSUB_CDNS_4066195613447
* cell instance $301 r0 *1 -225.895,-127
X$301 31 28 M1_PSUB_CDNS_4066195613446
* cell instance $302 r0 *1 -216.2,-136.68
X$302 31 28 M1_PSUB_CDNS_4066195613446
* cell instance $303 r0 *1 -226.205,-126.38
X$303 31 28 M1_PSUB_CDNS_4066195613445
* cell instance $304 r0 *1 -216.51,-136.06
X$304 31 28 M1_PSUB_CDNS_4066195613445
* cell instance $305 r0 *1 -225.275,-128.24
X$305 31 28 M1_PSUB_CDNS_4066195613434
* cell instance $306 r0 *1 -215.58,-137.92
X$306 31 28 M1_PSUB_CDNS_4066195613434
* cell instance $307 r0 *1 -104.16,-146.01
X$307 29 30 M3_M2_CDNS_4066195613488
* cell instance $308 r0 *1 -104.16,-146.01
X$308 29 30 M2_M1_CDNS_4066195613486
* cell instance $309 r0 *1 -79.795,-146.01
X$309 29 30 M3_M2_CDNS_4066195613488
* cell instance $310 r0 *1 -79.795,-146.01
X$310 29 30 M2_M1_CDNS_4066195613486
* cell instance $311 r0 *1 -149.98,-142.125
X$311 29 30 M2_M1_CDNS_4066195613468
* cell instance $312 r0 *1 -131.605,-142.165
X$312 29 30 M3_M2_CDNS_4066195613473
* cell instance $313 r0 *1 -97.73,-142.125
X$313 29 30 M2_M1_CDNS_4066195613468
* cell instance $314 r0 *1 -46.07,-142.125
X$314 29 30 M2_M1_CDNS_4066195613468
* cell instance $315 r0 *1 -227.01,-87.255
X$315 31 70 M2_M1_CDNS_4066195613459
* cell instance $316 r0 *1 -227.01,-87.255
X$316 31 70 M3_M2_CDNS_4066195613454
* cell instance $317 r0 *1 -209.265,-64.285
X$317 31 56 M2_M1_CDNS_4066195613421
* cell instance $318 r0 *1 -209.265,-64.285
X$318 31 56 M3_M2_CDNS_4066195613482
* cell instance $319 r0 *1 -193.41,-64.285
X$319 31 57 M2_M1_CDNS_4066195613421
* cell instance $320 r0 *1 -193.41,-64.285
X$320 31 57 M3_M2_CDNS_4066195613482
* cell instance $321 r0 *1 -173.345,-64.285
X$321 31 M2_M1_CDNS_4066195613483
* cell instance $322 r0 *1 -198.45,-138.04
X$322 31 117 M2_M1_CDNS_4066195613475
* cell instance $323 r0 *1 -198.45,-138.04
X$323 31 117 M3_M2_CDNS_4066195613476
* cell instance $324 r0 *1 -175.33,-138.04
X$324 31 147 M2_M1_CDNS_4066195613475
* cell instance $325 r0 *1 -175.33,-138.04
X$325 31 147 M3_M2_CDNS_4066195613476
* cell instance $326 r0 *1 -152.835,-138.04
X$326 31 165 M2_M1_CDNS_4066195613475
* cell instance $327 r0 *1 -152.835,-138.04
X$327 31 165 M3_M2_CDNS_4066195613476
* cell instance $328 r0 *1 -124.59,-138.04
X$328 31 79 M2_M1_CDNS_4066195613487
* cell instance $329 r0 *1 -124.59,-138.04
X$329 31 79 M3_M2_CDNS_40661956134101
* cell instance $330 r0 *1 -199.21,-137.28
X$330 31 127 M2_M1_CDNS_4066195613475
* cell instance $331 r0 *1 -199.21,-137.28
X$331 31 127 M3_M2_CDNS_4066195613476
* cell instance $332 r0 *1 -176.09,-137.28
X$332 31 134 M2_M1_CDNS_4066195613475
* cell instance $333 r0 *1 -176.09,-137.28
X$333 31 134 M3_M2_CDNS_4066195613476
* cell instance $334 r0 *1 -153.595,-137.28
X$334 31 166 M2_M1_CDNS_4066195613475
* cell instance $335 r0 *1 -153.595,-137.28
X$335 31 166 M3_M2_CDNS_4066195613476
* cell instance $336 r0 *1 -125.35,-137.28
X$336 31 86 M2_M1_CDNS_4066195613487
* cell instance $337 r0 *1 -125.35,-137.28
X$337 31 86 M3_M2_CDNS_40661956134101
* cell instance $338 r0 *1 -199.97,-136.52
X$338 31 126 M2_M1_CDNS_4066195613475
* cell instance $339 r0 *1 -199.97,-136.52
X$339 31 126 M3_M2_CDNS_4066195613476
* cell instance $340 r0 *1 -176.85,-136.52
X$340 31 118 M2_M1_CDNS_4066195613475
* cell instance $341 r0 *1 -176.85,-136.52
X$341 31 118 M3_M2_CDNS_4066195613476
* cell instance $342 r0 *1 -154.355,-136.52
X$342 31 140 M2_M1_CDNS_4066195613475
* cell instance $343 r0 *1 -154.355,-136.52
X$343 31 140 M3_M2_CDNS_4066195613476
* cell instance $344 r0 *1 -126.11,-136.52
X$344 31 92 M2_M1_CDNS_4066195613487
* cell instance $345 r0 *1 -126.11,-136.52
X$345 31 92 M3_M2_CDNS_40661956134101
* cell instance $346 r0 *1 -200.73,-135.76
X$346 31 125 M2_M1_CDNS_4066195613475
* cell instance $347 r0 *1 -200.73,-135.76
X$347 31 125 M3_M2_CDNS_4066195613476
* cell instance $348 r0 *1 -177.61,-135.76
X$348 31 139 M2_M1_CDNS_4066195613475
* cell instance $349 r0 *1 -177.61,-135.76
X$349 31 139 M3_M2_CDNS_4066195613476
* cell instance $350 r0 *1 -155.115,-135.76
X$350 31 131 M2_M1_CDNS_4066195613475
* cell instance $351 r0 *1 -155.115,-135.76
X$351 31 131 M3_M2_CDNS_4066195613476
* cell instance $352 r0 *1 -126.87,-135.76
X$352 31 83 M2_M1_CDNS_4066195613487
* cell instance $353 r0 *1 -126.87,-135.76
X$353 31 83 M3_M2_CDNS_40661956134101
* cell instance $354 r0 *1 -201.49,-135
X$354 31 124 M2_M1_CDNS_4066195613475
* cell instance $355 r0 *1 -201.49,-135
X$355 31 124 M3_M2_CDNS_4066195613476
* cell instance $356 r0 *1 -178.37,-135
X$356 31 137 M2_M1_CDNS_4066195613475
* cell instance $357 r0 *1 -178.37,-135
X$357 31 137 M3_M2_CDNS_4066195613476
* cell instance $358 r0 *1 -155.875,-135
X$358 31 130 M2_M1_CDNS_4066195613475
* cell instance $359 r0 *1 -155.875,-135
X$359 31 130 M3_M2_CDNS_4066195613476
* cell instance $360 r0 *1 -127.63,-135
X$360 31 82 M2_M1_CDNS_4066195613487
* cell instance $361 r0 *1 -127.63,-135
X$361 31 82 M3_M2_CDNS_40661956134101
* cell instance $362 r0 *1 -202.25,-134.24
X$362 31 152 M2_M1_CDNS_4066195613475
* cell instance $363 r0 *1 -202.25,-134.24
X$363 31 152 M3_M2_CDNS_4066195613476
* cell instance $364 r0 *1 -179.13,-134.24
X$364 31 146 M2_M1_CDNS_4066195613475
* cell instance $365 r0 *1 -179.13,-134.24
X$365 31 146 M3_M2_CDNS_4066195613476
* cell instance $366 r0 *1 -156.635,-134.24
X$366 31 145 M2_M1_CDNS_4066195613475
* cell instance $367 r0 *1 -156.635,-134.24
X$367 31 145 M3_M2_CDNS_4066195613476
* cell instance $368 r0 *1 -128.39,-134.24
X$368 31 88 M2_M1_CDNS_4066195613487
* cell instance $369 r0 *1 -128.39,-134.24
X$369 31 88 M3_M2_CDNS_40661956134101
* cell instance $370 r0 *1 -203.01,-133.48
X$370 31 123 M2_M1_CDNS_4066195613475
* cell instance $371 r0 *1 -203.01,-133.48
X$371 31 123 M3_M2_CDNS_4066195613476
* cell instance $372 r0 *1 -179.89,-133.48
X$372 31 135 M2_M1_CDNS_4066195613475
* cell instance $373 r0 *1 -179.89,-133.48
X$373 31 135 M3_M2_CDNS_4066195613476
* cell instance $374 r0 *1 -157.395,-133.48
X$374 31 107 M2_M1_CDNS_4066195613475
* cell instance $375 r0 *1 -157.395,-133.48
X$375 31 107 M3_M2_CDNS_4066195613476
* cell instance $376 r0 *1 -129.15,-133.48
X$376 31 89 M2_M1_CDNS_4066195613487
* cell instance $377 r0 *1 -129.15,-133.48
X$377 31 89 M3_M2_CDNS_40661956134101
* cell instance $378 r0 *1 -203.77,-132.72
X$378 31 122 M2_M1_CDNS_4066195613475
* cell instance $379 r0 *1 -203.77,-132.72
X$379 31 122 M3_M2_CDNS_4066195613476
* cell instance $380 r0 *1 -180.65,-132.72
X$380 31 141 M2_M1_CDNS_4066195613475
* cell instance $381 r0 *1 -180.65,-132.72
X$381 31 141 M3_M2_CDNS_4066195613476
* cell instance $382 r0 *1 -158.155,-132.72
X$382 31 108 M2_M1_CDNS_4066195613475
* cell instance $383 r0 *1 -158.155,-132.72
X$383 31 108 M3_M2_CDNS_4066195613476
* cell instance $384 r0 *1 -129.91,-132.72
X$384 31 87 M2_M1_CDNS_4066195613487
* cell instance $385 r0 *1 -129.91,-132.72
X$385 31 87 M3_M2_CDNS_40661956134101
* cell instance $386 r0 *1 -205.29,-131.2
X$386 31 151 M3_M2_CDNS_4066195613476
* cell instance $387 r0 *1 -205.29,-131.2
X$387 31 151 M2_M1_CDNS_4066195613475
* cell instance $388 r0 *1 -204.53,-131.96
X$388 31 150 M2_M1_CDNS_4066195613475
* cell instance $389 r0 *1 -204.53,-131.96
X$389 31 150 M3_M2_CDNS_4066195613476
* cell instance $390 r0 *1 -182.17,-131.2
X$390 31 148 M2_M1_CDNS_4066195613475
* cell instance $391 r0 *1 -182.17,-131.2
X$391 31 148 M3_M2_CDNS_4066195613476
* cell instance $392 r0 *1 -181.41,-131.96
X$392 31 121 M2_M1_CDNS_4066195613475
* cell instance $393 r0 *1 -181.41,-131.96
X$393 31 121 M3_M2_CDNS_4066195613476
* cell instance $394 r0 *1 -159.675,-131.2
X$394 31 109 M2_M1_CDNS_4066195613475
* cell instance $395 r0 *1 -159.675,-131.2
X$395 31 109 M3_M2_CDNS_4066195613476
* cell instance $396 r0 *1 -158.915,-131.96
X$396 31 143 M2_M1_CDNS_4066195613475
* cell instance $397 r0 *1 -158.915,-131.96
X$397 31 143 M3_M2_CDNS_4066195613476
* cell instance $398 r0 *1 -131.43,-131.2
X$398 31 85 M2_M1_CDNS_4066195613487
* cell instance $399 r0 *1 -131.43,-131.2
X$399 31 85 M3_M2_CDNS_40661956134101
* cell instance $400 r0 *1 -130.67,-131.96
X$400 31 84 M2_M1_CDNS_4066195613487
* cell instance $401 r0 *1 -130.67,-131.96
X$401 31 84 M3_M2_CDNS_40661956134101
* cell instance $402 r0 *1 -206.05,-130.44
X$402 31 153 M2_M1_CDNS_4066195613475
* cell instance $403 r0 *1 -206.05,-130.44
X$403 31 153 M3_M2_CDNS_4066195613476
* cell instance $404 r0 *1 -182.93,-130.44
X$404 31 136 M2_M1_CDNS_4066195613475
* cell instance $405 r0 *1 -182.93,-130.44
X$405 31 136 M3_M2_CDNS_4066195613476
* cell instance $406 r0 *1 -160.435,-130.44
X$406 31 110 M2_M1_CDNS_4066195613475
* cell instance $407 r0 *1 -160.435,-130.44
X$407 31 110 M3_M2_CDNS_4066195613476
* cell instance $408 r0 *1 -132.19,-130.44
X$408 31 91 M2_M1_CDNS_4066195613487
* cell instance $409 r0 *1 -132.19,-130.44
X$409 31 91 M3_M2_CDNS_40661956134101
* cell instance $410 r0 *1 -206.81,-129.68
X$410 31 149 M2_M1_CDNS_4066195613475
* cell instance $411 r0 *1 -206.81,-129.68
X$411 31 149 M3_M2_CDNS_4066195613476
* cell instance $412 r0 *1 -183.69,-129.68
X$412 31 119 M2_M1_CDNS_4066195613475
* cell instance $413 r0 *1 -183.69,-129.68
X$413 31 119 M3_M2_CDNS_4066195613476
* cell instance $414 r0 *1 -161.195,-129.68
X$414 31 144 M2_M1_CDNS_4066195613475
* cell instance $415 r0 *1 -161.195,-129.68
X$415 31 144 M3_M2_CDNS_4066195613476
* cell instance $416 r0 *1 -132.95,-129.68
X$416 31 90 M2_M1_CDNS_4066195613487
* cell instance $417 r0 *1 -132.95,-129.68
X$417 31 90 M3_M2_CDNS_40661956134101
* cell instance $418 r0 *1 -207.57,-128.92
X$418 31 129 M2_M1_CDNS_4066195613475
* cell instance $419 r0 *1 -207.57,-128.92
X$419 31 129 M3_M2_CDNS_4066195613476
* cell instance $420 r0 *1 -184.45,-128.92
X$420 31 120 M2_M1_CDNS_4066195613475
* cell instance $421 r0 *1 -184.45,-128.92
X$421 31 120 M3_M2_CDNS_4066195613476
* cell instance $422 r0 *1 -161.955,-128.92
X$422 31 142 M2_M1_CDNS_4066195613475
* cell instance $423 r0 *1 -161.955,-128.92
X$423 31 142 M3_M2_CDNS_4066195613476
* cell instance $424 r0 *1 -133.71,-128.92
X$424 31 80 M2_M1_CDNS_4066195613487
* cell instance $425 r0 *1 -133.71,-128.92
X$425 31 80 M3_M2_CDNS_40661956134101
* cell instance $426 r0 *1 -209.845,-126.405
X$426 33 32 M2_M1_CDNS_4066195613466
* cell instance $427 r0 *1 -66.63,-126.405
X$427 33 32 M2_M1_CDNS_4066195613468
* cell instance $428 r0 *1 -170.2,-126.405
X$428 33 32 M2_M1_CDNS_4066195613468
* cell instance $429 r0 *1 -118.29,-126.405
X$429 33 32 M2_M1_CDNS_4066195613468
* cell instance $430 r0 *1 -209.845,-69.925
X$430 35 34 M2_M1_CDNS_4066195613466
* cell instance $431 r0 *1 -164.12,-80.095
X$431 35 34 M3_M2_CDNS_4066195613485
* cell instance $432 r0 *1 -164.12,-80.095
X$432 35 34 M2_M1_CDNS_4066195613484
* cell instance $433 r0 *1 -181.22,-69.925
X$433 35 34 M3_M2_CDNS_4066195613474
* cell instance $434 r0 *1 -170.2,-69.925
X$434 35 34 M2_M1_CDNS_4066195613468
* cell instance $435 r0 *1 -164.705,-69.925
X$435 35 34 M3_M2_CDNS_4066195613474
* cell instance $436 r0 *1 -118.29,-69.925
X$436 35 34 M2_M1_CDNS_4066195613468
* cell instance $437 r0 *1 -66.63,-69.925
X$437 35 34 M2_M1_CDNS_4066195613468
* cell instance $438 r0 *1 48.175,-38.98
X$438 39 36 M3_M2_CDNS_4066195613427
* cell instance $439 r0 *1 48.175,-38.98
X$439 39 36 M2_M1_CDNS_4066195613432
* cell instance $440 r0 *1 48.275,-14.96
X$440 40 37 M2_M1_CDNS_4066195613432
* cell instance $441 r0 *1 48.275,-14.96
X$441 40 37 M3_M2_CDNS_4066195613427
* cell instance $442 r0 *1 48.215,-54.725
X$442 41 38 M3_M2_CDNS_4066195613427
* cell instance $443 r0 *1 48.215,-54.725
X$443 41 38 M2_M1_CDNS_4066195613432
* cell instance $444 r0 *1 41.385,-7.02
X$444 43 42 M2_M1_CDNS_4066195613457
* cell instance $445 r0 *1 41.385,-7.02
X$445 43 42 M3_M2_CDNS_4066195613422
* cell instance $446 r0 *1 44.345,0.19
X$446 45 44 M2_M1_CDNS_4066195613419
* cell instance $447 r0 *1 44.345,0.19
X$447 45 44 M3_M2_CDNS_4066195613424
* cell instance $448 r0 *1 34.75,-1.885
X$448 47 46 M2_M1_CDNS_4066195613420
* cell instance $449 r0 *1 34.75,-1.885
X$449 47 46 M3_M2_CDNS_4066195613423
* cell instance $450 r0 *1 29.12,-47.045
X$450 49 48 M2_M1_CDNS_4066195613425
* cell instance $451 r0 *1 29.12,-47.045
X$451 49 48 M3_M2_CDNS_4066195613426
* cell instance $452 r0 *1 2.71,0.19
X$452 52 50 M2_M1_CDNS_4066195613428
* cell instance $453 r0 *1 2.71,0.19
X$453 52 50 M3_M2_CDNS_4066195613430
* cell instance $454 r0 *1 26.585,0.19
X$454 53 51 M2_M1_CDNS_4066195613428
* cell instance $455 r0 *1 26.585,0.19
X$455 53 51 M3_M2_CDNS_4066195613430
* cell instance $456 r0 *1 -124.635,-77.375
X$456 55 54 M3_M2_CDNS_4066195613495
* cell instance $457 r0 *1 -124.635,-77.375
X$457 55 54 M2_M1_CDNS_4066195613496
* cell instance $458 r0 *1 -85.075,-90.39
X$458 59 58 M3_M2_CDNS_4066195613499
* cell instance $459 r0 *1 -85.075,-90.39
X$459 59 58 M2_M1_CDNS_40661956134100
* cell instance $460 r0 *1 -100.23,-78.34
X$460 61 60 M3_M2_CDNS_4066195613497
* cell instance $461 r0 *1 -100.23,-78.34
X$461 61 60 M2_M1_CDNS_4066195613498
* cell instance $462 r0 *1 -164.59,-98.275
X$462 64 62 M3_M2_CDNS_4066195613465
* cell instance $463 r0 *1 -164.59,-98.275
X$463 64 62 M2_M1_CDNS_4066195613464
* cell instance $464 r0 *1 -164.135,-109.68
X$464 65 63 M3_M2_CDNS_4066195613465
* cell instance $465 r0 *1 -164.135,-109.68
X$465 65 63 M2_M1_CDNS_4066195613464
* cell instance $466 r0 *1 -209.265,-98.275
X$466 68 66 M3_M2_CDNS_4066195613461
* cell instance $467 r0 *1 -209.265,-98.275
X$467 68 66 M2_M1_CDNS_4066195613460
* cell instance $468 r0 *1 -192.165,-98.275
X$468 69 67 M3_M2_CDNS_4066195613461
* cell instance $469 r0 *1 -192.165,-98.275
X$469 69 67 M2_M1_CDNS_4066195613460
* cell instance $470 r0 *1 -112.415,-110.555
X$470 75 71 M3_M2_CDNS_4066195613462
* cell instance $471 r0 *1 -112.415,-110.555
X$471 75 71 M2_M1_CDNS_4066195613463
* cell instance $472 r0 *1 -136.77,-86.675
X$472 76 72 M3_M2_CDNS_4066195613462
* cell instance $473 r0 *1 -136.77,-86.675
X$473 76 72 M2_M1_CDNS_4066195613463
* cell instance $474 r0 *1 -112.415,-87.825
X$474 77 73 M3_M2_CDNS_4066195613462
* cell instance $475 r0 *1 -112.415,-87.825
X$475 77 73 M2_M1_CDNS_4066195613463
* cell instance $476 r0 *1 -136.83,-109.09
X$476 78 74 M3_M2_CDNS_4066195613462
* cell instance $477 r0 *1 -136.83,-109.09
X$477 78 74 M2_M1_CDNS_4066195613463
* cell instance $478 r0 *1 -134.47,-128.16
X$478 93 81 M2_M1_CDNS_4066195613487
* cell instance $479 r0 *1 -134.47,-128.16
X$479 93 81 M3_M2_CDNS_40661956134101
* cell instance $480 r0 *1 -52.49,-165.09
X$480 95 94 M3_M2_CDNS_4066195613491
* cell instance $481 r0 *1 -52.49,-165.09
X$481 95 94 M2_M1_CDNS_4066195613492
* cell instance $482 r0 *1 -162.715,-128.16
X$482 102 98 M3_M2_CDNS_4066195613477
* cell instance $483 r0 *1 -162.715,-128.16
X$483 102 98 M2_M1_CDNS_4066195613469
* cell instance $484 r0 *1 -185.21,-128.16
X$484 103 99 M3_M2_CDNS_4066195613477
* cell instance $485 r0 *1 -185.21,-128.16
X$485 103 99 M2_M1_CDNS_4066195613469
* cell instance $486 r0 *1 -208.33,-128.16
X$486 104 101 M2_M1_CDNS_4066195613469
* cell instance $487 r0 *1 -208.33,-128.16
X$487 104 101 M3_M2_CDNS_4066195613477
* cell instance $488 r0 *1 -165.735,-170.755
X$488 168 115 M2_M1_CDNS_4066195613475
* cell instance $489 r0 *1 -165.735,-170.755
X$489 168 115 M3_M2_CDNS_4066195613476
* cell instance $490 r0 *1 -166.495,-169.995
X$490 167 162 M3_M2_CDNS_4066195613476
* cell instance $491 r0 *1 -166.495,-169.995
X$491 167 162 M2_M1_CDNS_4066195613475
* cell instance $492 r0 *1 -64.605,-180.695
X$492 175 170 M3_M2_CDNS_4066195613489
* cell instance $493 r0 *1 -64.605,-180.695
X$493 175 170 M2_M1_CDNS_4066195613490
* cell instance $494 r0 *1 -64.605,-158.325
X$494 176 171 M2_M1_CDNS_4066195613490
* cell instance $495 r0 *1 -64.605,-158.325
X$495 176 171 M3_M2_CDNS_4066195613489
* cell instance $496 r0 *1 -40.205,-159.985
X$496 177 172 M2_M1_CDNS_4066195613490
* cell instance $497 r0 *1 -40.205,-159.985
X$497 177 172 M3_M2_CDNS_4066195613489
* cell instance $498 r0 *1 -92.095,-153.39
X$498 178 173 M2_M1_CDNS_4066195613490
* cell instance $499 r0 *1 -92.095,-153.39
X$499 178 173 M3_M2_CDNS_4066195613489
* cell instance $500 r0 *1 -40.39,-182.515
X$500 179 174 M3_M2_CDNS_4066195613489
* cell instance $501 r0 *1 -40.39,-182.515
X$501 179 174 M2_M1_CDNS_4066195613490
* cell instance $502 r0 *1 -27.95,-187.26
X$502 183 180 M2_M1_CDNS_4066195613494
* cell instance $503 r0 *1 -27.95,-187.26
X$503 183 180 M3_M2_CDNS_4066195613493
* cell instance $504 r0 *1 -52.49,-149.245
X$504 184 181 M2_M1_CDNS_4066195613494
* cell instance $505 r0 *1 -52.49,-149.245
X$505 184 181 M3_M2_CDNS_4066195613493
* cell instance $506 r0 *1 -27.95,-149.245
X$506 185 182 M2_M1_CDNS_4066195613494
* cell instance $507 r0 *1 -27.95,-149.245
X$507 185 182 M3_M2_CDNS_4066195613493
* cell instance $508 r0 *1 -40.55,-232.115
X$508 187 186 M3_M2_CDNS_40661956134105
* cell instance $509 r0 *1 -40.55,-232.115
X$509 187 186 M2_M1_CDNS_40661956134104
* cell instance $510 r0 *1 -82.115,-232.115
X$510 189 188 M3_M2_CDNS_40661956134106
* cell instance $511 r0 *1 -82.115,-232.115
X$511 189 188 M2_M1_CDNS_40661956134107
* cell instance $512 r0 *1 -58.54,-250.875
X$512 207 193 M3_M2_CDNS_40661956134103
* cell instance $513 r0 *1 -58.54,-250.875
X$513 207 193 M2_M1_CDNS_40661956134102
* cell instance $514 r0 *1 -149.81,-161.15
X$514 208 194 M2_M1_CDNS_40661956134102
* cell instance $515 r0 *1 -149.81,-161.15
X$515 208 194 M3_M2_CDNS_40661956134103
* cell instance $516 r0 *1 -99.44,-215.98
X$516 209 195 M2_M1_CDNS_40661956134102
* cell instance $517 r0 *1 -99.44,-215.98
X$517 209 195 M3_M2_CDNS_40661956134103
* cell instance $518 r0 *1 -123.75,-188.905
X$518 210 196 M2_M1_CDNS_40661956134102
* cell instance $519 r0 *1 -123.75,-188.905
X$519 210 196 M3_M2_CDNS_40661956134103
* cell instance $520 r0 *1 -110.245,-178.38
X$520 211 197 M2_M1_CDNS_40661956134102
* cell instance $521 r0 *1 -110.245,-178.38
X$521 211 197 M3_M2_CDNS_40661956134103
* cell instance $522 r0 *1 -58.54,-231.875
X$522 212 198 M2_M1_CDNS_40661956134102
* cell instance $523 r0 *1 -58.54,-231.875
X$523 212 198 M3_M2_CDNS_40661956134103
* cell instance $524 r0 *1 -73.37,-241.005
X$524 213 199 M2_M1_CDNS_40661956134102
* cell instance $525 r0 *1 -73.37,-241.005
X$525 213 199 M3_M2_CDNS_40661956134103
* cell instance $526 r0 *1 -87.25,-223.4
X$526 214 200 M2_M1_CDNS_40661956134102
* cell instance $527 r0 *1 -87.25,-223.4
X$527 214 200 M3_M2_CDNS_40661956134103
* cell instance $528 r0 *1 -162.005,-152.5
X$528 215 201 M3_M2_CDNS_40661956134103
* cell instance $529 r0 *1 -162.005,-152.5
X$529 215 201 M2_M1_CDNS_40661956134102
* cell instance $530 r0 *1 -137.585,-178.38
X$530 216 202 M3_M2_CDNS_40661956134103
* cell instance $531 r0 *1 -137.585,-178.38
X$531 216 202 M2_M1_CDNS_40661956134102
* cell instance $532 r0 *1 -137.585,-152.5
X$532 217 203 M3_M2_CDNS_40661956134103
* cell instance $533 r0 *1 -137.585,-152.5
X$533 217 203 M2_M1_CDNS_40661956134102
* cell instance $534 r0 *1 -46.41,-250.875
X$534 218 204 M3_M2_CDNS_40661956134103
* cell instance $535 r0 *1 -46.41,-250.875
X$535 218 204 M2_M1_CDNS_40661956134102
* cell instance $536 r0 *1 -34.23,-250.875
X$536 219 205 M3_M2_CDNS_40661956134103
* cell instance $537 r0 *1 -34.23,-250.875
X$537 219 205 M2_M1_CDNS_40661956134102
* cell instance $538 r0 *1 -72.645,-215.98
X$538 220 206 M3_M2_CDNS_40661956134103
* cell instance $539 r0 *1 -72.645,-215.98
X$539 220 206 M2_M1_CDNS_40661956134102
.ENDS moscap_routing

* cell M1_PSUB_CDNS_406619561340
* pin
* pin
.SUBCKT M1_PSUB_CDNS_406619561340 1 2
.ENDS M1_PSUB_CDNS_406619561340

* cell M1_PSUB_CDNS_406619561344
* pin
* pin
.SUBCKT M1_PSUB_CDNS_406619561344 1 2
.ENDS M1_PSUB_CDNS_406619561344

* cell M1_PSUB_CDNS_406619561341
* pin
* pin
.SUBCKT M1_PSUB_CDNS_406619561341 1 2
.ENDS M1_PSUB_CDNS_406619561341

* cell M1_PSUB_CDNS_406619561342
* pin
* pin
.SUBCKT M1_PSUB_CDNS_406619561342 1 2
.ENDS M1_PSUB_CDNS_406619561342

* cell M3_M2_CDNS_406619561347
* pin
* pin
.SUBCKT M3_M2_CDNS_406619561347 1 2
.ENDS M3_M2_CDNS_406619561347

* cell M1_PSUB_CDNS_406619561343
* pin
* pin
.SUBCKT M1_PSUB_CDNS_406619561343 1 2
.ENDS M1_PSUB_CDNS_406619561343

* cell M1_PSUB_CDNS_406619561345
* pin
* pin
.SUBCKT M1_PSUB_CDNS_406619561345 1 2
.ENDS M1_PSUB_CDNS_406619561345

* cell M3_M2_CDNS_406619561346
* pin
* pin
.SUBCKT M3_M2_CDNS_406619561346 1 2
.ENDS M3_M2_CDNS_406619561346

* cell M1_NWELL_CDNS_40661956134483
* pin
* pin
* pin
* pin
.SUBCKT M1_NWELL_CDNS_40661956134483 1 2 3 4
.ENDS M1_NWELL_CDNS_40661956134483

* cell M1_PSUB_CDNS_40661956134199
* pin
* pin
.SUBCKT M1_PSUB_CDNS_40661956134199 1 2
.ENDS M1_PSUB_CDNS_40661956134199

* cell M1_PSUB_CDNS_40661956134499
* pin
.SUBCKT M1_PSUB_CDNS_40661956134499 1
.ENDS M1_PSUB_CDNS_40661956134499

* cell M1_PSUB_CDNS_40661956134484
* pin
* pin
.SUBCKT M1_PSUB_CDNS_40661956134484 1 2
.ENDS M1_PSUB_CDNS_40661956134484

* cell M2_M1_CDNS_40661956134492
* pin
* pin
.SUBCKT M2_M1_CDNS_40661956134492 1 2
.ENDS M2_M1_CDNS_40661956134492

* cell M3_M2_CDNS_40661956134491
* pin
* pin
.SUBCKT M3_M2_CDNS_40661956134491 1 2
.ENDS M3_M2_CDNS_40661956134491

* cell M3_M2_CDNS_40661956134490
* pin
* pin
.SUBCKT M3_M2_CDNS_40661956134490 1 2
.ENDS M3_M2_CDNS_40661956134490

* cell M2_M1_CDNS_40661956134462
* pin
* pin
.SUBCKT M2_M1_CDNS_40661956134462 1 2
.ENDS M2_M1_CDNS_40661956134462

* cell M2_M1_CDNS_40661956134493
* pin
* pin
.SUBCKT M2_M1_CDNS_40661956134493 1 2
.ENDS M2_M1_CDNS_40661956134493

* cell M3_M2_CDNS_40661956134224
* pin
* pin
.SUBCKT M3_M2_CDNS_40661956134224 1 2
.ENDS M3_M2_CDNS_40661956134224

* cell M3_M2_CDNS_40661956134223
* pin
* pin
.SUBCKT M3_M2_CDNS_40661956134223 1 2
.ENDS M3_M2_CDNS_40661956134223

* cell M2_M1_CDNS_40661956134497
* pin
* pin
.SUBCKT M2_M1_CDNS_40661956134497 1 2
.ENDS M2_M1_CDNS_40661956134497

* cell M2_M1_CDNS_40661956134498
* pin
* pin
.SUBCKT M2_M1_CDNS_40661956134498 1 2
.ENDS M2_M1_CDNS_40661956134498

* cell M2_M1_CDNS_40661956134258
* pin
* pin
.SUBCKT M2_M1_CDNS_40661956134258 1 2
.ENDS M2_M1_CDNS_40661956134258

* cell M3_M2_CDNS_40661956134227
* pin
* pin
.SUBCKT M3_M2_CDNS_40661956134227 1 2
.ENDS M3_M2_CDNS_40661956134227

* cell M2_M1_CDNS_40661956134494
* pin
* pin
.SUBCKT M2_M1_CDNS_40661956134494 1 2
.ENDS M2_M1_CDNS_40661956134494

* cell M2_M1_CDNS_40661956134495
* pin
* pin
.SUBCKT M2_M1_CDNS_40661956134495 1 2
.ENDS M2_M1_CDNS_40661956134495

* cell comp018green_esd_hbm
* pin
* pin
* pin
* pin
* pin
* pin
* pin
* pin
* pin
* pin
* pin
* pin
* pin
* pin
* pin
* pin
* pin
* pin
* pin
* pin
* pin
* pin
* pin
* pin
* pin
.SUBCKT comp018green_esd_hbm 3 4 8 9 10 11 12 13 14 15 16 17 18 19 20 21 22 23
+ 24 25 26 27 28 29 30
* cell instance $1 r0 *1 3.645,17.635
X$1 3 1 7 3 M1_NWELL_CDNS_40661956134503
* cell instance $2 r0 *1 30.655,3.595
X$2 3 1 7 3 M1_NWELL_CDNS_40661956134501
* cell instance $3 r0 *1 4.415,7.105
X$3 3 1 7 3 M1_NWELL_CDNS_40661956134321
* cell instance $4 r0 *1 30.655,10.615
X$4 3 3 7 1 M1_NWELL_CDNS_40661956134500
* cell instance $5 r0 *1 30.655,11.385
X$5 3 1 7 3 M1_NWELL_CDNS_40661956134502
* cell instance $6 r0 *1 30.655,23.885
X$6 3 1 7 3 M1_NWELL_CDNS_40661956134502
* cell instance $7 r0 *1 30.655,18.405
X$7 3 1 7 3 M1_NWELL_CDNS_40661956134502
* cell instance $8 r0 *1 30.655,9.845
X$8 3 1 7 3 M1_NWELL_CDNS_40661956134502
* cell instance $9 r0 *1 30.655,16.865
X$9 3 1 7 3 M1_NWELL_CDNS_40661956134502
* cell instance $10 r0 *1 30.655,25.425
X$10 3 1 7 3 M1_NWELL_CDNS_40661956134502
* cell instance $11 r0 *1 30.655,4.365
X$11 3 1 7 3 M1_NWELL_CDNS_40661956134502
* cell instance $12 r0 *1 30.655,30.905
X$12 3 1 7 3 M1_NWELL_CDNS_40661956134502
* cell instance $13 r0 *1 30.655,24.655
X$13 3 3 7 1 M1_NWELL_CDNS_40661956134500
* cell instance $14 r0 *1 30.655,17.635
X$14 3 3 7 1 M1_NWELL_CDNS_40661956134500
* cell instance $15 r0 *1 4.415,14.125
X$15 3 1 7 3 M1_NWELL_CDNS_40661956134321
* cell instance $16 r0 *1 4.415,21.145
X$16 3 1 7 3 M1_NWELL_CDNS_40661956134321
* cell instance $17 r0 *1 4.415,28.165
X$17 3 1 7 3 M1_NWELL_CDNS_40661956134321
* cell instance $18 r0 *1 56.895,21.145
X$18 3 1 7 3 M1_NWELL_CDNS_40661956134321
* cell instance $19 r0 *1 56.895,28.165
X$19 3 1 7 3 M1_NWELL_CDNS_40661956134321
* cell instance $20 r0 *1 56.895,7.105
X$20 3 1 7 3 M1_NWELL_CDNS_40661956134321
* cell instance $21 r0 *1 56.895,14.125
X$21 3 1 7 3 M1_NWELL_CDNS_40661956134321
* cell instance $22 r0 *1 30.655,31.675
X$22 3 1 7 3 M1_NWELL_CDNS_40661956134501
* cell instance $23 r0 *1 57.665,17.635
X$23 3 1 7 3 M1_NWELL_CDNS_40661956134503
* cell instance $24 r0 *1 30.655,40.63
X$24 4 2 M1_PSUB_CDNS_40661956134504
* cell instance $25 r0 *1 3.645,54.67
X$25 4 2 M1_PSUB_CDNS_40661956134505
* cell instance $26 r0 *1 4.415,51.16
X$26 4 2 M1_PSUB_CDNS_40661956134507
* cell instance $27 r0 *1 30.655,54.67
X$27 4 2 M1_PSUB_CDNS_40661956134508
* cell instance $28 r0 *1 30.655,55.44
X$28 4 2 M1_PSUB_CDNS_40661956134506
* cell instance $29 r0 *1 30.655,67.94
X$29 4 2 M1_PSUB_CDNS_40661956134506
* cell instance $30 r0 *1 30.655,46.88
X$30 4 2 M1_PSUB_CDNS_40661956134506
* cell instance $31 r0 *1 30.655,62.46
X$31 4 2 M1_PSUB_CDNS_40661956134506
* cell instance $32 r0 *1 30.655,60.92
X$32 4 2 M1_PSUB_CDNS_40661956134506
* cell instance $33 r0 *1 30.655,41.4
X$33 4 2 M1_PSUB_CDNS_40661956134506
* cell instance $34 r0 *1 30.655,48.42
X$34 4 2 M1_PSUB_CDNS_40661956134506
* cell instance $35 r0 *1 30.655,53.9
X$35 4 2 M1_PSUB_CDNS_40661956134506
* cell instance $36 r0 *1 30.655,61.69
X$36 4 2 M1_PSUB_CDNS_40661956134508
* cell instance $37 r0 *1 30.655,47.65
X$37 4 2 M1_PSUB_CDNS_40661956134508
* cell instance $38 r0 *1 56.895,65.2
X$38 4 2 M1_PSUB_CDNS_40661956134507
* cell instance $39 r0 *1 56.895,58.18
X$39 4 2 M1_PSUB_CDNS_40661956134507
* cell instance $40 r0 *1 56.895,51.16
X$40 4 2 M1_PSUB_CDNS_40661956134507
* cell instance $41 r0 *1 56.895,44.14
X$41 4 2 M1_PSUB_CDNS_40661956134507
* cell instance $42 r0 *1 4.415,65.2
X$42 4 2 M1_PSUB_CDNS_40661956134507
* cell instance $43 r0 *1 4.415,44.14
X$43 4 2 M1_PSUB_CDNS_40661956134507
* cell instance $44 r0 *1 4.415,58.18
X$44 4 2 M1_PSUB_CDNS_40661956134507
* cell instance $45 r0 *1 57.665,54.67
X$45 4 2 M1_PSUB_CDNS_40661956134505
* cell instance $46 r0 *1 30.655,68.71
X$46 4 2 M1_PSUB_CDNS_40661956134504
* cell instance $47 r0 *1 1.385,54.67
X$47 3 5 31 3 M1_NWELL_CDNS_40661956134515
* cell instance $48 r0 *1 59.925,54.67
X$48 3 5 31 3 M1_NWELL_CDNS_40661956134515
* cell instance $49 r0 *1 30.655,38.42
X$49 3 5 3 31 M1_NWELL_CDNS_40661956134510
* cell instance $50 r0 *1 30.655,70.92
X$50 3 5 3 31 M1_NWELL_CDNS_40661956134510
* cell instance $51 r90 *1 55.655,5.605
X$51 30 3 7 pn_6p0_CDNS_4066195613452
* cell instance $52 r90 *1 55.655,12.625
X$52 30 3 7 pn_6p0_CDNS_4066195613452
* cell instance $53 r90 *1 55.655,19.645
X$53 30 3 7 pn_6p0_CDNS_4066195613452
* cell instance $54 r90 *1 55.655,26.665
X$54 30 3 7 pn_6p0_CDNS_4066195613452
* cell instance $55 r0 *1 4.085,17.635
X$55 3 10 M2_M1_CDNS_40661956134511
* cell instance $56 r0 *1 12.605,3.98
X$56 3 15 M2_M1_CDNS_40661956134250
* cell instance $57 r0 *1 23.965,3.98
X$57 3 20 M2_M1_CDNS_40661956134250
* cell instance $58 m90 *1 37.345,3.98
X$58 3 24 M2_M1_CDNS_40661956134250
* cell instance $59 m90 *1 48.705,3.98
X$59 3 28 M2_M1_CDNS_40661956134250
* cell instance $60 m90 *1 57.225,17.635
X$60 3 9 M2_M1_CDNS_40661956134511
* cell instance $61 r0 *1 12.605,10.615
X$61 3 15 M2_M1_CDNS_40661956134207
* cell instance $62 r0 *1 23.965,10.615
X$62 3 20 M2_M1_CDNS_40661956134207
* cell instance $63 m90 *1 37.345,10.615
X$63 3 24 M2_M1_CDNS_40661956134207
* cell instance $64 m90 *1 48.705,10.615
X$64 3 28 M2_M1_CDNS_40661956134207
* cell instance $65 r0 *1 12.605,17.635
X$65 3 15 M2_M1_CDNS_40661956134207
* cell instance $66 r0 *1 23.965,17.635
X$66 3 20 M2_M1_CDNS_40661956134207
* cell instance $67 m90 *1 37.345,17.635
X$67 3 24 M2_M1_CDNS_40661956134207
* cell instance $68 m90 *1 48.705,17.635
X$68 3 28 M2_M1_CDNS_40661956134207
* cell instance $69 r0 *1 12.605,24.655
X$69 3 15 M2_M1_CDNS_40661956134207
* cell instance $70 r0 *1 23.965,24.655
X$70 3 20 M2_M1_CDNS_40661956134207
* cell instance $71 m90 *1 37.345,24.655
X$71 3 24 M2_M1_CDNS_40661956134207
* cell instance $72 m90 *1 48.705,24.655
X$72 3 28 M2_M1_CDNS_40661956134207
* cell instance $73 r0 *1 12.605,31.29
X$73 3 15 M2_M1_CDNS_40661956134250
* cell instance $74 r0 *1 23.965,31.29
X$74 3 20 M2_M1_CDNS_40661956134250
* cell instance $75 m90 *1 37.345,31.29
X$75 3 24 M2_M1_CDNS_40661956134250
* cell instance $76 m90 *1 48.705,31.29
X$76 3 28 M2_M1_CDNS_40661956134250
* cell instance $77 r0 *1 4.085,38.42
X$77 3 10 M2_M1_CDNS_40661956134516
* cell instance $78 r0 *1 12.605,38.42
X$78 3 15 M2_M1_CDNS_40661956134516
* cell instance $79 r0 *1 23.965,38.42
X$79 3 20 M2_M1_CDNS_40661956134516
* cell instance $80 m90 *1 37.345,38.42
X$80 3 24 M2_M1_CDNS_40661956134516
* cell instance $81 m90 *1 48.705,38.42
X$81 3 28 M2_M1_CDNS_40661956134516
* cell instance $82 m90 *1 57.225,38.42
X$82 3 9 M2_M1_CDNS_40661956134516
* cell instance $83 r0 *1 4.085,70.92
X$83 3 10 M2_M1_CDNS_40661956134516
* cell instance $84 r0 *1 12.605,70.92
X$84 3 15 M2_M1_CDNS_40661956134516
* cell instance $85 r0 *1 23.965,70.92
X$85 3 20 M2_M1_CDNS_40661956134516
* cell instance $86 m90 *1 37.345,70.92
X$86 3 24 M2_M1_CDNS_40661956134516
* cell instance $87 m90 *1 48.705,70.92
X$87 3 28 M2_M1_CDNS_40661956134516
* cell instance $88 m90 *1 57.225,70.92
X$88 3 9 M2_M1_CDNS_40661956134516
* cell instance $89 r0 *1 1.615,17.635
X$89 4 12 M2_M1_CDNS_40661956134509
* cell instance $90 r0 *1 1.385,17.635
X$90 4 6 M1_PSUB_CDNS_40661956134512
* cell instance $91 r0 *1 59.925,17.635
X$91 4 6 M1_PSUB_CDNS_40661956134512
* cell instance $92 r0 *1 59.695,17.635
X$92 4 11 M2_M1_CDNS_40661956134513
* cell instance $93 m90 *1 59.695,17.635
X$93 4 11 M2_M1_CDNS_40661956134509
* cell instance $94 r0 *1 6.925,1.385
X$94 4 8 M2_M1_CDNS_40661956134516
* cell instance $95 r0 *1 30.655,1.385
X$95 4 6 M1_PSUB_CDNS_40661956134514
* cell instance $96 r0 *1 18.285,1.385
X$96 4 16 M2_M1_CDNS_40661956134516
* cell instance $97 r0 *1 29.44,1.385
X$97 4 22 M2_M1_CDNS_40661956134517
* cell instance $98 m90 *1 31.87,1.385
X$98 4 18 M2_M1_CDNS_40661956134517
* cell instance $99 m90 *1 43.025,1.385
X$99 4 26 M2_M1_CDNS_40661956134516
* cell instance $100 m90 *1 54.385,1.385
X$100 4 13 M2_M1_CDNS_40661956134516
* cell instance $101 r0 *1 6.925,33.885
X$101 4 8 M2_M1_CDNS_40661956134516
* cell instance $102 r0 *1 30.655,33.885
X$102 4 6 M1_PSUB_CDNS_40661956134514
* cell instance $103 r0 *1 18.285,33.885
X$103 4 16 M2_M1_CDNS_40661956134516
* cell instance $104 r0 *1 29.44,33.885
X$104 4 22 M2_M1_CDNS_40661956134517
* cell instance $105 m90 *1 31.87,33.885
X$105 4 18 M2_M1_CDNS_40661956134517
* cell instance $106 m90 *1 43.025,33.885
X$106 4 26 M2_M1_CDNS_40661956134516
* cell instance $107 m90 *1 54.385,33.885
X$107 4 13 M2_M1_CDNS_40661956134516
* cell instance $108 r0 *1 6.925,41.015
X$108 4 8 M2_M1_CDNS_40661956134250
* cell instance $109 r0 *1 18.285,41.015
X$109 4 16 M2_M1_CDNS_40661956134250
* cell instance $110 r0 *1 29.44,41.015
X$110 4 22 M2_M1_CDNS_40661956134488
* cell instance $111 m90 *1 31.87,41.015
X$111 4 18 M2_M1_CDNS_40661956134488
* cell instance $112 m90 *1 43.025,41.015
X$112 4 26 M2_M1_CDNS_40661956134250
* cell instance $113 m90 *1 54.385,41.015
X$113 4 13 M2_M1_CDNS_40661956134250
* cell instance $114 r0 *1 6.925,68.325
X$114 4 8 M2_M1_CDNS_40661956134250
* cell instance $115 r0 *1 18.285,68.325
X$115 4 16 M2_M1_CDNS_40661956134250
* cell instance $116 r0 *1 29.44,68.325
X$116 4 22 M2_M1_CDNS_40661956134488
* cell instance $117 m90 *1 31.87,68.325
X$117 4 18 M2_M1_CDNS_40661956134488
* cell instance $118 m90 *1 43.025,68.325
X$118 4 26 M2_M1_CDNS_40661956134250
* cell instance $119 m90 *1 54.385,68.325
X$119 4 13 M2_M1_CDNS_40661956134250
* cell instance $120 r0 *1 6.925,47.65
X$120 4 8 M2_M1_CDNS_40661956134207
* cell instance $121 r0 *1 18.285,47.65
X$121 4 16 M2_M1_CDNS_40661956134207
* cell instance $122 r0 *1 29.44,47.65
X$122 4 22 M2_M1_CDNS_40661956134489
* cell instance $123 m90 *1 31.87,47.65
X$123 4 18 M2_M1_CDNS_40661956134489
* cell instance $124 m90 *1 43.025,47.65
X$124 4 26 M2_M1_CDNS_40661956134207
* cell instance $125 m90 *1 54.385,47.65
X$125 4 13 M2_M1_CDNS_40661956134207
* cell instance $126 r0 *1 6.925,54.67
X$126 4 8 M2_M1_CDNS_40661956134207
* cell instance $127 r0 *1 18.285,54.67
X$127 4 16 M2_M1_CDNS_40661956134207
* cell instance $128 r0 *1 29.44,54.67
X$128 4 22 M2_M1_CDNS_40661956134489
* cell instance $129 m90 *1 31.87,54.67
X$129 4 18 M2_M1_CDNS_40661956134489
* cell instance $130 m90 *1 43.025,54.67
X$130 4 26 M2_M1_CDNS_40661956134207
* cell instance $131 m90 *1 54.385,54.67
X$131 4 13 M2_M1_CDNS_40661956134207
* cell instance $132 r0 *1 6.925,61.69
X$132 4 8 M2_M1_CDNS_40661956134207
* cell instance $133 r0 *1 18.285,61.69
X$133 4 16 M2_M1_CDNS_40661956134207
* cell instance $134 r0 *1 29.44,61.69
X$134 4 22 M2_M1_CDNS_40661956134489
* cell instance $135 m90 *1 31.87,61.69
X$135 4 18 M2_M1_CDNS_40661956134489
* cell instance $136 m90 *1 43.025,61.69
X$136 4 26 M2_M1_CDNS_40661956134207
* cell instance $137 m90 *1 54.385,61.69
X$137 4 13 M2_M1_CDNS_40661956134207
* cell instance $138 r0 *1 9.765,7.105
X$138 30 14 M2_M1_CDNS_40661956134496
* cell instance $139 r0 *1 9.765,44.14
X$139 30 14 M2_M1_CDNS_40661956134496
* cell instance $140 r0 *1 9.765,28.165
X$140 30 14 M2_M1_CDNS_40661956134496
* cell instance $141 r0 *1 9.765,65.2
X$141 30 14 M2_M1_CDNS_40661956134496
* cell instance $142 r0 *1 9.765,58.18
X$142 30 14 M2_M1_CDNS_40661956134496
* cell instance $143 r0 *1 9.765,51.16
X$143 30 14 M2_M1_CDNS_40661956134496
* cell instance $144 r0 *1 9.765,21.145
X$144 30 14 M2_M1_CDNS_40661956134496
* cell instance $145 r0 *1 9.765,14.125
X$145 30 14 M2_M1_CDNS_40661956134496
* cell instance $146 r0 *1 15.445,51.16
X$146 30 17 M2_M1_CDNS_40661956134496
* cell instance $147 r0 *1 15.445,65.2
X$147 30 17 M2_M1_CDNS_40661956134496
* cell instance $148 r0 *1 15.445,58.18
X$148 30 17 M2_M1_CDNS_40661956134496
* cell instance $149 r0 *1 15.445,14.125
X$149 30 17 M2_M1_CDNS_40661956134496
* cell instance $150 r0 *1 15.445,7.105
X$150 30 17 M2_M1_CDNS_40661956134496
* cell instance $151 r0 *1 15.445,28.165
X$151 30 17 M2_M1_CDNS_40661956134496
* cell instance $152 r0 *1 15.445,21.145
X$152 30 17 M2_M1_CDNS_40661956134496
* cell instance $153 r0 *1 15.445,44.14
X$153 30 17 M2_M1_CDNS_40661956134496
* cell instance $154 r0 *1 26.805,51.16
X$154 30 19 M2_M1_CDNS_40661956134496
* cell instance $155 r0 *1 26.805,44.14
X$155 30 19 M2_M1_CDNS_40661956134496
* cell instance $156 r0 *1 26.805,58.18
X$156 30 19 M2_M1_CDNS_40661956134496
* cell instance $157 r0 *1 26.805,65.2
X$157 30 19 M2_M1_CDNS_40661956134496
* cell instance $158 r0 *1 26.805,7.105
X$158 30 19 M2_M1_CDNS_40661956134496
* cell instance $159 r0 *1 26.805,14.125
X$159 30 19 M2_M1_CDNS_40661956134496
* cell instance $160 r0 *1 26.805,21.145
X$160 30 19 M2_M1_CDNS_40661956134496
* cell instance $161 r0 *1 26.805,28.165
X$161 30 19 M2_M1_CDNS_40661956134496
* cell instance $162 r0 *1 21.125,51.16
X$162 30 21 M2_M1_CDNS_40661956134496
* cell instance $163 r0 *1 21.125,65.2
X$163 30 21 M2_M1_CDNS_40661956134496
* cell instance $164 r0 *1 21.125,58.18
X$164 30 21 M2_M1_CDNS_40661956134496
* cell instance $165 r0 *1 21.125,44.14
X$165 30 21 M2_M1_CDNS_40661956134496
* cell instance $166 r0 *1 21.125,14.125
X$166 30 21 M2_M1_CDNS_40661956134496
* cell instance $167 r0 *1 21.125,7.105
X$167 30 21 M2_M1_CDNS_40661956134496
* cell instance $168 r0 *1 21.125,21.145
X$168 30 21 M2_M1_CDNS_40661956134496
* cell instance $169 r0 *1 21.125,28.165
X$169 30 21 M2_M1_CDNS_40661956134496
* cell instance $170 r0 *1 34.505,65.2
X$170 30 23 M2_M1_CDNS_40661956134496
* cell instance $171 r0 *1 34.505,44.14
X$171 30 23 M2_M1_CDNS_40661956134496
* cell instance $172 r0 *1 34.505,51.16
X$172 30 23 M2_M1_CDNS_40661956134496
* cell instance $173 r0 *1 34.505,58.18
X$173 30 23 M2_M1_CDNS_40661956134496
* cell instance $174 r0 *1 34.505,21.145
X$174 30 23 M2_M1_CDNS_40661956134496
* cell instance $175 r0 *1 34.505,28.165
X$175 30 23 M2_M1_CDNS_40661956134496
* cell instance $176 r0 *1 34.505,14.125
X$176 30 23 M2_M1_CDNS_40661956134496
* cell instance $177 r0 *1 34.505,7.105
X$177 30 23 M2_M1_CDNS_40661956134496
* cell instance $178 r0 *1 40.185,65.2
X$178 30 25 M2_M1_CDNS_40661956134496
* cell instance $179 r0 *1 40.185,51.16
X$179 30 25 M2_M1_CDNS_40661956134496
* cell instance $180 r0 *1 40.185,44.14
X$180 30 25 M2_M1_CDNS_40661956134496
* cell instance $181 r0 *1 40.185,58.18
X$181 30 25 M2_M1_CDNS_40661956134496
* cell instance $182 r0 *1 40.185,21.145
X$182 30 25 M2_M1_CDNS_40661956134496
* cell instance $183 r0 *1 40.185,28.165
X$183 30 25 M2_M1_CDNS_40661956134496
* cell instance $184 r0 *1 40.185,14.125
X$184 30 25 M2_M1_CDNS_40661956134496
* cell instance $185 r0 *1 40.185,7.105
X$185 30 25 M2_M1_CDNS_40661956134496
* cell instance $186 r0 *1 45.865,44.14
X$186 30 27 M2_M1_CDNS_40661956134496
* cell instance $187 r0 *1 45.865,51.16
X$187 30 27 M2_M1_CDNS_40661956134496
* cell instance $188 r0 *1 45.865,58.18
X$188 30 27 M2_M1_CDNS_40661956134496
* cell instance $189 r0 *1 45.865,65.2
X$189 30 27 M2_M1_CDNS_40661956134496
* cell instance $190 r0 *1 45.865,21.145
X$190 30 27 M2_M1_CDNS_40661956134496
* cell instance $191 r0 *1 45.865,14.125
X$191 30 27 M2_M1_CDNS_40661956134496
* cell instance $192 r0 *1 45.865,7.105
X$192 30 27 M2_M1_CDNS_40661956134496
* cell instance $193 r0 *1 45.865,28.165
X$193 30 27 M2_M1_CDNS_40661956134496
* cell instance $194 r0 *1 51.545,65.2
X$194 30 29 M2_M1_CDNS_40661956134496
* cell instance $195 r0 *1 51.545,51.16
X$195 30 29 M2_M1_CDNS_40661956134496
* cell instance $196 r0 *1 51.545,44.14
X$196 30 29 M2_M1_CDNS_40661956134496
* cell instance $197 r0 *1 51.545,58.18
X$197 30 29 M2_M1_CDNS_40661956134496
* cell instance $198 r0 *1 51.545,21.145
X$198 30 29 M2_M1_CDNS_40661956134496
* cell instance $199 r0 *1 51.545,28.165
X$199 30 29 M2_M1_CDNS_40661956134496
* cell instance $200 r0 *1 51.545,14.125
X$200 30 29 M2_M1_CDNS_40661956134496
* cell instance $201 r0 *1 51.545,7.105
X$201 30 29 M2_M1_CDNS_40661956134496
* cell instance $202 r90 *1 55.655,42.64
X$202 30 np_6p0_CDNS_4066195613453
* cell instance $203 r90 *1 55.655,63.7
X$203 30 np_6p0_CDNS_4066195613453
* cell instance $204 r90 *1 55.655,56.68
X$204 30 np_6p0_CDNS_4066195613453
* cell instance $205 r90 *1 55.655,49.66
X$205 30 np_6p0_CDNS_4066195613453
* device instance $1 r0 *1 30.655,7.105 pn_6p0
D$1 30 3 pn_6p0 A=150P P=106U
* device instance $2 r0 *1 30.655,14.125 pn_6p0
D$2 30 3 pn_6p0 A=150P P=106U
* device instance $3 r0 *1 30.655,21.145 pn_6p0
D$3 30 3 pn_6p0 A=150P P=106U
* device instance $4 r0 *1 30.655,28.165 pn_6p0
D$4 30 3 pn_6p0 A=150P P=106U
.ENDS comp018green_esd_hbm

* cell M1_PSUB_CDNS_40661956134486
* pin
* pin
.SUBCKT M1_PSUB_CDNS_40661956134486 1 2
.ENDS M1_PSUB_CDNS_40661956134486

* cell M1_PSUB_CDNS_40661956134485
* pin
* pin
.SUBCKT M1_PSUB_CDNS_40661956134485 1 2
.ENDS M1_PSUB_CDNS_40661956134485

* cell M1_PSUB_CDNS_40661956134482
* pin
* pin
.SUBCKT M1_PSUB_CDNS_40661956134482 1 2
.ENDS M1_PSUB_CDNS_40661956134482

* cell M1_NWELL_CDNS_40661956134487
* pin
* pin
* pin
* pin
.SUBCKT M1_NWELL_CDNS_40661956134487 1 2 3 4
.ENDS M1_NWELL_CDNS_40661956134487

* cell M1_PSUB_CDNS_40661956134198
* pin
* pin
.SUBCKT M1_PSUB_CDNS_40661956134198 1 2
.ENDS M1_PSUB_CDNS_40661956134198

* cell M1_PSUB_CDNS_40661956134200
* pin
* pin
.SUBCKT M1_PSUB_CDNS_40661956134200 1 2
.ENDS M1_PSUB_CDNS_40661956134200

* cell M3_M2_CDNS_40661956134225
* pin
* pin
.SUBCKT M3_M2_CDNS_40661956134225 1 2
.ENDS M3_M2_CDNS_40661956134225

* cell nmoscap_6p0_CDNS_406619561348
* pin
* pin
.SUBCKT nmoscap_6p0_CDNS_406619561348 1 2
* device instance $1 r0 *1 7.5,7.5 nmoscap_6p0
C$1 2 1 5.175e-13 nmoscap_6p0 A=225P P=60U
.ENDS nmoscap_6p0_CDNS_406619561348

* cell np_6p0_CDNS_406619561349
* pin
.SUBCKT np_6p0_CDNS_406619561349 1
.ENDS np_6p0_CDNS_406619561349

* cell 3LM_METAL_RAIL
* pin
* pin DVSS
* pin VSS
* pin VDD
* pin DVDD
* pin
.SUBCKT 3LM_METAL_RAIL 1 2 3 4 5 6
* net 2 DVSS
* net 3 VSS
* net 4 VDD
* net 5 DVDD
* cell instance $1 r0 *1 0.24,207.62
X$1 6 1 M1_PSUB_CDNS_40661956134176
* cell instance $2 r0 *1 37.665,349.365
X$2 6 1 M1_PSUB_CDNS_40661956134192
* cell instance $3 r0 *1 37.665,65.96
X$3 6 1 M1_PSUB_CDNS_40661956134192
* cell instance $4 r0 *1 74.76,207.62
X$4 6 1 M1_PSUB_CDNS_40661956134176
.ENDS 3LM_METAL_RAIL

* cell Bondpad_3LM
* pin
* pin
.SUBCKT Bondpad_3LM 1 2
* cell instance $1 r0 *1 32.035,1.015
X$1 2 1 M3_M2_CDNS_40661956134196
* cell instance $2 r0 *1 32.04,63.675
X$2 2 1 M3_M2_CDNS_40661956134195
* cell instance $3 r90 *1 64.01,31.27
X$3 2 1 M3_M2_CDNS_40661956134194
* cell instance $4 r90 *1 34.205,31.945
X$4 2 1 M3_M2_CDNS_40661956134193
* cell instance $5 r90 *1 60.2,31.945
X$5 2 1 M3_M2_CDNS_40661956134193
* cell instance $6 r90 *1 36.22,31.945
X$6 2 1 M3_M2_CDNS_40661956134193
* cell instance $7 r90 *1 38.19,31.945
X$7 2 1 M3_M2_CDNS_40661956134193
* cell instance $8 r90 *1 40.195,31.945
X$8 2 1 M3_M2_CDNS_40661956134193
* cell instance $9 r90 *1 42.195,31.945
X$9 2 1 M3_M2_CDNS_40661956134193
* cell instance $10 r90 *1 44.18,31.945
X$10 2 1 M3_M2_CDNS_40661956134193
* cell instance $11 r90 *1 46.165,31.945
X$11 2 1 M3_M2_CDNS_40661956134193
* cell instance $12 r90 *1 48.185,31.945
X$12 2 1 M3_M2_CDNS_40661956134193
* cell instance $13 r90 *1 50.165,31.945
X$13 2 1 M3_M2_CDNS_40661956134193
* cell instance $14 r90 *1 52.165,31.945
X$14 2 1 M3_M2_CDNS_40661956134193
* cell instance $15 r90 *1 54.15,31.945
X$15 2 1 M3_M2_CDNS_40661956134193
* cell instance $16 r90 *1 56.175,31.945
X$16 2 1 M3_M2_CDNS_40661956134193
* cell instance $17 r90 *1 58.175,31.945
X$17 2 1 M3_M2_CDNS_40661956134193
* cell instance $18 r90 *1 32.195,31.945
X$18 2 1 M3_M2_CDNS_40661956134193
* cell instance $19 r90 *1 6.205,31.945
X$19 2 1 M3_M2_CDNS_40661956134193
* cell instance $20 r90 *1 8.205,31.945
X$20 2 1 M3_M2_CDNS_40661956134193
* cell instance $21 r90 *1 10.19,31.945
X$21 2 1 M3_M2_CDNS_40661956134193
* cell instance $22 r90 *1 12.175,31.945
X$22 2 1 M3_M2_CDNS_40661956134193
* cell instance $23 r90 *1 14.195,31.945
X$23 2 1 M3_M2_CDNS_40661956134193
* cell instance $24 r90 *1 16.175,31.945
X$24 2 1 M3_M2_CDNS_40661956134193
* cell instance $25 r90 *1 18.175,31.945
X$25 2 1 M3_M2_CDNS_40661956134193
* cell instance $26 r90 *1 20.16,31.945
X$26 2 1 M3_M2_CDNS_40661956134193
* cell instance $27 r90 *1 22.185,31.945
X$27 2 1 M3_M2_CDNS_40661956134193
* cell instance $28 r90 *1 24.185,31.945
X$28 2 1 M3_M2_CDNS_40661956134193
* cell instance $29 r90 *1 26.21,31.945
X$29 2 1 M3_M2_CDNS_40661956134193
* cell instance $30 r90 *1 28.195,31.945
X$30 2 1 M3_M2_CDNS_40661956134193
* cell instance $31 r90 *1 4.2,31.945
X$31 2 1 M3_M2_CDNS_40661956134193
* cell instance $32 r90 *1 30.18,31.945
X$32 2 1 M3_M2_CDNS_40661956134193
* cell instance $33 r90 *1 -0.05,31.27
X$33 2 1 M3_M2_CDNS_40661956134194
.ENDS Bondpad_3LM

* cell M3_M2_CDNS_40661956134180
* pin
* pin
.SUBCKT M3_M2_CDNS_40661956134180 1 2
.ENDS M3_M2_CDNS_40661956134180

* cell M3_M2_CDNS_40661956134193
* pin
* pin
.SUBCKT M3_M2_CDNS_40661956134193 1 2
.ENDS M3_M2_CDNS_40661956134193

* cell M3_M2_CDNS_40661956134194
* pin
* pin
.SUBCKT M3_M2_CDNS_40661956134194 1 2
.ENDS M3_M2_CDNS_40661956134194

* cell M3_M2_CDNS_40661956134195
* pin
* pin
.SUBCKT M3_M2_CDNS_40661956134195 1 2
.ENDS M3_M2_CDNS_40661956134195

* cell M3_M2_CDNS_40661956134196
* pin
* pin
.SUBCKT M3_M2_CDNS_40661956134196 1 2
.ENDS M3_M2_CDNS_40661956134196

* cell M2_M1_CDNS_40661956134231
* pin
* pin
.SUBCKT M2_M1_CDNS_40661956134231 1 2
.ENDS M2_M1_CDNS_40661956134231

* cell M2_M1_CDNS_40661956134239
* pin
* pin
.SUBCKT M2_M1_CDNS_40661956134239 1 2
.ENDS M2_M1_CDNS_40661956134239

* cell M2_M1_CDNS_40661956134241
* pin
* pin
.SUBCKT M2_M1_CDNS_40661956134241 1 2
.ENDS M2_M1_CDNS_40661956134241

* cell nmos_clamp_20_50_4_DVDD
* pin
* pin
* pin
* pin
* pin
* pin
* pin
* pin
* pin
* pin
* pin
* pin
* pin
* pin
* pin
* pin
* pin gf180mcu_gnd
.SUBCKT nmos_clamp_20_50_4_DVDD 1 3 5 6 7 8 9 10 11 12 13 14 15 16 17 18 19
* net 19 gf180mcu_gnd
* cell instance $1 r90 *1 57.405,66.125
X$1 3 5 3 5 3 5 3 5 3 5 3 5 3 5 3 5 3 5 3 5 3 1 1 1 1 1 1 1 1 1 1 1 1 1 1 1 1 1
+ 1 1 1 19 nmos_6p0_CDNS_406619561341
* cell instance $2 r90 *1 57.405,36.765
X$2 3 5 3 5 3 5 3 5 3 5 3 5 3 5 3 5 3 5 3 5 3 1 1 1 1 1 1 1 1 1 1 1 1 1 1 1 1 1
+ 1 1 1 19 nmos_6p0_CDNS_406619561341
* cell instance $3 r90 *1 57.405,7.405
X$3 3 5 3 5 3 5 3 5 3 5 3 5 3 5 3 5 3 5 3 5 3 1 1 1 1 1 1 1 1 1 1 1 1 1 1 1 1 1
+ 1 1 1 19 nmos_6p0_CDNS_406619561341
* cell instance $4 r90 *1 57.405,95.485
X$4 3 5 3 5 3 5 3 5 3 5 3 5 3 5 3 5 3 5 3 5 3 1 1 1 1 1 1 1 1 1 1 1 1 1 1 1 1 1
+ 1 1 1 19 nmos_6p0_CDNS_406619561341
* cell instance $5 r0 *1 58.245,48.705
X$5 1 16 M2_M1_CDNS_40661956134141
* cell instance $6 m90 *1 58.165,48.705
X$6 1 M1_POLY2_CDNS_40661956134136
* cell instance $7 r0 *1 58.245,19.345
X$7 1 16 M2_M1_CDNS_40661956134141
* cell instance $8 m90 *1 58.165,19.345
X$8 1 M1_POLY2_CDNS_40661956134136
* cell instance $9 r0 *1 58.245,78.065
X$9 1 16 M2_M1_CDNS_40661956134141
* cell instance $10 m90 *1 58.165,78.065
X$10 1 M1_POLY2_CDNS_40661956134136
* cell instance $11 r0 *1 58.245,107.425
X$11 1 16 M2_M1_CDNS_40661956134141
* cell instance $12 m90 *1 58.165,107.425
X$12 1 M1_POLY2_CDNS_40661956134136
* cell instance $13 r0 *1 6.645,19.345
X$13 1 M1_POLY2_CDNS_40661956134136
* cell instance $14 r0 *1 6.565,19.345
X$14 1 7 M2_M1_CDNS_40661956134141
* cell instance $15 r0 *1 6.645,78.065
X$15 1 M1_POLY2_CDNS_40661956134136
* cell instance $16 r0 *1 6.565,78.065
X$16 1 7 M2_M1_CDNS_40661956134141
* cell instance $17 r0 *1 6.645,107.425
X$17 1 M1_POLY2_CDNS_40661956134136
* cell instance $18 r0 *1 6.565,107.425
X$18 1 7 M2_M1_CDNS_40661956134141
* cell instance $19 r0 *1 6.645,48.705
X$19 1 M1_POLY2_CDNS_40661956134136
* cell instance $20 r0 *1 6.565,48.705
X$20 1 7 M2_M1_CDNS_40661956134141
* cell instance $21 r0 *1 32.405,125.635
X$21 3 20 3 2 M1_NWELL_CDNS_40661956134139
* cell instance $22 r0 *1 32.405,1.135
X$22 3 20 3 2 M1_NWELL_CDNS_40661956134139
* cell instance $23 r0 *1 63.675,63.385
X$23 3 2 3 20 M1_NWELL_CDNS_40661956134135
* cell instance $24 r0 *1 1.135,63.385
X$24 3 2 3 20 M1_NWELL_CDNS_40661956134135
* cell instance $25 r0 *1 13.79,107.425
X$25 3 15 M2_M1_CDNS_40661956134249
* cell instance $26 r0 *1 25.64,107.425
X$26 3 13 M2_M1_CDNS_40661956134249
* cell instance $27 m90 *1 39.17,107.425
X$27 3 11 M2_M1_CDNS_40661956134249
* cell instance $28 m90 *1 51.02,107.425
X$28 3 9 M2_M1_CDNS_40661956134249
* cell instance $29 r0 *1 13.79,109.865
X$29 3 15 M2_M1_CDNS_40661956134249
* cell instance $30 r0 *1 25.64,109.865
X$30 3 13 M2_M1_CDNS_40661956134249
* cell instance $31 m90 *1 39.17,109.865
X$31 3 11 M2_M1_CDNS_40661956134249
* cell instance $32 m90 *1 51.02,109.865
X$32 3 9 M2_M1_CDNS_40661956134249
* cell instance $33 r0 *1 13.79,21.785
X$33 3 15 M2_M1_CDNS_40661956134249
* cell instance $34 r0 *1 25.64,21.785
X$34 3 13 M2_M1_CDNS_40661956134249
* cell instance $35 m90 *1 39.17,21.785
X$35 3 11 M2_M1_CDNS_40661956134249
* cell instance $36 m90 *1 51.02,21.785
X$36 3 9 M2_M1_CDNS_40661956134249
* cell instance $37 r0 *1 13.79,97.665
X$37 3 15 M2_M1_CDNS_40661956134249
* cell instance $38 r0 *1 25.64,97.665
X$38 3 13 M2_M1_CDNS_40661956134249
* cell instance $39 m90 *1 39.17,97.665
X$39 3 11 M2_M1_CDNS_40661956134249
* cell instance $40 m90 *1 51.02,97.665
X$40 3 9 M2_M1_CDNS_40661956134249
* cell instance $41 r0 *1 13.79,114.745
X$41 3 15 M2_M1_CDNS_40661956134249
* cell instance $42 r0 *1 25.64,114.745
X$42 3 13 M2_M1_CDNS_40661956134249
* cell instance $43 m90 *1 39.17,114.745
X$43 3 11 M2_M1_CDNS_40661956134249
* cell instance $44 m90 *1 51.02,114.745
X$44 3 9 M2_M1_CDNS_40661956134249
* cell instance $45 r0 *1 13.79,9.585
X$45 3 15 M2_M1_CDNS_40661956134249
* cell instance $46 r0 *1 25.64,9.585
X$46 3 13 M2_M1_CDNS_40661956134249
* cell instance $47 m90 *1 39.17,9.585
X$47 3 11 M2_M1_CDNS_40661956134249
* cell instance $48 m90 *1 51.02,9.585
X$48 3 9 M2_M1_CDNS_40661956134249
* cell instance $49 r0 *1 13.79,12.025
X$49 3 15 M2_M1_CDNS_40661956134249
* cell instance $50 r0 *1 25.64,12.025
X$50 3 13 M2_M1_CDNS_40661956134249
* cell instance $51 m90 *1 39.17,12.025
X$51 3 11 M2_M1_CDNS_40661956134249
* cell instance $52 m90 *1 51.02,12.025
X$52 3 9 M2_M1_CDNS_40661956134249
* cell instance $53 r0 *1 13.79,14.465
X$53 3 15 M2_M1_CDNS_40661956134249
* cell instance $54 r0 *1 25.64,14.465
X$54 3 13 M2_M1_CDNS_40661956134249
* cell instance $55 m90 *1 39.17,14.465
X$55 3 11 M2_M1_CDNS_40661956134249
* cell instance $56 m90 *1 51.02,14.465
X$56 3 9 M2_M1_CDNS_40661956134249
* cell instance $57 r0 *1 13.79,16.905
X$57 3 15 M2_M1_CDNS_40661956134249
* cell instance $58 r0 *1 25.64,16.905
X$58 3 13 M2_M1_CDNS_40661956134249
* cell instance $59 m90 *1 39.17,16.905
X$59 3 11 M2_M1_CDNS_40661956134249
* cell instance $60 m90 *1 51.02,16.905
X$60 3 9 M2_M1_CDNS_40661956134249
* cell instance $61 r0 *1 13.79,19.345
X$61 3 15 M2_M1_CDNS_40661956134249
* cell instance $62 r0 *1 25.64,19.345
X$62 3 13 M2_M1_CDNS_40661956134249
* cell instance $63 m90 *1 39.17,19.345
X$63 3 11 M2_M1_CDNS_40661956134249
* cell instance $64 m90 *1 51.02,19.345
X$64 3 9 M2_M1_CDNS_40661956134249
* cell instance $65 r0 *1 13.79,112.305
X$65 3 15 M2_M1_CDNS_40661956134249
* cell instance $66 r0 *1 25.64,112.305
X$66 3 13 M2_M1_CDNS_40661956134249
* cell instance $67 m90 *1 39.17,112.305
X$67 3 11 M2_M1_CDNS_40661956134249
* cell instance $68 m90 *1 51.02,112.305
X$68 3 9 M2_M1_CDNS_40661956134249
* cell instance $69 r0 *1 13.79,95.225
X$69 3 15 M2_M1_CDNS_40661956134249
* cell instance $70 r0 *1 25.64,95.225
X$70 3 13 M2_M1_CDNS_40661956134249
* cell instance $71 m90 *1 39.17,95.225
X$71 3 11 M2_M1_CDNS_40661956134249
* cell instance $72 m90 *1 51.02,95.225
X$72 3 9 M2_M1_CDNS_40661956134249
* cell instance $73 r0 *1 13.79,90.265
X$73 3 15 M2_M1_CDNS_40661956134249
* cell instance $74 r0 *1 25.64,90.265
X$74 3 13 M2_M1_CDNS_40661956134249
* cell instance $75 m90 *1 39.17,90.265
X$75 3 11 M2_M1_CDNS_40661956134249
* cell instance $76 m90 *1 51.02,90.265
X$76 3 9 M2_M1_CDNS_40661956134249
* cell instance $77 r0 *1 13.79,87.825
X$77 3 15 M2_M1_CDNS_40661956134249
* cell instance $78 r0 *1 25.64,87.825
X$78 3 13 M2_M1_CDNS_40661956134249
* cell instance $79 m90 *1 39.17,87.825
X$79 3 11 M2_M1_CDNS_40661956134249
* cell instance $80 m90 *1 51.02,87.825
X$80 3 9 M2_M1_CDNS_40661956134249
* cell instance $81 r0 *1 13.79,85.385
X$81 3 15 M2_M1_CDNS_40661956134249
* cell instance $82 r0 *1 25.64,85.385
X$82 3 13 M2_M1_CDNS_40661956134249
* cell instance $83 m90 *1 39.17,85.385
X$83 3 11 M2_M1_CDNS_40661956134249
* cell instance $84 m90 *1 51.02,85.385
X$84 3 9 M2_M1_CDNS_40661956134249
* cell instance $85 r0 *1 13.79,82.945
X$85 3 15 M2_M1_CDNS_40661956134249
* cell instance $86 r0 *1 25.64,82.945
X$86 3 13 M2_M1_CDNS_40661956134249
* cell instance $87 m90 *1 39.17,82.945
X$87 3 11 M2_M1_CDNS_40661956134249
* cell instance $88 m90 *1 51.02,82.945
X$88 3 9 M2_M1_CDNS_40661956134249
* cell instance $89 r0 *1 13.79,80.505
X$89 3 15 M2_M1_CDNS_40661956134249
* cell instance $90 r0 *1 25.64,80.505
X$90 3 13 M2_M1_CDNS_40661956134249
* cell instance $91 m90 *1 39.17,80.505
X$91 3 11 M2_M1_CDNS_40661956134249
* cell instance $92 m90 *1 51.02,80.505
X$92 3 9 M2_M1_CDNS_40661956134249
* cell instance $93 r0 *1 13.79,78.065
X$93 3 15 M2_M1_CDNS_40661956134249
* cell instance $94 r0 *1 25.64,78.065
X$94 3 13 M2_M1_CDNS_40661956134249
* cell instance $95 m90 *1 39.17,78.065
X$95 3 11 M2_M1_CDNS_40661956134249
* cell instance $96 m90 *1 51.02,78.065
X$96 3 9 M2_M1_CDNS_40661956134249
* cell instance $97 r0 *1 13.79,102.545
X$97 3 15 M2_M1_CDNS_40661956134249
* cell instance $98 r0 *1 25.64,102.545
X$98 3 13 M2_M1_CDNS_40661956134249
* cell instance $99 m90 *1 39.17,102.545
X$99 3 11 M2_M1_CDNS_40661956134249
* cell instance $100 m90 *1 51.02,102.545
X$100 3 9 M2_M1_CDNS_40661956134249
* cell instance $101 r0 *1 13.79,104.985
X$101 3 15 M2_M1_CDNS_40661956134249
* cell instance $102 r0 *1 25.64,104.985
X$102 3 13 M2_M1_CDNS_40661956134249
* cell instance $103 m90 *1 39.17,104.985
X$103 3 11 M2_M1_CDNS_40661956134249
* cell instance $104 m90 *1 51.02,104.985
X$104 3 9 M2_M1_CDNS_40661956134249
* cell instance $105 r0 *1 13.79,73.185
X$105 3 15 M2_M1_CDNS_40661956134249
* cell instance $106 r0 *1 25.64,73.185
X$106 3 13 M2_M1_CDNS_40661956134249
* cell instance $107 m90 *1 39.17,73.185
X$107 3 11 M2_M1_CDNS_40661956134249
* cell instance $108 m90 *1 51.02,73.185
X$108 3 9 M2_M1_CDNS_40661956134249
* cell instance $109 r0 *1 13.79,75.625
X$109 3 15 M2_M1_CDNS_40661956134249
* cell instance $110 r0 *1 25.64,75.625
X$110 3 13 M2_M1_CDNS_40661956134249
* cell instance $111 m90 *1 39.17,75.625
X$111 3 11 M2_M1_CDNS_40661956134249
* cell instance $112 m90 *1 51.02,75.625
X$112 3 9 M2_M1_CDNS_40661956134249
* cell instance $113 r0 *1 13.79,119.625
X$113 3 15 M2_M1_CDNS_40661956134249
* cell instance $114 r0 *1 25.64,119.625
X$114 3 13 M2_M1_CDNS_40661956134249
* cell instance $115 m90 *1 39.17,119.625
X$115 3 11 M2_M1_CDNS_40661956134249
* cell instance $116 m90 *1 51.02,119.625
X$116 3 9 M2_M1_CDNS_40661956134249
* cell instance $117 r0 *1 13.79,117.185
X$117 3 15 M2_M1_CDNS_40661956134249
* cell instance $118 r0 *1 25.64,117.185
X$118 3 13 M2_M1_CDNS_40661956134249
* cell instance $119 m90 *1 39.17,117.185
X$119 3 11 M2_M1_CDNS_40661956134249
* cell instance $120 m90 *1 51.02,117.185
X$120 3 9 M2_M1_CDNS_40661956134249
* cell instance $121 r0 *1 13.79,65.865
X$121 3 15 M2_M1_CDNS_40661956134249
* cell instance $122 r0 *1 25.64,65.865
X$122 3 13 M2_M1_CDNS_40661956134249
* cell instance $123 m90 *1 39.17,65.865
X$123 3 11 M2_M1_CDNS_40661956134249
* cell instance $124 m90 *1 51.02,65.865
X$124 3 9 M2_M1_CDNS_40661956134249
* cell instance $125 r0 *1 13.79,68.305
X$125 3 15 M2_M1_CDNS_40661956134249
* cell instance $126 r0 *1 25.64,68.305
X$126 3 13 M2_M1_CDNS_40661956134249
* cell instance $127 m90 *1 39.17,68.305
X$127 3 11 M2_M1_CDNS_40661956134249
* cell instance $128 m90 *1 51.02,68.305
X$128 3 9 M2_M1_CDNS_40661956134249
* cell instance $129 r0 *1 13.79,70.745
X$129 3 15 M2_M1_CDNS_40661956134249
* cell instance $130 r0 *1 25.64,70.745
X$130 3 13 M2_M1_CDNS_40661956134249
* cell instance $131 m90 *1 39.17,70.745
X$131 3 11 M2_M1_CDNS_40661956134249
* cell instance $132 m90 *1 51.02,70.745
X$132 3 9 M2_M1_CDNS_40661956134249
* cell instance $133 r0 *1 13.79,31.545
X$133 3 15 M2_M1_CDNS_40661956134249
* cell instance $134 r0 *1 25.64,31.545
X$134 3 13 M2_M1_CDNS_40661956134249
* cell instance $135 m90 *1 39.17,31.545
X$135 3 11 M2_M1_CDNS_40661956134249
* cell instance $136 m90 *1 51.02,31.545
X$136 3 9 M2_M1_CDNS_40661956134249
* cell instance $137 r0 *1 13.79,58.465
X$137 3 15 M2_M1_CDNS_40661956134249
* cell instance $138 r0 *1 25.64,58.465
X$138 3 13 M2_M1_CDNS_40661956134249
* cell instance $139 m90 *1 39.17,58.465
X$139 3 11 M2_M1_CDNS_40661956134249
* cell instance $140 m90 *1 51.02,58.465
X$140 3 9 M2_M1_CDNS_40661956134249
* cell instance $141 r0 *1 13.79,56.025
X$141 3 15 M2_M1_CDNS_40661956134249
* cell instance $142 r0 *1 25.64,56.025
X$142 3 13 M2_M1_CDNS_40661956134249
* cell instance $143 m90 *1 39.17,56.025
X$143 3 11 M2_M1_CDNS_40661956134249
* cell instance $144 m90 *1 51.02,56.025
X$144 3 9 M2_M1_CDNS_40661956134249
* cell instance $145 r0 *1 13.79,53.585
X$145 3 15 M2_M1_CDNS_40661956134249
* cell instance $146 r0 *1 25.64,53.585
X$146 3 13 M2_M1_CDNS_40661956134249
* cell instance $147 m90 *1 39.17,53.585
X$147 3 11 M2_M1_CDNS_40661956134249
* cell instance $148 m90 *1 51.02,53.585
X$148 3 9 M2_M1_CDNS_40661956134249
* cell instance $149 r0 *1 13.79,51.145
X$149 3 15 M2_M1_CDNS_40661956134249
* cell instance $150 r0 *1 25.64,51.145
X$150 3 13 M2_M1_CDNS_40661956134249
* cell instance $151 m90 *1 39.17,51.145
X$151 3 11 M2_M1_CDNS_40661956134249
* cell instance $152 m90 *1 51.02,51.145
X$152 3 9 M2_M1_CDNS_40661956134249
* cell instance $153 r0 *1 13.79,48.705
X$153 3 15 M2_M1_CDNS_40661956134249
* cell instance $154 r0 *1 25.64,48.705
X$154 3 13 M2_M1_CDNS_40661956134249
* cell instance $155 m90 *1 39.17,48.705
X$155 3 11 M2_M1_CDNS_40661956134249
* cell instance $156 m90 *1 51.02,48.705
X$156 3 9 M2_M1_CDNS_40661956134249
* cell instance $157 r0 *1 13.79,46.265
X$157 3 15 M2_M1_CDNS_40661956134249
* cell instance $158 r0 *1 25.64,46.265
X$158 3 13 M2_M1_CDNS_40661956134249
* cell instance $159 m90 *1 39.17,46.265
X$159 3 11 M2_M1_CDNS_40661956134249
* cell instance $160 m90 *1 51.02,46.265
X$160 3 9 M2_M1_CDNS_40661956134249
* cell instance $161 r0 *1 13.79,26.665
X$161 3 15 M2_M1_CDNS_40661956134249
* cell instance $162 r0 *1 25.64,26.665
X$162 3 13 M2_M1_CDNS_40661956134249
* cell instance $163 m90 *1 39.17,26.665
X$163 3 11 M2_M1_CDNS_40661956134249
* cell instance $164 m90 *1 51.02,26.665
X$164 3 9 M2_M1_CDNS_40661956134249
* cell instance $165 r0 *1 13.79,29.105
X$165 3 15 M2_M1_CDNS_40661956134249
* cell instance $166 r0 *1 25.64,29.105
X$166 3 13 M2_M1_CDNS_40661956134249
* cell instance $167 m90 *1 39.17,29.105
X$167 3 11 M2_M1_CDNS_40661956134249
* cell instance $168 m90 *1 51.02,29.105
X$168 3 9 M2_M1_CDNS_40661956134249
* cell instance $169 r0 *1 13.79,41.385
X$169 3 15 M2_M1_CDNS_40661956134249
* cell instance $170 r0 *1 25.64,41.385
X$170 3 13 M2_M1_CDNS_40661956134249
* cell instance $171 m90 *1 39.17,41.385
X$171 3 11 M2_M1_CDNS_40661956134249
* cell instance $172 m90 *1 51.02,41.385
X$172 3 9 M2_M1_CDNS_40661956134249
* cell instance $173 r0 *1 13.79,38.945
X$173 3 15 M2_M1_CDNS_40661956134249
* cell instance $174 r0 *1 25.64,38.945
X$174 3 13 M2_M1_CDNS_40661956134249
* cell instance $175 m90 *1 39.17,38.945
X$175 3 11 M2_M1_CDNS_40661956134249
* cell instance $176 m90 *1 51.02,38.945
X$176 3 9 M2_M1_CDNS_40661956134249
* cell instance $177 r0 *1 13.79,36.505
X$177 3 15 M2_M1_CDNS_40661956134249
* cell instance $178 r0 *1 25.64,36.505
X$178 3 13 M2_M1_CDNS_40661956134249
* cell instance $179 m90 *1 39.17,36.505
X$179 3 11 M2_M1_CDNS_40661956134249
* cell instance $180 m90 *1 51.02,36.505
X$180 3 9 M2_M1_CDNS_40661956134249
* cell instance $181 r0 *1 13.79,24.225
X$181 3 15 M2_M1_CDNS_40661956134249
* cell instance $182 r0 *1 25.64,24.225
X$182 3 13 M2_M1_CDNS_40661956134249
* cell instance $183 m90 *1 39.17,24.225
X$183 3 11 M2_M1_CDNS_40661956134249
* cell instance $184 m90 *1 51.02,24.225
X$184 3 9 M2_M1_CDNS_40661956134249
* cell instance $185 r0 *1 13.79,43.825
X$185 3 15 M2_M1_CDNS_40661956134249
* cell instance $186 r0 *1 25.64,43.825
X$186 3 13 M2_M1_CDNS_40661956134249
* cell instance $187 m90 *1 39.17,43.825
X$187 3 11 M2_M1_CDNS_40661956134249
* cell instance $188 m90 *1 51.02,43.825
X$188 3 9 M2_M1_CDNS_40661956134249
* cell instance $189 r0 *1 13.79,100.105
X$189 3 15 M2_M1_CDNS_40661956134249
* cell instance $190 r0 *1 25.64,100.105
X$190 3 13 M2_M1_CDNS_40661956134249
* cell instance $191 m90 *1 39.17,100.105
X$191 3 11 M2_M1_CDNS_40661956134249
* cell instance $192 m90 *1 51.02,100.105
X$192 3 9 M2_M1_CDNS_40661956134249
* cell instance $193 r0 *1 13.79,60.905
X$193 3 15 M2_M1_CDNS_40661956134249
* cell instance $194 r0 *1 25.64,60.905
X$194 3 13 M2_M1_CDNS_40661956134249
* cell instance $195 m90 *1 39.17,60.905
X$195 3 11 M2_M1_CDNS_40661956134249
* cell instance $196 m90 *1 51.02,60.905
X$196 3 9 M2_M1_CDNS_40661956134249
* cell instance $197 r0 *1 3.97,125.635
X$197 3 6 M2_M1_CDNS_40661956134248
* cell instance $198 r0 *1 13.79,125.635
X$198 3 15 M2_M1_CDNS_40661956134247
* cell instance $199 r0 *1 25.64,125.635
X$199 3 13 M2_M1_CDNS_40661956134247
* cell instance $200 m90 *1 39.17,125.635
X$200 3 11 M2_M1_CDNS_40661956134247
* cell instance $201 m90 *1 51.02,125.635
X$201 3 9 M2_M1_CDNS_40661956134247
* cell instance $202 r0 *1 60.84,125.635
X$202 3 18 M2_M1_CDNS_40661956134248
* cell instance $203 r0 *1 63.675,63.385
X$203 3 18 M2_M1_CDNS_40661956134246
* cell instance $204 r0 *1 13.79,7.145
X$204 3 15 M2_M1_CDNS_40661956134249
* cell instance $205 r0 *1 25.64,7.145
X$205 3 13 M2_M1_CDNS_40661956134249
* cell instance $206 m90 *1 39.17,7.145
X$206 3 11 M2_M1_CDNS_40661956134249
* cell instance $207 m90 *1 51.02,7.145
X$207 3 9 M2_M1_CDNS_40661956134249
* cell instance $208 r0 *1 3.97,1.135
X$208 3 6 M2_M1_CDNS_40661956134248
* cell instance $209 r0 *1 13.79,1.135
X$209 3 15 M2_M1_CDNS_40661956134247
* cell instance $210 r0 *1 25.64,1.135
X$210 3 13 M2_M1_CDNS_40661956134247
* cell instance $211 m90 *1 39.17,1.135
X$211 3 11 M2_M1_CDNS_40661956134247
* cell instance $212 m90 *1 51.02,1.135
X$212 3 9 M2_M1_CDNS_40661956134247
* cell instance $213 r0 *1 60.84,1.135
X$213 3 18 M2_M1_CDNS_40661956134248
* cell instance $214 r0 *1 1.135,63.385
X$214 3 6 M2_M1_CDNS_40661956134246
* cell instance $215 r0 *1 32.405,34.025
X$215 5 4 M1_PSUB_CDNS_40661956134134
* cell instance $216 r0 *1 32.405,63.385
X$216 5 4 M1_PSUB_CDNS_40661956134134
* cell instance $217 r0 *1 32.405,92.745
X$217 5 4 M1_PSUB_CDNS_40661956134134
* cell instance $218 r0 *1 32.405,4.135
X$218 5 4 M1_PSUB_CDNS_40661956134138
* cell instance $219 r0 *1 32.405,122.635
X$219 5 4 M1_PSUB_CDNS_40661956134138
* cell instance $220 r0 *1 3.885,63.385
X$220 5 4 M1_PSUB_CDNS_40661956134137
* cell instance $221 r0 *1 60.925,63.385
X$221 5 4 M1_PSUB_CDNS_40661956134137
* cell instance $222 r0 *1 7.865,63.385
X$222 5 8 M2_M1_CDNS_40661956134126
* cell instance $223 m90 *1 19.715,63.385
X$223 5 14 M2_M1_CDNS_40661956134126
* cell instance $224 r0 *1 32.405,63.385
X$224 5 12 M2_M1_CDNS_40661956134250
* cell instance $225 m90 *1 45.095,63.385
X$225 5 10 M2_M1_CDNS_40661956134126
* cell instance $226 m90 *1 56.945,63.385
X$226 5 17 M2_M1_CDNS_40661956134126
* cell instance $227 r0 *1 7.865,92.745
X$227 5 8 M2_M1_CDNS_40661956134126
* cell instance $228 m90 *1 19.715,92.745
X$228 5 14 M2_M1_CDNS_40661956134126
* cell instance $229 r0 *1 32.405,92.745
X$229 5 12 M2_M1_CDNS_40661956134250
* cell instance $230 m90 *1 45.095,92.745
X$230 5 10 M2_M1_CDNS_40661956134126
* cell instance $231 m90 *1 56.945,92.745
X$231 5 17 M2_M1_CDNS_40661956134126
* cell instance $232 r0 *1 7.865,115.965
X$232 5 8 M2_M1_CDNS_40661956134218
* cell instance $233 m90 *1 19.715,115.965
X$233 5 14 M2_M1_CDNS_40661956134218
* cell instance $234 r0 *1 32.405,115.965
X$234 5 12 M2_M1_CDNS_40661956134217
* cell instance $235 m90 *1 45.095,115.965
X$235 5 10 M2_M1_CDNS_40661956134218
* cell instance $236 m90 *1 56.945,115.965
X$236 5 17 M2_M1_CDNS_40661956134218
* cell instance $237 r0 *1 7.865,74.405
X$237 5 8 M2_M1_CDNS_40661956134218
* cell instance $238 m90 *1 19.715,74.405
X$238 5 14 M2_M1_CDNS_40661956134218
* cell instance $239 r0 *1 32.405,74.405
X$239 5 12 M2_M1_CDNS_40661956134217
* cell instance $240 m90 *1 45.095,74.405
X$240 5 10 M2_M1_CDNS_40661956134218
* cell instance $241 m90 *1 56.945,74.405
X$241 5 17 M2_M1_CDNS_40661956134218
* cell instance $242 r0 *1 7.865,118.405
X$242 5 8 M2_M1_CDNS_40661956134218
* cell instance $243 m90 *1 19.715,118.405
X$243 5 14 M2_M1_CDNS_40661956134218
* cell instance $244 r0 *1 32.405,118.405
X$244 5 12 M2_M1_CDNS_40661956134217
* cell instance $245 m90 *1 45.095,118.405
X$245 5 10 M2_M1_CDNS_40661956134218
* cell instance $246 m90 *1 56.945,118.405
X$246 5 17 M2_M1_CDNS_40661956134218
* cell instance $247 r0 *1 7.865,111.085
X$247 5 8 M2_M1_CDNS_40661956134218
* cell instance $248 m90 *1 19.715,111.085
X$248 5 14 M2_M1_CDNS_40661956134218
* cell instance $249 r0 *1 32.405,111.085
X$249 5 12 M2_M1_CDNS_40661956134217
* cell instance $250 m90 *1 45.095,111.085
X$250 5 10 M2_M1_CDNS_40661956134218
* cell instance $251 m90 *1 56.945,111.085
X$251 5 17 M2_M1_CDNS_40661956134218
* cell instance $252 r0 *1 7.865,101.325
X$252 5 8 M2_M1_CDNS_40661956134218
* cell instance $253 m90 *1 19.715,101.325
X$253 5 14 M2_M1_CDNS_40661956134218
* cell instance $254 r0 *1 32.405,101.325
X$254 5 12 M2_M1_CDNS_40661956134217
* cell instance $255 m90 *1 45.095,101.325
X$255 5 10 M2_M1_CDNS_40661956134218
* cell instance $256 m90 *1 56.945,101.325
X$256 5 17 M2_M1_CDNS_40661956134218
* cell instance $257 r0 *1 7.865,30.325
X$257 5 8 M2_M1_CDNS_40661956134218
* cell instance $258 m90 *1 19.715,30.325
X$258 5 14 M2_M1_CDNS_40661956134218
* cell instance $259 r0 *1 32.405,30.325
X$259 5 12 M2_M1_CDNS_40661956134217
* cell instance $260 m90 *1 45.095,30.325
X$260 5 10 M2_M1_CDNS_40661956134218
* cell instance $261 m90 *1 56.945,30.325
X$261 5 17 M2_M1_CDNS_40661956134218
* cell instance $262 r0 *1 7.865,10.805
X$262 5 8 M2_M1_CDNS_40661956134218
* cell instance $263 m90 *1 19.715,10.805
X$263 5 14 M2_M1_CDNS_40661956134218
* cell instance $264 r0 *1 32.405,10.805
X$264 5 12 M2_M1_CDNS_40661956134217
* cell instance $265 m90 *1 45.095,10.805
X$265 5 10 M2_M1_CDNS_40661956134218
* cell instance $266 m90 *1 56.945,10.805
X$266 5 17 M2_M1_CDNS_40661956134218
* cell instance $267 r0 *1 7.865,20.565
X$267 5 8 M2_M1_CDNS_40661956134218
* cell instance $268 m90 *1 19.715,20.565
X$268 5 14 M2_M1_CDNS_40661956134218
* cell instance $269 r0 *1 32.405,20.565
X$269 5 12 M2_M1_CDNS_40661956134217
* cell instance $270 m90 *1 45.095,20.565
X$270 5 10 M2_M1_CDNS_40661956134218
* cell instance $271 m90 *1 56.945,20.565
X$271 5 17 M2_M1_CDNS_40661956134218
* cell instance $272 r0 *1 7.865,84.165
X$272 5 8 M2_M1_CDNS_40661956134218
* cell instance $273 m90 *1 19.715,84.165
X$273 5 14 M2_M1_CDNS_40661956134218
* cell instance $274 r0 *1 32.405,84.165
X$274 5 12 M2_M1_CDNS_40661956134217
* cell instance $275 m90 *1 45.095,84.165
X$275 5 10 M2_M1_CDNS_40661956134218
* cell instance $276 m90 *1 56.945,84.165
X$276 5 17 M2_M1_CDNS_40661956134218
* cell instance $277 r0 *1 7.865,37.725
X$277 5 8 M2_M1_CDNS_40661956134218
* cell instance $278 m90 *1 19.715,37.725
X$278 5 14 M2_M1_CDNS_40661956134218
* cell instance $279 r0 *1 32.405,37.725
X$279 5 12 M2_M1_CDNS_40661956134217
* cell instance $280 m90 *1 45.095,37.725
X$280 5 10 M2_M1_CDNS_40661956134218
* cell instance $281 m90 *1 56.945,37.725
X$281 5 17 M2_M1_CDNS_40661956134218
* cell instance $282 r0 *1 7.865,57.245
X$282 5 8 M2_M1_CDNS_40661956134218
* cell instance $283 m90 *1 19.715,57.245
X$283 5 14 M2_M1_CDNS_40661956134218
* cell instance $284 r0 *1 32.405,57.245
X$284 5 12 M2_M1_CDNS_40661956134217
* cell instance $285 m90 *1 45.095,57.245
X$285 5 10 M2_M1_CDNS_40661956134218
* cell instance $286 m90 *1 56.945,57.245
X$286 5 17 M2_M1_CDNS_40661956134218
* cell instance $287 r0 *1 7.865,54.805
X$287 5 8 M2_M1_CDNS_40661956134218
* cell instance $288 m90 *1 19.715,54.805
X$288 5 14 M2_M1_CDNS_40661956134218
* cell instance $289 r0 *1 32.405,54.805
X$289 5 12 M2_M1_CDNS_40661956134217
* cell instance $290 m90 *1 45.095,54.805
X$290 5 10 M2_M1_CDNS_40661956134218
* cell instance $291 m90 *1 56.945,54.805
X$291 5 17 M2_M1_CDNS_40661956134218
* cell instance $292 r0 *1 7.865,13.245
X$292 5 8 M2_M1_CDNS_40661956134218
* cell instance $293 m90 *1 19.715,13.245
X$293 5 14 M2_M1_CDNS_40661956134218
* cell instance $294 r0 *1 32.405,13.245
X$294 5 12 M2_M1_CDNS_40661956134217
* cell instance $295 m90 *1 45.095,13.245
X$295 5 10 M2_M1_CDNS_40661956134218
* cell instance $296 m90 *1 56.945,13.245
X$296 5 17 M2_M1_CDNS_40661956134218
* cell instance $297 r0 *1 7.865,45.045
X$297 5 8 M2_M1_CDNS_40661956134218
* cell instance $298 m90 *1 19.715,45.045
X$298 5 14 M2_M1_CDNS_40661956134218
* cell instance $299 r0 *1 32.405,45.045
X$299 5 12 M2_M1_CDNS_40661956134217
* cell instance $300 m90 *1 45.095,45.045
X$300 5 10 M2_M1_CDNS_40661956134218
* cell instance $301 m90 *1 56.945,45.045
X$301 5 17 M2_M1_CDNS_40661956134218
* cell instance $302 r0 *1 7.865,23.005
X$302 5 8 M2_M1_CDNS_40661956134218
* cell instance $303 m90 *1 19.715,23.005
X$303 5 14 M2_M1_CDNS_40661956134218
* cell instance $304 r0 *1 32.405,23.005
X$304 5 12 M2_M1_CDNS_40661956134217
* cell instance $305 m90 *1 45.095,23.005
X$305 5 10 M2_M1_CDNS_40661956134218
* cell instance $306 m90 *1 56.945,23.005
X$306 5 17 M2_M1_CDNS_40661956134218
* cell instance $307 r0 *1 7.865,18.125
X$307 5 8 M2_M1_CDNS_40661956134218
* cell instance $308 m90 *1 19.715,18.125
X$308 5 14 M2_M1_CDNS_40661956134218
* cell instance $309 r0 *1 32.405,18.125
X$309 5 12 M2_M1_CDNS_40661956134217
* cell instance $310 m90 *1 45.095,18.125
X$310 5 10 M2_M1_CDNS_40661956134218
* cell instance $311 m90 *1 56.945,18.125
X$311 5 17 M2_M1_CDNS_40661956134218
* cell instance $312 r0 *1 7.865,49.925
X$312 5 8 M2_M1_CDNS_40661956134218
* cell instance $313 m90 *1 19.715,49.925
X$313 5 14 M2_M1_CDNS_40661956134218
* cell instance $314 r0 *1 32.405,49.925
X$314 5 12 M2_M1_CDNS_40661956134217
* cell instance $315 m90 *1 45.095,49.925
X$315 5 10 M2_M1_CDNS_40661956134218
* cell instance $316 m90 *1 56.945,49.925
X$316 5 17 M2_M1_CDNS_40661956134218
* cell instance $317 r0 *1 7.865,42.605
X$317 5 8 M2_M1_CDNS_40661956134218
* cell instance $318 m90 *1 19.715,42.605
X$318 5 14 M2_M1_CDNS_40661956134218
* cell instance $319 r0 *1 32.405,42.605
X$319 5 12 M2_M1_CDNS_40661956134217
* cell instance $320 m90 *1 45.095,42.605
X$320 5 10 M2_M1_CDNS_40661956134218
* cell instance $321 m90 *1 56.945,42.605
X$321 5 17 M2_M1_CDNS_40661956134218
* cell instance $322 r0 *1 7.865,47.485
X$322 5 8 M2_M1_CDNS_40661956134218
* cell instance $323 m90 *1 19.715,47.485
X$323 5 14 M2_M1_CDNS_40661956134218
* cell instance $324 r0 *1 32.405,47.485
X$324 5 12 M2_M1_CDNS_40661956134217
* cell instance $325 m90 *1 45.095,47.485
X$325 5 10 M2_M1_CDNS_40661956134218
* cell instance $326 m90 *1 56.945,47.485
X$326 5 17 M2_M1_CDNS_40661956134218
* cell instance $327 r0 *1 7.865,89.045
X$327 5 8 M2_M1_CDNS_40661956134218
* cell instance $328 m90 *1 19.715,89.045
X$328 5 14 M2_M1_CDNS_40661956134218
* cell instance $329 r0 *1 32.405,89.045
X$329 5 12 M2_M1_CDNS_40661956134217
* cell instance $330 m90 *1 45.095,89.045
X$330 5 10 M2_M1_CDNS_40661956134218
* cell instance $331 m90 *1 56.945,89.045
X$331 5 17 M2_M1_CDNS_40661956134218
* cell instance $332 r0 *1 7.865,40.165
X$332 5 8 M2_M1_CDNS_40661956134218
* cell instance $333 m90 *1 19.715,40.165
X$333 5 14 M2_M1_CDNS_40661956134218
* cell instance $334 r0 *1 32.405,40.165
X$334 5 12 M2_M1_CDNS_40661956134217
* cell instance $335 m90 *1 45.095,40.165
X$335 5 10 M2_M1_CDNS_40661956134218
* cell instance $336 m90 *1 56.945,40.165
X$336 5 17 M2_M1_CDNS_40661956134218
* cell instance $337 r0 *1 7.865,52.365
X$337 5 8 M2_M1_CDNS_40661956134218
* cell instance $338 m90 *1 19.715,52.365
X$338 5 14 M2_M1_CDNS_40661956134218
* cell instance $339 r0 *1 32.405,52.365
X$339 5 12 M2_M1_CDNS_40661956134217
* cell instance $340 m90 *1 45.095,52.365
X$340 5 10 M2_M1_CDNS_40661956134218
* cell instance $341 m90 *1 56.945,52.365
X$341 5 17 M2_M1_CDNS_40661956134218
* cell instance $342 r0 *1 7.865,27.885
X$342 5 8 M2_M1_CDNS_40661956134218
* cell instance $343 m90 *1 19.715,27.885
X$343 5 14 M2_M1_CDNS_40661956134218
* cell instance $344 r0 *1 32.405,27.885
X$344 5 12 M2_M1_CDNS_40661956134217
* cell instance $345 m90 *1 45.095,27.885
X$345 5 10 M2_M1_CDNS_40661956134218
* cell instance $346 m90 *1 56.945,27.885
X$346 5 17 M2_M1_CDNS_40661956134218
* cell instance $347 r0 *1 7.865,69.525
X$347 5 8 M2_M1_CDNS_40661956134218
* cell instance $348 m90 *1 19.715,69.525
X$348 5 14 M2_M1_CDNS_40661956134218
* cell instance $349 r0 *1 32.405,69.525
X$349 5 12 M2_M1_CDNS_40661956134217
* cell instance $350 m90 *1 45.095,69.525
X$350 5 10 M2_M1_CDNS_40661956134218
* cell instance $351 m90 *1 56.945,69.525
X$351 5 17 M2_M1_CDNS_40661956134218
* cell instance $352 r0 *1 7.865,103.765
X$352 5 8 M2_M1_CDNS_40661956134218
* cell instance $353 m90 *1 19.715,103.765
X$353 5 14 M2_M1_CDNS_40661956134218
* cell instance $354 r0 *1 32.405,103.765
X$354 5 12 M2_M1_CDNS_40661956134217
* cell instance $355 m90 *1 45.095,103.765
X$355 5 10 M2_M1_CDNS_40661956134218
* cell instance $356 m90 *1 56.945,103.765
X$356 5 17 M2_M1_CDNS_40661956134218
* cell instance $357 r0 *1 7.865,25.445
X$357 5 8 M2_M1_CDNS_40661956134218
* cell instance $358 m90 *1 19.715,25.445
X$358 5 14 M2_M1_CDNS_40661956134218
* cell instance $359 r0 *1 32.405,25.445
X$359 5 12 M2_M1_CDNS_40661956134217
* cell instance $360 m90 *1 45.095,25.445
X$360 5 10 M2_M1_CDNS_40661956134218
* cell instance $361 m90 *1 56.945,25.445
X$361 5 17 M2_M1_CDNS_40661956134218
* cell instance $362 r0 *1 7.865,108.645
X$362 5 8 M2_M1_CDNS_40661956134218
* cell instance $363 m90 *1 19.715,108.645
X$363 5 14 M2_M1_CDNS_40661956134218
* cell instance $364 r0 *1 32.405,108.645
X$364 5 12 M2_M1_CDNS_40661956134217
* cell instance $365 m90 *1 45.095,108.645
X$365 5 10 M2_M1_CDNS_40661956134218
* cell instance $366 m90 *1 56.945,108.645
X$366 5 17 M2_M1_CDNS_40661956134218
* cell instance $367 r0 *1 7.865,86.605
X$367 5 8 M2_M1_CDNS_40661956134218
* cell instance $368 m90 *1 19.715,86.605
X$368 5 14 M2_M1_CDNS_40661956134218
* cell instance $369 r0 *1 32.405,86.605
X$369 5 12 M2_M1_CDNS_40661956134217
* cell instance $370 m90 *1 45.095,86.605
X$370 5 10 M2_M1_CDNS_40661956134218
* cell instance $371 m90 *1 56.945,86.605
X$371 5 17 M2_M1_CDNS_40661956134218
* cell instance $372 r0 *1 7.865,113.525
X$372 5 8 M2_M1_CDNS_40661956134218
* cell instance $373 m90 *1 19.715,113.525
X$373 5 14 M2_M1_CDNS_40661956134218
* cell instance $374 r0 *1 32.405,113.525
X$374 5 12 M2_M1_CDNS_40661956134217
* cell instance $375 m90 *1 45.095,113.525
X$375 5 10 M2_M1_CDNS_40661956134218
* cell instance $376 m90 *1 56.945,113.525
X$376 5 17 M2_M1_CDNS_40661956134218
* cell instance $377 r0 *1 7.865,15.685
X$377 5 8 M2_M1_CDNS_40661956134218
* cell instance $378 m90 *1 19.715,15.685
X$378 5 14 M2_M1_CDNS_40661956134218
* cell instance $379 r0 *1 32.405,15.685
X$379 5 12 M2_M1_CDNS_40661956134217
* cell instance $380 m90 *1 45.095,15.685
X$380 5 10 M2_M1_CDNS_40661956134218
* cell instance $381 m90 *1 56.945,15.685
X$381 5 17 M2_M1_CDNS_40661956134218
* cell instance $382 r0 *1 7.865,79.285
X$382 5 8 M2_M1_CDNS_40661956134218
* cell instance $383 m90 *1 19.715,79.285
X$383 5 14 M2_M1_CDNS_40661956134218
* cell instance $384 r0 *1 32.405,79.285
X$384 5 12 M2_M1_CDNS_40661956134217
* cell instance $385 m90 *1 45.095,79.285
X$385 5 10 M2_M1_CDNS_40661956134218
* cell instance $386 m90 *1 56.945,79.285
X$386 5 17 M2_M1_CDNS_40661956134218
* cell instance $387 r0 *1 7.865,96.445
X$387 5 8 M2_M1_CDNS_40661956134218
* cell instance $388 m90 *1 19.715,96.445
X$388 5 14 M2_M1_CDNS_40661956134218
* cell instance $389 r0 *1 32.405,96.445
X$389 5 12 M2_M1_CDNS_40661956134217
* cell instance $390 m90 *1 45.095,96.445
X$390 5 10 M2_M1_CDNS_40661956134218
* cell instance $391 m90 *1 56.945,96.445
X$391 5 17 M2_M1_CDNS_40661956134218
* cell instance $392 r0 *1 7.865,76.845
X$392 5 8 M2_M1_CDNS_40661956134218
* cell instance $393 m90 *1 19.715,76.845
X$393 5 14 M2_M1_CDNS_40661956134218
* cell instance $394 r0 *1 32.405,76.845
X$394 5 12 M2_M1_CDNS_40661956134217
* cell instance $395 m90 *1 45.095,76.845
X$395 5 10 M2_M1_CDNS_40661956134218
* cell instance $396 m90 *1 56.945,76.845
X$396 5 17 M2_M1_CDNS_40661956134218
* cell instance $397 r0 *1 7.865,106.205
X$397 5 8 M2_M1_CDNS_40661956134218
* cell instance $398 m90 *1 19.715,106.205
X$398 5 14 M2_M1_CDNS_40661956134218
* cell instance $399 r0 *1 32.405,106.205
X$399 5 12 M2_M1_CDNS_40661956134217
* cell instance $400 m90 *1 45.095,106.205
X$400 5 10 M2_M1_CDNS_40661956134218
* cell instance $401 m90 *1 56.945,106.205
X$401 5 17 M2_M1_CDNS_40661956134218
* cell instance $402 r0 *1 7.865,98.885
X$402 5 8 M2_M1_CDNS_40661956134218
* cell instance $403 m90 *1 19.715,98.885
X$403 5 14 M2_M1_CDNS_40661956134218
* cell instance $404 r0 *1 32.405,98.885
X$404 5 12 M2_M1_CDNS_40661956134217
* cell instance $405 m90 *1 45.095,98.885
X$405 5 10 M2_M1_CDNS_40661956134218
* cell instance $406 m90 *1 56.945,98.885
X$406 5 17 M2_M1_CDNS_40661956134218
* cell instance $407 r0 *1 7.865,59.685
X$407 5 8 M2_M1_CDNS_40661956134218
* cell instance $408 m90 *1 19.715,59.685
X$408 5 14 M2_M1_CDNS_40661956134218
* cell instance $409 r0 *1 32.405,59.685
X$409 5 12 M2_M1_CDNS_40661956134217
* cell instance $410 m90 *1 45.095,59.685
X$410 5 10 M2_M1_CDNS_40661956134218
* cell instance $411 m90 *1 56.945,59.685
X$411 5 17 M2_M1_CDNS_40661956134218
* cell instance $412 r0 *1 7.865,71.965
X$412 5 8 M2_M1_CDNS_40661956134218
* cell instance $413 m90 *1 19.715,71.965
X$413 5 14 M2_M1_CDNS_40661956134218
* cell instance $414 r0 *1 32.405,71.965
X$414 5 12 M2_M1_CDNS_40661956134217
* cell instance $415 m90 *1 45.095,71.965
X$415 5 10 M2_M1_CDNS_40661956134218
* cell instance $416 m90 *1 56.945,71.965
X$416 5 17 M2_M1_CDNS_40661956134218
* cell instance $417 r0 *1 7.865,67.085
X$417 5 8 M2_M1_CDNS_40661956134218
* cell instance $418 m90 *1 19.715,67.085
X$418 5 14 M2_M1_CDNS_40661956134218
* cell instance $419 r0 *1 32.405,67.085
X$419 5 12 M2_M1_CDNS_40661956134217
* cell instance $420 m90 *1 45.095,67.085
X$420 5 10 M2_M1_CDNS_40661956134218
* cell instance $421 m90 *1 56.945,67.085
X$421 5 17 M2_M1_CDNS_40661956134218
* cell instance $422 r0 *1 7.865,81.725
X$422 5 8 M2_M1_CDNS_40661956134218
* cell instance $423 m90 *1 19.715,81.725
X$423 5 14 M2_M1_CDNS_40661956134218
* cell instance $424 r0 *1 32.405,81.725
X$424 5 12 M2_M1_CDNS_40661956134217
* cell instance $425 m90 *1 45.095,81.725
X$425 5 10 M2_M1_CDNS_40661956134218
* cell instance $426 m90 *1 56.945,81.725
X$426 5 17 M2_M1_CDNS_40661956134218
* cell instance $427 r0 *1 7.865,122.635
X$427 5 8 M2_M1_CDNS_40661956134206
* cell instance $428 m90 *1 19.715,122.635
X$428 5 14 M2_M1_CDNS_40661956134206
* cell instance $429 r0 *1 32.405,122.635
X$429 5 12 M2_M1_CDNS_40661956134207
* cell instance $430 m90 *1 45.095,122.635
X$430 5 10 M2_M1_CDNS_40661956134206
* cell instance $431 m90 *1 56.945,122.635
X$431 5 17 M2_M1_CDNS_40661956134206
* cell instance $432 r0 *1 7.865,34.025
X$432 5 8 M2_M1_CDNS_40661956134126
* cell instance $433 m90 *1 19.715,34.025
X$433 5 14 M2_M1_CDNS_40661956134126
* cell instance $434 r0 *1 32.405,34.025
X$434 5 12 M2_M1_CDNS_40661956134250
* cell instance $435 m90 *1 45.095,34.025
X$435 5 10 M2_M1_CDNS_40661956134126
* cell instance $436 m90 *1 56.945,34.025
X$436 5 17 M2_M1_CDNS_40661956134126
* cell instance $437 r0 *1 7.865,8.365
X$437 5 8 M2_M1_CDNS_40661956134218
* cell instance $438 m90 *1 19.715,8.365
X$438 5 14 M2_M1_CDNS_40661956134218
* cell instance $439 r0 *1 32.405,8.365
X$439 5 12 M2_M1_CDNS_40661956134217
* cell instance $440 m90 *1 45.095,8.365
X$440 5 10 M2_M1_CDNS_40661956134218
* cell instance $441 m90 *1 56.945,8.365
X$441 5 17 M2_M1_CDNS_40661956134218
* cell instance $442 r0 *1 7.865,4.135
X$442 5 8 M2_M1_CDNS_40661956134206
* cell instance $443 m90 *1 19.715,4.135
X$443 5 14 M2_M1_CDNS_40661956134206
* cell instance $444 r0 *1 32.405,4.135
X$444 5 12 M2_M1_CDNS_40661956134207
* cell instance $445 m90 *1 45.095,4.135
X$445 5 10 M2_M1_CDNS_40661956134206
* cell instance $446 m90 *1 56.945,4.135
X$446 5 17 M2_M1_CDNS_40661956134206
.ENDS nmos_clamp_20_50_4_DVDD

* cell M2_M1_CDNS_40661956134234
* pin
* pin
.SUBCKT M2_M1_CDNS_40661956134234 1 2
.ENDS M2_M1_CDNS_40661956134234

* cell M2_M1_CDNS_40661956134236
* pin
* pin
.SUBCKT M2_M1_CDNS_40661956134236 1 2
.ENDS M2_M1_CDNS_40661956134236

* cell M2_M1_CDNS_40661956134240
* pin
* pin
.SUBCKT M2_M1_CDNS_40661956134240 1 2
.ENDS M2_M1_CDNS_40661956134240

* cell M2_M1_CDNS_40661956134235
* pin
* pin
.SUBCKT M2_M1_CDNS_40661956134235 1 2
.ENDS M2_M1_CDNS_40661956134235

* cell M2_M1_CDNS_40661956134265
* pin
* pin
.SUBCKT M2_M1_CDNS_40661956134265 1 2
.ENDS M2_M1_CDNS_40661956134265

* cell M2_M1_CDNS_40661956134266
* pin
* pin
.SUBCKT M2_M1_CDNS_40661956134266 1 2
.ENDS M2_M1_CDNS_40661956134266

* cell M2_M1_CDNS_40661956134267
* pin
* pin
.SUBCKT M2_M1_CDNS_40661956134267 1 2
.ENDS M2_M1_CDNS_40661956134267

* cell nmos_clamp_20_50_4_DVSS
* pin
* pin
* pin
* pin
* pin
* pin
* pin
* pin
* pin
* pin
* pin
* pin
* pin
* pin
* pin
* pin
* pin gf180mcu_gnd
.SUBCKT nmos_clamp_20_50_4_DVSS 1 3 5 6 7 8 9 10 11 12 13 14 15 16 17 18 19
* net 19 gf180mcu_gnd
* cell instance $1 r90 *1 57.405,36.765
X$1 5 3 5 3 5 3 5 3 5 3 5 3 5 3 5 3 5 3 5 3 5 1 1 1 1 1 1 1 1 1 1 1 1 1 1 1 1 1
+ 1 1 1 19 nmos_6p0_CDNS_406619561341
* cell instance $2 r90 *1 57.405,7.405
X$2 5 3 5 3 5 3 5 3 5 3 5 3 5 3 5 3 5 3 5 3 5 1 1 1 1 1 1 1 1 1 1 1 1 1 1 1 1 1
+ 1 1 1 19 nmos_6p0_CDNS_406619561341
* cell instance $3 r90 *1 57.405,95.485
X$3 5 3 5 3 5 3 5 3 5 3 5 3 5 3 5 3 5 3 5 3 5 1 1 1 1 1 1 1 1 1 1 1 1 1 1 1 1 1
+ 1 1 1 19 nmos_6p0_CDNS_406619561341
* cell instance $4 r90 *1 57.405,66.125
X$4 5 3 5 3 5 3 5 3 5 3 5 3 5 3 5 3 5 3 5 3 5 1 1 1 1 1 1 1 1 1 1 1 1 1 1 1 1 1
+ 1 1 1 19 nmos_6p0_CDNS_406619561341
* cell instance $5 r0 *1 58.245,107.425
X$5 1 16 M2_M1_CDNS_40661956134141
* cell instance $6 m90 *1 58.165,107.425
X$6 1 M1_POLY2_CDNS_40661956134136
* cell instance $7 r0 *1 58.245,48.705
X$7 1 16 M2_M1_CDNS_40661956134141
* cell instance $8 m90 *1 58.165,48.705
X$8 1 M1_POLY2_CDNS_40661956134136
* cell instance $9 r0 *1 58.245,19.345
X$9 1 16 M2_M1_CDNS_40661956134141
* cell instance $10 m90 *1 58.165,19.345
X$10 1 M1_POLY2_CDNS_40661956134136
* cell instance $11 r0 *1 58.245,78.065
X$11 1 16 M2_M1_CDNS_40661956134141
* cell instance $12 m90 *1 58.165,78.065
X$12 1 M1_POLY2_CDNS_40661956134136
* cell instance $13 r0 *1 6.645,19.345
X$13 1 M1_POLY2_CDNS_40661956134136
* cell instance $14 r0 *1 6.565,19.345
X$14 1 7 M2_M1_CDNS_40661956134141
* cell instance $15 r0 *1 6.645,48.705
X$15 1 M1_POLY2_CDNS_40661956134136
* cell instance $16 r0 *1 6.565,48.705
X$16 1 7 M2_M1_CDNS_40661956134141
* cell instance $17 r0 *1 6.645,78.065
X$17 1 M1_POLY2_CDNS_40661956134136
* cell instance $18 r0 *1 6.565,78.065
X$18 1 7 M2_M1_CDNS_40661956134141
* cell instance $19 r0 *1 6.645,107.425
X$19 1 M1_POLY2_CDNS_40661956134136
* cell instance $20 r0 *1 6.565,107.425
X$20 1 7 M2_M1_CDNS_40661956134141
* cell instance $21 r0 *1 32.405,125.635
X$21 3 20 3 2 M1_NWELL_CDNS_40661956134139
* cell instance $22 r0 *1 32.405,1.135
X$22 3 20 3 2 M1_NWELL_CDNS_40661956134139
* cell instance $23 r0 *1 63.675,63.385
X$23 3 2 3 20 M1_NWELL_CDNS_40661956134135
* cell instance $24 r0 *1 1.135,63.385
X$24 3 2 3 20 M1_NWELL_CDNS_40661956134135
* cell instance $25 r0 *1 7.865,13.245
X$25 3 8 M2_M1_CDNS_40661956134218
* cell instance $26 m90 *1 19.715,13.245
X$26 3 14 M2_M1_CDNS_40661956134218
* cell instance $27 r0 *1 32.405,13.245
X$27 3 12 M2_M1_CDNS_40661956134217
* cell instance $28 m90 *1 45.095,13.245
X$28 3 10 M2_M1_CDNS_40661956134218
* cell instance $29 m90 *1 56.945,13.245
X$29 3 17 M2_M1_CDNS_40661956134218
* cell instance $30 r0 *1 7.865,15.685
X$30 3 8 M2_M1_CDNS_40661956134218
* cell instance $31 m90 *1 19.715,15.685
X$31 3 14 M2_M1_CDNS_40661956134218
* cell instance $32 r0 *1 32.405,15.685
X$32 3 12 M2_M1_CDNS_40661956134217
* cell instance $33 m90 *1 45.095,15.685
X$33 3 10 M2_M1_CDNS_40661956134218
* cell instance $34 m90 *1 56.945,15.685
X$34 3 17 M2_M1_CDNS_40661956134218
* cell instance $35 r0 *1 7.865,18.125
X$35 3 8 M2_M1_CDNS_40661956134218
* cell instance $36 m90 *1 19.715,18.125
X$36 3 14 M2_M1_CDNS_40661956134218
* cell instance $37 r0 *1 32.405,18.125
X$37 3 12 M2_M1_CDNS_40661956134217
* cell instance $38 m90 *1 45.095,18.125
X$38 3 10 M2_M1_CDNS_40661956134218
* cell instance $39 m90 *1 56.945,18.125
X$39 3 17 M2_M1_CDNS_40661956134218
* cell instance $40 r0 *1 7.865,20.565
X$40 3 8 M2_M1_CDNS_40661956134218
* cell instance $41 m90 *1 19.715,20.565
X$41 3 14 M2_M1_CDNS_40661956134218
* cell instance $42 r0 *1 32.405,20.565
X$42 3 12 M2_M1_CDNS_40661956134217
* cell instance $43 m90 *1 45.095,20.565
X$43 3 10 M2_M1_CDNS_40661956134218
* cell instance $44 m90 *1 56.945,20.565
X$44 3 17 M2_M1_CDNS_40661956134218
* cell instance $45 r0 *1 7.865,23.005
X$45 3 8 M2_M1_CDNS_40661956134218
* cell instance $46 m90 *1 19.715,23.005
X$46 3 14 M2_M1_CDNS_40661956134218
* cell instance $47 r0 *1 32.405,23.005
X$47 3 12 M2_M1_CDNS_40661956134217
* cell instance $48 m90 *1 45.095,23.005
X$48 3 10 M2_M1_CDNS_40661956134218
* cell instance $49 m90 *1 56.945,23.005
X$49 3 17 M2_M1_CDNS_40661956134218
* cell instance $50 r0 *1 7.865,25.445
X$50 3 8 M2_M1_CDNS_40661956134218
* cell instance $51 m90 *1 19.715,25.445
X$51 3 14 M2_M1_CDNS_40661956134218
* cell instance $52 r0 *1 32.405,25.445
X$52 3 12 M2_M1_CDNS_40661956134217
* cell instance $53 m90 *1 45.095,25.445
X$53 3 10 M2_M1_CDNS_40661956134218
* cell instance $54 m90 *1 56.945,25.445
X$54 3 17 M2_M1_CDNS_40661956134218
* cell instance $55 r0 *1 7.865,27.885
X$55 3 8 M2_M1_CDNS_40661956134218
* cell instance $56 m90 *1 19.715,27.885
X$56 3 14 M2_M1_CDNS_40661956134218
* cell instance $57 r0 *1 32.405,27.885
X$57 3 12 M2_M1_CDNS_40661956134217
* cell instance $58 m90 *1 45.095,27.885
X$58 3 10 M2_M1_CDNS_40661956134218
* cell instance $59 m90 *1 56.945,27.885
X$59 3 17 M2_M1_CDNS_40661956134218
* cell instance $60 r0 *1 7.865,71.965
X$60 3 8 M2_M1_CDNS_40661956134218
* cell instance $61 m90 *1 19.715,71.965
X$61 3 14 M2_M1_CDNS_40661956134218
* cell instance $62 r0 *1 32.405,71.965
X$62 3 12 M2_M1_CDNS_40661956134217
* cell instance $63 m90 *1 45.095,71.965
X$63 3 10 M2_M1_CDNS_40661956134218
* cell instance $64 m90 *1 56.945,71.965
X$64 3 17 M2_M1_CDNS_40661956134218
* cell instance $65 r0 *1 7.865,103.765
X$65 3 8 M2_M1_CDNS_40661956134218
* cell instance $66 m90 *1 19.715,103.765
X$66 3 14 M2_M1_CDNS_40661956134218
* cell instance $67 r0 *1 32.405,103.765
X$67 3 12 M2_M1_CDNS_40661956134217
* cell instance $68 m90 *1 45.095,103.765
X$68 3 10 M2_M1_CDNS_40661956134218
* cell instance $69 m90 *1 56.945,103.765
X$69 3 17 M2_M1_CDNS_40661956134218
* cell instance $70 r0 *1 7.865,98.885
X$70 3 8 M2_M1_CDNS_40661956134218
* cell instance $71 m90 *1 19.715,98.885
X$71 3 14 M2_M1_CDNS_40661956134218
* cell instance $72 r0 *1 32.405,98.885
X$72 3 12 M2_M1_CDNS_40661956134217
* cell instance $73 m90 *1 45.095,98.885
X$73 3 10 M2_M1_CDNS_40661956134218
* cell instance $74 m90 *1 56.945,98.885
X$74 3 17 M2_M1_CDNS_40661956134218
* cell instance $75 r0 *1 7.865,111.085
X$75 3 8 M2_M1_CDNS_40661956134218
* cell instance $76 m90 *1 19.715,111.085
X$76 3 14 M2_M1_CDNS_40661956134218
* cell instance $77 r0 *1 32.405,111.085
X$77 3 12 M2_M1_CDNS_40661956134217
* cell instance $78 m90 *1 45.095,111.085
X$78 3 10 M2_M1_CDNS_40661956134218
* cell instance $79 m90 *1 56.945,111.085
X$79 3 17 M2_M1_CDNS_40661956134218
* cell instance $80 r0 *1 7.865,115.965
X$80 3 8 M2_M1_CDNS_40661956134218
* cell instance $81 m90 *1 19.715,115.965
X$81 3 14 M2_M1_CDNS_40661956134218
* cell instance $82 r0 *1 32.405,115.965
X$82 3 12 M2_M1_CDNS_40661956134217
* cell instance $83 m90 *1 45.095,115.965
X$83 3 10 M2_M1_CDNS_40661956134218
* cell instance $84 m90 *1 56.945,115.965
X$84 3 17 M2_M1_CDNS_40661956134218
* cell instance $85 r0 *1 7.865,118.405
X$85 3 8 M2_M1_CDNS_40661956134218
* cell instance $86 m90 *1 19.715,118.405
X$86 3 14 M2_M1_CDNS_40661956134218
* cell instance $87 r0 *1 32.405,118.405
X$87 3 12 M2_M1_CDNS_40661956134217
* cell instance $88 m90 *1 45.095,118.405
X$88 3 10 M2_M1_CDNS_40661956134218
* cell instance $89 m90 *1 56.945,118.405
X$89 3 17 M2_M1_CDNS_40661956134218
* cell instance $90 r0 *1 7.865,69.525
X$90 3 8 M2_M1_CDNS_40661956134218
* cell instance $91 m90 *1 19.715,69.525
X$91 3 14 M2_M1_CDNS_40661956134218
* cell instance $92 r0 *1 32.405,69.525
X$92 3 12 M2_M1_CDNS_40661956134217
* cell instance $93 m90 *1 45.095,69.525
X$93 3 10 M2_M1_CDNS_40661956134218
* cell instance $94 m90 *1 56.945,69.525
X$94 3 17 M2_M1_CDNS_40661956134218
* cell instance $95 r0 *1 7.865,96.445
X$95 3 8 M2_M1_CDNS_40661956134218
* cell instance $96 m90 *1 19.715,96.445
X$96 3 14 M2_M1_CDNS_40661956134218
* cell instance $97 r0 *1 32.405,96.445
X$97 3 12 M2_M1_CDNS_40661956134217
* cell instance $98 m90 *1 45.095,96.445
X$98 3 10 M2_M1_CDNS_40661956134218
* cell instance $99 m90 *1 56.945,96.445
X$99 3 17 M2_M1_CDNS_40661956134218
* cell instance $100 r0 *1 7.865,84.165
X$100 3 8 M2_M1_CDNS_40661956134218
* cell instance $101 m90 *1 19.715,84.165
X$101 3 14 M2_M1_CDNS_40661956134218
* cell instance $102 r0 *1 32.405,84.165
X$102 3 12 M2_M1_CDNS_40661956134217
* cell instance $103 m90 *1 45.095,84.165
X$103 3 10 M2_M1_CDNS_40661956134218
* cell instance $104 m90 *1 56.945,84.165
X$104 3 17 M2_M1_CDNS_40661956134218
* cell instance $105 r0 *1 7.865,86.605
X$105 3 8 M2_M1_CDNS_40661956134218
* cell instance $106 m90 *1 19.715,86.605
X$106 3 14 M2_M1_CDNS_40661956134218
* cell instance $107 r0 *1 32.405,86.605
X$107 3 12 M2_M1_CDNS_40661956134217
* cell instance $108 m90 *1 45.095,86.605
X$108 3 10 M2_M1_CDNS_40661956134218
* cell instance $109 m90 *1 56.945,86.605
X$109 3 17 M2_M1_CDNS_40661956134218
* cell instance $110 r0 *1 7.865,47.485
X$110 3 8 M2_M1_CDNS_40661956134218
* cell instance $111 m90 *1 19.715,47.485
X$111 3 14 M2_M1_CDNS_40661956134218
* cell instance $112 r0 *1 32.405,47.485
X$112 3 12 M2_M1_CDNS_40661956134217
* cell instance $113 m90 *1 45.095,47.485
X$113 3 10 M2_M1_CDNS_40661956134218
* cell instance $114 m90 *1 56.945,47.485
X$114 3 17 M2_M1_CDNS_40661956134218
* cell instance $115 r0 *1 7.865,45.045
X$115 3 8 M2_M1_CDNS_40661956134218
* cell instance $116 m90 *1 19.715,45.045
X$116 3 14 M2_M1_CDNS_40661956134218
* cell instance $117 r0 *1 32.405,45.045
X$117 3 12 M2_M1_CDNS_40661956134217
* cell instance $118 m90 *1 45.095,45.045
X$118 3 10 M2_M1_CDNS_40661956134218
* cell instance $119 m90 *1 56.945,45.045
X$119 3 17 M2_M1_CDNS_40661956134218
* cell instance $120 r0 *1 7.865,40.165
X$120 3 8 M2_M1_CDNS_40661956134218
* cell instance $121 m90 *1 19.715,40.165
X$121 3 14 M2_M1_CDNS_40661956134218
* cell instance $122 r0 *1 32.405,40.165
X$122 3 12 M2_M1_CDNS_40661956134217
* cell instance $123 m90 *1 45.095,40.165
X$123 3 10 M2_M1_CDNS_40661956134218
* cell instance $124 m90 *1 56.945,40.165
X$124 3 17 M2_M1_CDNS_40661956134218
* cell instance $125 r0 *1 7.865,30.325
X$125 3 8 M2_M1_CDNS_40661956134218
* cell instance $126 m90 *1 19.715,30.325
X$126 3 14 M2_M1_CDNS_40661956134218
* cell instance $127 r0 *1 32.405,30.325
X$127 3 12 M2_M1_CDNS_40661956134217
* cell instance $128 m90 *1 45.095,30.325
X$128 3 10 M2_M1_CDNS_40661956134218
* cell instance $129 m90 *1 56.945,30.325
X$129 3 17 M2_M1_CDNS_40661956134218
* cell instance $130 r0 *1 7.865,89.045
X$130 3 8 M2_M1_CDNS_40661956134218
* cell instance $131 m90 *1 19.715,89.045
X$131 3 14 M2_M1_CDNS_40661956134218
* cell instance $132 r0 *1 32.405,89.045
X$132 3 12 M2_M1_CDNS_40661956134217
* cell instance $133 m90 *1 45.095,89.045
X$133 3 10 M2_M1_CDNS_40661956134218
* cell instance $134 m90 *1 56.945,89.045
X$134 3 17 M2_M1_CDNS_40661956134218
* cell instance $135 r0 *1 7.865,108.645
X$135 3 8 M2_M1_CDNS_40661956134218
* cell instance $136 m90 *1 19.715,108.645
X$136 3 14 M2_M1_CDNS_40661956134218
* cell instance $137 r0 *1 32.405,108.645
X$137 3 12 M2_M1_CDNS_40661956134217
* cell instance $138 m90 *1 45.095,108.645
X$138 3 10 M2_M1_CDNS_40661956134218
* cell instance $139 m90 *1 56.945,108.645
X$139 3 17 M2_M1_CDNS_40661956134218
* cell instance $140 r0 *1 7.865,106.205
X$140 3 8 M2_M1_CDNS_40661956134218
* cell instance $141 m90 *1 19.715,106.205
X$141 3 14 M2_M1_CDNS_40661956134218
* cell instance $142 r0 *1 32.405,106.205
X$142 3 12 M2_M1_CDNS_40661956134217
* cell instance $143 m90 *1 45.095,106.205
X$143 3 10 M2_M1_CDNS_40661956134218
* cell instance $144 m90 *1 56.945,106.205
X$144 3 17 M2_M1_CDNS_40661956134218
* cell instance $145 r0 *1 7.865,81.725
X$145 3 8 M2_M1_CDNS_40661956134218
* cell instance $146 m90 *1 19.715,81.725
X$146 3 14 M2_M1_CDNS_40661956134218
* cell instance $147 r0 *1 32.405,81.725
X$147 3 12 M2_M1_CDNS_40661956134217
* cell instance $148 m90 *1 45.095,81.725
X$148 3 10 M2_M1_CDNS_40661956134218
* cell instance $149 m90 *1 56.945,81.725
X$149 3 17 M2_M1_CDNS_40661956134218
* cell instance $150 r0 *1 7.865,10.805
X$150 3 8 M2_M1_CDNS_40661956134218
* cell instance $151 m90 *1 19.715,10.805
X$151 3 14 M2_M1_CDNS_40661956134218
* cell instance $152 r0 *1 32.405,10.805
X$152 3 12 M2_M1_CDNS_40661956134217
* cell instance $153 m90 *1 45.095,10.805
X$153 3 10 M2_M1_CDNS_40661956134218
* cell instance $154 m90 *1 56.945,10.805
X$154 3 17 M2_M1_CDNS_40661956134218
* cell instance $155 r0 *1 7.865,8.365
X$155 3 8 M2_M1_CDNS_40661956134218
* cell instance $156 m90 *1 19.715,8.365
X$156 3 14 M2_M1_CDNS_40661956134218
* cell instance $157 r0 *1 32.405,8.365
X$157 3 12 M2_M1_CDNS_40661956134217
* cell instance $158 m90 *1 45.095,8.365
X$158 3 10 M2_M1_CDNS_40661956134218
* cell instance $159 m90 *1 56.945,8.365
X$159 3 17 M2_M1_CDNS_40661956134218
* cell instance $160 r0 *1 7.865,59.685
X$160 3 8 M2_M1_CDNS_40661956134218
* cell instance $161 m90 *1 19.715,59.685
X$161 3 14 M2_M1_CDNS_40661956134218
* cell instance $162 r0 *1 32.405,59.685
X$162 3 12 M2_M1_CDNS_40661956134217
* cell instance $163 m90 *1 45.095,59.685
X$163 3 10 M2_M1_CDNS_40661956134218
* cell instance $164 m90 *1 56.945,59.685
X$164 3 17 M2_M1_CDNS_40661956134218
* cell instance $165 r0 *1 7.865,42.605
X$165 3 8 M2_M1_CDNS_40661956134218
* cell instance $166 m90 *1 19.715,42.605
X$166 3 14 M2_M1_CDNS_40661956134218
* cell instance $167 r0 *1 32.405,42.605
X$167 3 12 M2_M1_CDNS_40661956134217
* cell instance $168 m90 *1 45.095,42.605
X$168 3 10 M2_M1_CDNS_40661956134218
* cell instance $169 m90 *1 56.945,42.605
X$169 3 17 M2_M1_CDNS_40661956134218
* cell instance $170 r0 *1 7.865,79.285
X$170 3 8 M2_M1_CDNS_40661956134218
* cell instance $171 m90 *1 19.715,79.285
X$171 3 14 M2_M1_CDNS_40661956134218
* cell instance $172 r0 *1 32.405,79.285
X$172 3 12 M2_M1_CDNS_40661956134217
* cell instance $173 m90 *1 45.095,79.285
X$173 3 10 M2_M1_CDNS_40661956134218
* cell instance $174 m90 *1 56.945,79.285
X$174 3 17 M2_M1_CDNS_40661956134218
* cell instance $175 r0 *1 7.865,76.845
X$175 3 8 M2_M1_CDNS_40661956134218
* cell instance $176 m90 *1 19.715,76.845
X$176 3 14 M2_M1_CDNS_40661956134218
* cell instance $177 r0 *1 32.405,76.845
X$177 3 12 M2_M1_CDNS_40661956134217
* cell instance $178 m90 *1 45.095,76.845
X$178 3 10 M2_M1_CDNS_40661956134218
* cell instance $179 m90 *1 56.945,76.845
X$179 3 17 M2_M1_CDNS_40661956134218
* cell instance $180 r0 *1 7.865,74.405
X$180 3 8 M2_M1_CDNS_40661956134218
* cell instance $181 m90 *1 19.715,74.405
X$181 3 14 M2_M1_CDNS_40661956134218
* cell instance $182 r0 *1 32.405,74.405
X$182 3 12 M2_M1_CDNS_40661956134217
* cell instance $183 m90 *1 45.095,74.405
X$183 3 10 M2_M1_CDNS_40661956134218
* cell instance $184 m90 *1 56.945,74.405
X$184 3 17 M2_M1_CDNS_40661956134218
* cell instance $185 r0 *1 7.865,67.085
X$185 3 8 M2_M1_CDNS_40661956134218
* cell instance $186 m90 *1 19.715,67.085
X$186 3 14 M2_M1_CDNS_40661956134218
* cell instance $187 r0 *1 32.405,67.085
X$187 3 12 M2_M1_CDNS_40661956134217
* cell instance $188 m90 *1 45.095,67.085
X$188 3 10 M2_M1_CDNS_40661956134218
* cell instance $189 m90 *1 56.945,67.085
X$189 3 17 M2_M1_CDNS_40661956134218
* cell instance $190 r0 *1 7.865,101.325
X$190 3 8 M2_M1_CDNS_40661956134218
* cell instance $191 m90 *1 19.715,101.325
X$191 3 14 M2_M1_CDNS_40661956134218
* cell instance $192 r0 *1 32.405,101.325
X$192 3 12 M2_M1_CDNS_40661956134217
* cell instance $193 m90 *1 45.095,101.325
X$193 3 10 M2_M1_CDNS_40661956134218
* cell instance $194 m90 *1 56.945,101.325
X$194 3 17 M2_M1_CDNS_40661956134218
* cell instance $195 r0 *1 7.865,37.725
X$195 3 8 M2_M1_CDNS_40661956134218
* cell instance $196 m90 *1 19.715,37.725
X$196 3 14 M2_M1_CDNS_40661956134218
* cell instance $197 r0 *1 32.405,37.725
X$197 3 12 M2_M1_CDNS_40661956134217
* cell instance $198 m90 *1 45.095,37.725
X$198 3 10 M2_M1_CDNS_40661956134218
* cell instance $199 m90 *1 56.945,37.725
X$199 3 17 M2_M1_CDNS_40661956134218
* cell instance $200 r0 *1 7.865,57.245
X$200 3 8 M2_M1_CDNS_40661956134218
* cell instance $201 m90 *1 19.715,57.245
X$201 3 14 M2_M1_CDNS_40661956134218
* cell instance $202 r0 *1 32.405,57.245
X$202 3 12 M2_M1_CDNS_40661956134217
* cell instance $203 m90 *1 45.095,57.245
X$203 3 10 M2_M1_CDNS_40661956134218
* cell instance $204 m90 *1 56.945,57.245
X$204 3 17 M2_M1_CDNS_40661956134218
* cell instance $205 r0 *1 7.865,54.805
X$205 3 8 M2_M1_CDNS_40661956134218
* cell instance $206 m90 *1 19.715,54.805
X$206 3 14 M2_M1_CDNS_40661956134218
* cell instance $207 r0 *1 32.405,54.805
X$207 3 12 M2_M1_CDNS_40661956134217
* cell instance $208 m90 *1 45.095,54.805
X$208 3 10 M2_M1_CDNS_40661956134218
* cell instance $209 m90 *1 56.945,54.805
X$209 3 17 M2_M1_CDNS_40661956134218
* cell instance $210 r0 *1 7.865,52.365
X$210 3 8 M2_M1_CDNS_40661956134218
* cell instance $211 m90 *1 19.715,52.365
X$211 3 14 M2_M1_CDNS_40661956134218
* cell instance $212 r0 *1 32.405,52.365
X$212 3 12 M2_M1_CDNS_40661956134217
* cell instance $213 m90 *1 45.095,52.365
X$213 3 10 M2_M1_CDNS_40661956134218
* cell instance $214 m90 *1 56.945,52.365
X$214 3 17 M2_M1_CDNS_40661956134218
* cell instance $215 r0 *1 7.865,113.525
X$215 3 8 M2_M1_CDNS_40661956134218
* cell instance $216 m90 *1 19.715,113.525
X$216 3 14 M2_M1_CDNS_40661956134218
* cell instance $217 r0 *1 32.405,113.525
X$217 3 12 M2_M1_CDNS_40661956134217
* cell instance $218 m90 *1 45.095,113.525
X$218 3 10 M2_M1_CDNS_40661956134218
* cell instance $219 m90 *1 56.945,113.525
X$219 3 17 M2_M1_CDNS_40661956134218
* cell instance $220 r0 *1 7.865,49.925
X$220 3 8 M2_M1_CDNS_40661956134218
* cell instance $221 m90 *1 19.715,49.925
X$221 3 14 M2_M1_CDNS_40661956134218
* cell instance $222 r0 *1 32.405,49.925
X$222 3 12 M2_M1_CDNS_40661956134217
* cell instance $223 m90 *1 45.095,49.925
X$223 3 10 M2_M1_CDNS_40661956134218
* cell instance $224 m90 *1 56.945,49.925
X$224 3 17 M2_M1_CDNS_40661956134218
* cell instance $225 r0 *1 7.865,1.135
X$225 3 8 M2_M1_CDNS_40661956134206
* cell instance $226 m90 *1 19.715,1.135
X$226 3 14 M2_M1_CDNS_40661956134206
* cell instance $227 r0 *1 32.405,1.135
X$227 3 12 M2_M1_CDNS_40661956134207
* cell instance $228 m90 *1 45.095,1.135
X$228 3 10 M2_M1_CDNS_40661956134206
* cell instance $229 m90 *1 56.945,1.135
X$229 3 17 M2_M1_CDNS_40661956134206
* cell instance $230 r0 *1 7.865,125.635
X$230 3 8 M2_M1_CDNS_40661956134206
* cell instance $231 m90 *1 19.715,125.635
X$231 3 14 M2_M1_CDNS_40661956134206
* cell instance $232 r0 *1 32.405,125.635
X$232 3 12 M2_M1_CDNS_40661956134207
* cell instance $233 m90 *1 45.095,125.635
X$233 3 10 M2_M1_CDNS_40661956134206
* cell instance $234 m90 *1 56.945,125.635
X$234 3 17 M2_M1_CDNS_40661956134206
* cell instance $235 r0 *1 32.405,34.025
X$235 5 4 M1_PSUB_CDNS_40661956134134
* cell instance $236 r0 *1 32.405,63.385
X$236 5 4 M1_PSUB_CDNS_40661956134134
* cell instance $237 r0 *1 32.405,92.745
X$237 5 4 M1_PSUB_CDNS_40661956134134
* cell instance $238 r0 *1 32.405,4.135
X$238 5 4 M1_PSUB_CDNS_40661956134138
* cell instance $239 r0 *1 32.405,122.635
X$239 5 4 M1_PSUB_CDNS_40661956134138
* cell instance $240 r0 *1 3.885,63.385
X$240 5 4 M1_PSUB_CDNS_40661956134137
* cell instance $241 r0 *1 60.925,63.385
X$241 5 4 M1_PSUB_CDNS_40661956134137
* cell instance $242 r0 *1 13.79,63.385
X$242 5 15 M2_M1_CDNS_40661956134255
* cell instance $243 r0 *1 25.64,63.385
X$243 5 13 M2_M1_CDNS_40661956134255
* cell instance $244 m90 *1 39.17,63.385
X$244 5 11 M2_M1_CDNS_40661956134255
* cell instance $245 m90 *1 51.02,63.385
X$245 5 9 M2_M1_CDNS_40661956134255
* cell instance $246 r0 *1 13.79,92.745
X$246 5 15 M2_M1_CDNS_40661956134255
* cell instance $247 r0 *1 25.64,92.745
X$247 5 13 M2_M1_CDNS_40661956134255
* cell instance $248 m90 *1 39.17,92.745
X$248 5 11 M2_M1_CDNS_40661956134255
* cell instance $249 m90 *1 51.02,92.745
X$249 5 9 M2_M1_CDNS_40661956134255
* cell instance $250 r0 *1 60.925,63.385
X$250 5 18 M2_M1_CDNS_40661956134268
* cell instance $251 r0 *1 13.79,43.825
X$251 5 15 M2_M1_CDNS_40661956134249
* cell instance $252 r0 *1 25.64,43.825
X$252 5 13 M2_M1_CDNS_40661956134249
* cell instance $253 m90 *1 39.17,43.825
X$253 5 11 M2_M1_CDNS_40661956134249
* cell instance $254 m90 *1 51.02,43.825
X$254 5 9 M2_M1_CDNS_40661956134249
* cell instance $255 r0 *1 13.79,46.265
X$255 5 15 M2_M1_CDNS_40661956134249
* cell instance $256 r0 *1 25.64,46.265
X$256 5 13 M2_M1_CDNS_40661956134249
* cell instance $257 m90 *1 39.17,46.265
X$257 5 11 M2_M1_CDNS_40661956134249
* cell instance $258 m90 *1 51.02,46.265
X$258 5 9 M2_M1_CDNS_40661956134249
* cell instance $259 r0 *1 13.79,29.105
X$259 5 15 M2_M1_CDNS_40661956134249
* cell instance $260 r0 *1 25.64,29.105
X$260 5 13 M2_M1_CDNS_40661956134249
* cell instance $261 m90 *1 39.17,29.105
X$261 5 11 M2_M1_CDNS_40661956134249
* cell instance $262 m90 *1 51.02,29.105
X$262 5 9 M2_M1_CDNS_40661956134249
* cell instance $263 r0 *1 13.79,41.385
X$263 5 15 M2_M1_CDNS_40661956134249
* cell instance $264 r0 *1 25.64,41.385
X$264 5 13 M2_M1_CDNS_40661956134249
* cell instance $265 m90 *1 39.17,41.385
X$265 5 11 M2_M1_CDNS_40661956134249
* cell instance $266 m90 *1 51.02,41.385
X$266 5 9 M2_M1_CDNS_40661956134249
* cell instance $267 r0 *1 13.79,38.945
X$267 5 15 M2_M1_CDNS_40661956134249
* cell instance $268 r0 *1 25.64,38.945
X$268 5 13 M2_M1_CDNS_40661956134249
* cell instance $269 m90 *1 39.17,38.945
X$269 5 11 M2_M1_CDNS_40661956134249
* cell instance $270 m90 *1 51.02,38.945
X$270 5 9 M2_M1_CDNS_40661956134249
* cell instance $271 r0 *1 13.79,36.505
X$271 5 15 M2_M1_CDNS_40661956134249
* cell instance $272 r0 *1 25.64,36.505
X$272 5 13 M2_M1_CDNS_40661956134249
* cell instance $273 m90 *1 39.17,36.505
X$273 5 11 M2_M1_CDNS_40661956134249
* cell instance $274 m90 *1 51.02,36.505
X$274 5 9 M2_M1_CDNS_40661956134249
* cell instance $275 r0 *1 13.79,31.545
X$275 5 15 M2_M1_CDNS_40661956134249
* cell instance $276 r0 *1 25.64,31.545
X$276 5 13 M2_M1_CDNS_40661956134249
* cell instance $277 m90 *1 39.17,31.545
X$277 5 11 M2_M1_CDNS_40661956134249
* cell instance $278 m90 *1 51.02,31.545
X$278 5 9 M2_M1_CDNS_40661956134249
* cell instance $279 r0 *1 13.79,60.905
X$279 5 15 M2_M1_CDNS_40661956134249
* cell instance $280 r0 *1 25.64,60.905
X$280 5 13 M2_M1_CDNS_40661956134249
* cell instance $281 m90 *1 39.17,60.905
X$281 5 11 M2_M1_CDNS_40661956134249
* cell instance $282 m90 *1 51.02,60.905
X$282 5 9 M2_M1_CDNS_40661956134249
* cell instance $283 r0 *1 13.79,117.185
X$283 5 15 M2_M1_CDNS_40661956134249
* cell instance $284 r0 *1 25.64,117.185
X$284 5 13 M2_M1_CDNS_40661956134249
* cell instance $285 m90 *1 39.17,117.185
X$285 5 11 M2_M1_CDNS_40661956134249
* cell instance $286 m90 *1 51.02,117.185
X$286 5 9 M2_M1_CDNS_40661956134249
* cell instance $287 r0 *1 13.79,78.065
X$287 5 15 M2_M1_CDNS_40661956134249
* cell instance $288 r0 *1 25.64,78.065
X$288 5 13 M2_M1_CDNS_40661956134249
* cell instance $289 m90 *1 39.17,78.065
X$289 5 11 M2_M1_CDNS_40661956134249
* cell instance $290 m90 *1 51.02,78.065
X$290 5 9 M2_M1_CDNS_40661956134249
* cell instance $291 r0 *1 13.79,75.625
X$291 5 15 M2_M1_CDNS_40661956134249
* cell instance $292 r0 *1 25.64,75.625
X$292 5 13 M2_M1_CDNS_40661956134249
* cell instance $293 m90 *1 39.17,75.625
X$293 5 11 M2_M1_CDNS_40661956134249
* cell instance $294 m90 *1 51.02,75.625
X$294 5 9 M2_M1_CDNS_40661956134249
* cell instance $295 r0 *1 13.79,73.185
X$295 5 15 M2_M1_CDNS_40661956134249
* cell instance $296 r0 *1 25.64,73.185
X$296 5 13 M2_M1_CDNS_40661956134249
* cell instance $297 m90 *1 39.17,73.185
X$297 5 11 M2_M1_CDNS_40661956134249
* cell instance $298 m90 *1 51.02,73.185
X$298 5 9 M2_M1_CDNS_40661956134249
* cell instance $299 r0 *1 13.79,70.745
X$299 5 15 M2_M1_CDNS_40661956134249
* cell instance $300 r0 *1 25.64,70.745
X$300 5 13 M2_M1_CDNS_40661956134249
* cell instance $301 m90 *1 39.17,70.745
X$301 5 11 M2_M1_CDNS_40661956134249
* cell instance $302 m90 *1 51.02,70.745
X$302 5 9 M2_M1_CDNS_40661956134249
* cell instance $303 r0 *1 13.79,68.305
X$303 5 15 M2_M1_CDNS_40661956134249
* cell instance $304 r0 *1 25.64,68.305
X$304 5 13 M2_M1_CDNS_40661956134249
* cell instance $305 m90 *1 39.17,68.305
X$305 5 11 M2_M1_CDNS_40661956134249
* cell instance $306 m90 *1 51.02,68.305
X$306 5 9 M2_M1_CDNS_40661956134249
* cell instance $307 r0 *1 13.79,65.865
X$307 5 15 M2_M1_CDNS_40661956134249
* cell instance $308 r0 *1 25.64,65.865
X$308 5 13 M2_M1_CDNS_40661956134249
* cell instance $309 m90 *1 39.17,65.865
X$309 5 11 M2_M1_CDNS_40661956134249
* cell instance $310 m90 *1 51.02,65.865
X$310 5 9 M2_M1_CDNS_40661956134249
* cell instance $311 r0 *1 13.79,85.385
X$311 5 15 M2_M1_CDNS_40661956134249
* cell instance $312 r0 *1 25.64,85.385
X$312 5 13 M2_M1_CDNS_40661956134249
* cell instance $313 m90 *1 39.17,85.385
X$313 5 11 M2_M1_CDNS_40661956134249
* cell instance $314 m90 *1 51.02,85.385
X$314 5 9 M2_M1_CDNS_40661956134249
* cell instance $315 r0 *1 13.79,82.945
X$315 5 15 M2_M1_CDNS_40661956134249
* cell instance $316 r0 *1 25.64,82.945
X$316 5 13 M2_M1_CDNS_40661956134249
* cell instance $317 m90 *1 39.17,82.945
X$317 5 11 M2_M1_CDNS_40661956134249
* cell instance $318 m90 *1 51.02,82.945
X$318 5 9 M2_M1_CDNS_40661956134249
* cell instance $319 r0 *1 13.79,87.825
X$319 5 15 M2_M1_CDNS_40661956134249
* cell instance $320 r0 *1 25.64,87.825
X$320 5 13 M2_M1_CDNS_40661956134249
* cell instance $321 m90 *1 39.17,87.825
X$321 5 11 M2_M1_CDNS_40661956134249
* cell instance $322 m90 *1 51.02,87.825
X$322 5 9 M2_M1_CDNS_40661956134249
* cell instance $323 r0 *1 13.79,90.265
X$323 5 15 M2_M1_CDNS_40661956134249
* cell instance $324 r0 *1 25.64,90.265
X$324 5 13 M2_M1_CDNS_40661956134249
* cell instance $325 m90 *1 39.17,90.265
X$325 5 11 M2_M1_CDNS_40661956134249
* cell instance $326 m90 *1 51.02,90.265
X$326 5 9 M2_M1_CDNS_40661956134249
* cell instance $327 r0 *1 13.79,95.225
X$327 5 15 M2_M1_CDNS_40661956134249
* cell instance $328 r0 *1 25.64,95.225
X$328 5 13 M2_M1_CDNS_40661956134249
* cell instance $329 m90 *1 39.17,95.225
X$329 5 11 M2_M1_CDNS_40661956134249
* cell instance $330 m90 *1 51.02,95.225
X$330 5 9 M2_M1_CDNS_40661956134249
* cell instance $331 r0 *1 13.79,100.105
X$331 5 15 M2_M1_CDNS_40661956134249
* cell instance $332 r0 *1 25.64,100.105
X$332 5 13 M2_M1_CDNS_40661956134249
* cell instance $333 m90 *1 39.17,100.105
X$333 5 11 M2_M1_CDNS_40661956134249
* cell instance $334 m90 *1 51.02,100.105
X$334 5 9 M2_M1_CDNS_40661956134249
* cell instance $335 r0 *1 13.79,102.545
X$335 5 15 M2_M1_CDNS_40661956134249
* cell instance $336 r0 *1 25.64,102.545
X$336 5 13 M2_M1_CDNS_40661956134249
* cell instance $337 m90 *1 39.17,102.545
X$337 5 11 M2_M1_CDNS_40661956134249
* cell instance $338 m90 *1 51.02,102.545
X$338 5 9 M2_M1_CDNS_40661956134249
* cell instance $339 r0 *1 13.79,104.985
X$339 5 15 M2_M1_CDNS_40661956134249
* cell instance $340 r0 *1 25.64,104.985
X$340 5 13 M2_M1_CDNS_40661956134249
* cell instance $341 m90 *1 39.17,104.985
X$341 5 11 M2_M1_CDNS_40661956134249
* cell instance $342 m90 *1 51.02,104.985
X$342 5 9 M2_M1_CDNS_40661956134249
* cell instance $343 r0 *1 13.79,107.425
X$343 5 15 M2_M1_CDNS_40661956134249
* cell instance $344 r0 *1 25.64,107.425
X$344 5 13 M2_M1_CDNS_40661956134249
* cell instance $345 m90 *1 39.17,107.425
X$345 5 11 M2_M1_CDNS_40661956134249
* cell instance $346 m90 *1 51.02,107.425
X$346 5 9 M2_M1_CDNS_40661956134249
* cell instance $347 r0 *1 13.79,109.865
X$347 5 15 M2_M1_CDNS_40661956134249
* cell instance $348 r0 *1 25.64,109.865
X$348 5 13 M2_M1_CDNS_40661956134249
* cell instance $349 m90 *1 39.17,109.865
X$349 5 11 M2_M1_CDNS_40661956134249
* cell instance $350 m90 *1 51.02,109.865
X$350 5 9 M2_M1_CDNS_40661956134249
* cell instance $351 r0 *1 13.79,112.305
X$351 5 15 M2_M1_CDNS_40661956134249
* cell instance $352 r0 *1 25.64,112.305
X$352 5 13 M2_M1_CDNS_40661956134249
* cell instance $353 m90 *1 39.17,112.305
X$353 5 11 M2_M1_CDNS_40661956134249
* cell instance $354 m90 *1 51.02,112.305
X$354 5 9 M2_M1_CDNS_40661956134249
* cell instance $355 r0 *1 13.79,114.745
X$355 5 15 M2_M1_CDNS_40661956134249
* cell instance $356 r0 *1 25.64,114.745
X$356 5 13 M2_M1_CDNS_40661956134249
* cell instance $357 m90 *1 39.17,114.745
X$357 5 11 M2_M1_CDNS_40661956134249
* cell instance $358 m90 *1 51.02,114.745
X$358 5 9 M2_M1_CDNS_40661956134249
* cell instance $359 r0 *1 13.79,119.625
X$359 5 15 M2_M1_CDNS_40661956134249
* cell instance $360 r0 *1 25.64,119.625
X$360 5 13 M2_M1_CDNS_40661956134249
* cell instance $361 m90 *1 39.17,119.625
X$361 5 11 M2_M1_CDNS_40661956134249
* cell instance $362 m90 *1 51.02,119.625
X$362 5 9 M2_M1_CDNS_40661956134249
* cell instance $363 r0 *1 13.79,97.665
X$363 5 15 M2_M1_CDNS_40661956134249
* cell instance $364 r0 *1 25.64,97.665
X$364 5 13 M2_M1_CDNS_40661956134249
* cell instance $365 m90 *1 39.17,97.665
X$365 5 11 M2_M1_CDNS_40661956134249
* cell instance $366 m90 *1 51.02,97.665
X$366 5 9 M2_M1_CDNS_40661956134249
* cell instance $367 r0 *1 13.79,7.145
X$367 5 15 M2_M1_CDNS_40661956134249
* cell instance $368 r0 *1 25.64,7.145
X$368 5 13 M2_M1_CDNS_40661956134249
* cell instance $369 m90 *1 39.17,7.145
X$369 5 11 M2_M1_CDNS_40661956134249
* cell instance $370 m90 *1 51.02,7.145
X$370 5 9 M2_M1_CDNS_40661956134249
* cell instance $371 r0 *1 13.79,12.025
X$371 5 15 M2_M1_CDNS_40661956134249
* cell instance $372 r0 *1 25.64,12.025
X$372 5 13 M2_M1_CDNS_40661956134249
* cell instance $373 m90 *1 39.17,12.025
X$373 5 11 M2_M1_CDNS_40661956134249
* cell instance $374 m90 *1 51.02,12.025
X$374 5 9 M2_M1_CDNS_40661956134249
* cell instance $375 r0 *1 13.79,14.465
X$375 5 15 M2_M1_CDNS_40661956134249
* cell instance $376 r0 *1 25.64,14.465
X$376 5 13 M2_M1_CDNS_40661956134249
* cell instance $377 m90 *1 39.17,14.465
X$377 5 11 M2_M1_CDNS_40661956134249
* cell instance $378 m90 *1 51.02,14.465
X$378 5 9 M2_M1_CDNS_40661956134249
* cell instance $379 r0 *1 13.79,16.905
X$379 5 15 M2_M1_CDNS_40661956134249
* cell instance $380 r0 *1 25.64,16.905
X$380 5 13 M2_M1_CDNS_40661956134249
* cell instance $381 m90 *1 39.17,16.905
X$381 5 11 M2_M1_CDNS_40661956134249
* cell instance $382 m90 *1 51.02,16.905
X$382 5 9 M2_M1_CDNS_40661956134249
* cell instance $383 r0 *1 13.79,19.345
X$383 5 15 M2_M1_CDNS_40661956134249
* cell instance $384 r0 *1 25.64,19.345
X$384 5 13 M2_M1_CDNS_40661956134249
* cell instance $385 m90 *1 39.17,19.345
X$385 5 11 M2_M1_CDNS_40661956134249
* cell instance $386 m90 *1 51.02,19.345
X$386 5 9 M2_M1_CDNS_40661956134249
* cell instance $387 r0 *1 13.79,21.785
X$387 5 15 M2_M1_CDNS_40661956134249
* cell instance $388 r0 *1 25.64,21.785
X$388 5 13 M2_M1_CDNS_40661956134249
* cell instance $389 m90 *1 39.17,21.785
X$389 5 11 M2_M1_CDNS_40661956134249
* cell instance $390 m90 *1 51.02,21.785
X$390 5 9 M2_M1_CDNS_40661956134249
* cell instance $391 r0 *1 13.79,24.225
X$391 5 15 M2_M1_CDNS_40661956134249
* cell instance $392 r0 *1 25.64,24.225
X$392 5 13 M2_M1_CDNS_40661956134249
* cell instance $393 m90 *1 39.17,24.225
X$393 5 11 M2_M1_CDNS_40661956134249
* cell instance $394 m90 *1 51.02,24.225
X$394 5 9 M2_M1_CDNS_40661956134249
* cell instance $395 r0 *1 13.79,26.665
X$395 5 15 M2_M1_CDNS_40661956134249
* cell instance $396 r0 *1 25.64,26.665
X$396 5 13 M2_M1_CDNS_40661956134249
* cell instance $397 m90 *1 39.17,26.665
X$397 5 11 M2_M1_CDNS_40661956134249
* cell instance $398 m90 *1 51.02,26.665
X$398 5 9 M2_M1_CDNS_40661956134249
* cell instance $399 r0 *1 13.79,58.465
X$399 5 15 M2_M1_CDNS_40661956134249
* cell instance $400 r0 *1 25.64,58.465
X$400 5 13 M2_M1_CDNS_40661956134249
* cell instance $401 m90 *1 39.17,58.465
X$401 5 11 M2_M1_CDNS_40661956134249
* cell instance $402 m90 *1 51.02,58.465
X$402 5 9 M2_M1_CDNS_40661956134249
* cell instance $403 r0 *1 13.79,9.585
X$403 5 15 M2_M1_CDNS_40661956134249
* cell instance $404 r0 *1 25.64,9.585
X$404 5 13 M2_M1_CDNS_40661956134249
* cell instance $405 m90 *1 39.17,9.585
X$405 5 11 M2_M1_CDNS_40661956134249
* cell instance $406 m90 *1 51.02,9.585
X$406 5 9 M2_M1_CDNS_40661956134249
* cell instance $407 r0 *1 13.79,80.505
X$407 5 15 M2_M1_CDNS_40661956134249
* cell instance $408 r0 *1 25.64,80.505
X$408 5 13 M2_M1_CDNS_40661956134249
* cell instance $409 m90 *1 39.17,80.505
X$409 5 11 M2_M1_CDNS_40661956134249
* cell instance $410 m90 *1 51.02,80.505
X$410 5 9 M2_M1_CDNS_40661956134249
* cell instance $411 r0 *1 13.79,51.145
X$411 5 15 M2_M1_CDNS_40661956134249
* cell instance $412 r0 *1 25.64,51.145
X$412 5 13 M2_M1_CDNS_40661956134249
* cell instance $413 m90 *1 39.17,51.145
X$413 5 11 M2_M1_CDNS_40661956134249
* cell instance $414 m90 *1 51.02,51.145
X$414 5 9 M2_M1_CDNS_40661956134249
* cell instance $415 r0 *1 13.79,53.585
X$415 5 15 M2_M1_CDNS_40661956134249
* cell instance $416 r0 *1 25.64,53.585
X$416 5 13 M2_M1_CDNS_40661956134249
* cell instance $417 m90 *1 39.17,53.585
X$417 5 11 M2_M1_CDNS_40661956134249
* cell instance $418 m90 *1 51.02,53.585
X$418 5 9 M2_M1_CDNS_40661956134249
* cell instance $419 r0 *1 13.79,56.025
X$419 5 15 M2_M1_CDNS_40661956134249
* cell instance $420 r0 *1 25.64,56.025
X$420 5 13 M2_M1_CDNS_40661956134249
* cell instance $421 m90 *1 39.17,56.025
X$421 5 11 M2_M1_CDNS_40661956134249
* cell instance $422 m90 *1 51.02,56.025
X$422 5 9 M2_M1_CDNS_40661956134249
* cell instance $423 r0 *1 13.79,48.705
X$423 5 15 M2_M1_CDNS_40661956134249
* cell instance $424 r0 *1 25.64,48.705
X$424 5 13 M2_M1_CDNS_40661956134249
* cell instance $425 m90 *1 39.17,48.705
X$425 5 11 M2_M1_CDNS_40661956134249
* cell instance $426 m90 *1 51.02,48.705
X$426 5 9 M2_M1_CDNS_40661956134249
* cell instance $427 r0 *1 13.79,4.135
X$427 5 15 M2_M1_CDNS_40661956134247
* cell instance $428 r0 *1 25.64,4.135
X$428 5 13 M2_M1_CDNS_40661956134247
* cell instance $429 m90 *1 39.17,4.135
X$429 5 11 M2_M1_CDNS_40661956134247
* cell instance $430 m90 *1 51.02,4.135
X$430 5 9 M2_M1_CDNS_40661956134247
* cell instance $431 r0 *1 13.79,122.635
X$431 5 15 M2_M1_CDNS_40661956134247
* cell instance $432 r0 *1 25.64,122.635
X$432 5 13 M2_M1_CDNS_40661956134247
* cell instance $433 m90 *1 39.17,122.635
X$433 5 11 M2_M1_CDNS_40661956134247
* cell instance $434 m90 *1 51.02,122.635
X$434 5 9 M2_M1_CDNS_40661956134247
* cell instance $435 r0 *1 13.79,34.025
X$435 5 15 M2_M1_CDNS_40661956134255
* cell instance $436 r0 *1 25.64,34.025
X$436 5 13 M2_M1_CDNS_40661956134255
* cell instance $437 m90 *1 39.17,34.025
X$437 5 11 M2_M1_CDNS_40661956134255
* cell instance $438 m90 *1 51.02,34.025
X$438 5 9 M2_M1_CDNS_40661956134255
* cell instance $439 r0 *1 3.885,63.385
X$439 5 6 M2_M1_CDNS_40661956134268
.ENDS nmos_clamp_20_50_4_DVSS

* cell M2_M1_CDNS_40661956134232
* pin
* pin
.SUBCKT M2_M1_CDNS_40661956134232 1 2
.ENDS M2_M1_CDNS_40661956134232

* cell M2_M1_CDNS_40661956134233
* pin
* pin
.SUBCKT M2_M1_CDNS_40661956134233 1 2
.ENDS M2_M1_CDNS_40661956134233

* cell M2_M1_CDNS_40661956134237
* pin
* pin
.SUBCKT M2_M1_CDNS_40661956134237 1 2
.ENDS M2_M1_CDNS_40661956134237

* cell M2_M1_CDNS_40661956134238
* pin
* pin
.SUBCKT M2_M1_CDNS_40661956134238 1 2
.ENDS M2_M1_CDNS_40661956134238

* cell M2_M1_CDNS_40661956134242
* pin
* pin
.SUBCKT M2_M1_CDNS_40661956134242 1 2
.ENDS M2_M1_CDNS_40661956134242

* cell M1_PSUB_CDNS_40661956134243
* pin
* pin
.SUBCKT M1_PSUB_CDNS_40661956134243 1 2
.ENDS M1_PSUB_CDNS_40661956134243

* cell M1_PSUB_CDNS_40661956134244
* pin
* pin
.SUBCKT M1_PSUB_CDNS_40661956134244 1 2
.ENDS M1_PSUB_CDNS_40661956134244

* cell M2_M1_CDNS_40661956134245
* pin
* pin
.SUBCKT M2_M1_CDNS_40661956134245 1 2
.ENDS M2_M1_CDNS_40661956134245

* cell M1_PSUB_CDNS_4066195613410
* pin
* pin
.SUBCKT M1_PSUB_CDNS_4066195613410 1 2
.ENDS M1_PSUB_CDNS_4066195613410

* cell M1_PSUB_CDNS_4066195613413
* pin
* pin
.SUBCKT M1_PSUB_CDNS_4066195613413 1 2
.ENDS M1_PSUB_CDNS_4066195613413

* cell M1_PSUB_CDNS_4066195613412
* pin
* pin
.SUBCKT M1_PSUB_CDNS_4066195613412 1 2
.ENDS M1_PSUB_CDNS_4066195613412

* cell M1_PSUB_CDNS_4066195613417
* pin
* pin
.SUBCKT M1_PSUB_CDNS_4066195613417 1 2
.ENDS M1_PSUB_CDNS_4066195613417

* cell M1_PSUB_CDNS_4066195613416
* pin
* pin
.SUBCKT M1_PSUB_CDNS_4066195613416 1 2
.ENDS M1_PSUB_CDNS_4066195613416

* cell M1_PSUB_CDNS_4066195613415
* pin
* pin
.SUBCKT M1_PSUB_CDNS_4066195613415 1 2
.ENDS M1_PSUB_CDNS_4066195613415

* cell M1_PSUB_CDNS_4066195613414
* pin
* pin
.SUBCKT M1_PSUB_CDNS_4066195613414 1 2
.ENDS M1_PSUB_CDNS_4066195613414

* cell power_via_cor_5
* pin
* pin
* pin
* pin
* pin
* pin
* pin
* pin
* pin
* pin
* pin
* pin
* pin
* pin
* pin
* pin
* pin
* pin
* pin
* pin
* pin
* pin
* pin
* pin
* pin
* pin
* pin
* pin
* pin
* pin
* pin
* pin
* pin
* pin
* pin
* pin
* pin
* pin
* pin
* pin
* pin
* pin
* pin
* pin
* pin
* pin
* pin
* pin
* pin
* pin
* pin
* pin
* pin
* pin
* pin
* pin
* pin
* pin
* pin
* pin
* pin
* pin
* pin
* pin
* pin
* pin
* pin
* pin
* pin
* pin
* pin
* pin
* pin
* pin
* pin
* pin
* pin
* pin
* pin
* pin
* pin
* pin
* pin
* pin
* pin
* pin
* pin
* pin
* pin
* pin
* pin
* pin
* pin
* pin
* pin
* pin
* pin
* pin
* pin
* pin
* pin
* pin
* pin
* pin
* pin
* pin
* pin
* pin
* pin
* pin
* pin
* pin
* pin
* pin
* pin
* pin
* pin
* pin
* pin
* pin
* pin
* pin
* pin
* pin
* pin
* pin
* pin
* pin
* pin
* pin
* pin
* pin
* pin
* pin
* pin
* pin
* pin
* pin
* pin
* pin
* pin
* pin
* pin
* pin
* pin
* pin
* pin
* pin
* pin
* pin
* pin
* pin
* pin
* pin
* pin
* pin
* pin
* pin
* pin
* pin
* pin
* pin
* pin
* pin
* pin
* pin
* pin
* pin
* pin
* pin
* pin
* pin
* pin
* pin
* pin
* pin
* pin
* pin
* pin
* pin
* pin
* pin
* pin
* pin
* pin
* pin
* pin
* pin
* pin
* pin
* pin
* pin
* pin
* pin
* pin
* pin
* pin
* pin
* pin
* pin
* pin
* pin
* pin
* pin
* pin
* pin
* pin
* pin
* pin
* pin
* pin
* pin
* pin
* pin
* pin
* pin
* pin
* pin
* pin
* pin
* pin
* pin
* pin
* pin
* pin
* pin
* pin
* pin
* pin
* pin
* pin
* pin
* pin
* pin
* pin
* pin
* pin
* pin
* pin
* pin
* pin
* pin
* pin
* pin
* pin
* pin
* pin
* pin
* pin
* pin
* pin
* pin
* pin
* pin
* pin
* pin
* pin
* pin
* pin
* pin
* pin
* pin
* pin
* pin
* pin
* pin
* pin
* pin
* pin
* pin
* pin
* pin
* pin
* pin
* pin
* pin
* pin
* pin
* pin
* pin
* pin
* pin
* pin
* pin
* pin
* pin
* pin
* pin
* pin
* pin
* pin
* pin
.SUBCKT power_via_cor_5 1 2 3 4 5 6 7 8 9 10 11 12 13 14 15 16 17 18 19 20 21
+ 22 23 24 25 26 27 28 29 30 31 32 33 34 35 36 37 38 39 40 41 42 43 44 45 46 47
+ 48 49 50 51 52 53 54 55 56 57 58 59 60 61 62 63 64 65 66 67 68 69 70 71 72 73
+ 74 75 76 77 78 79 80 81 82 83 84 85 86 87 88 89 90 91 92 93 94 95 96 97 98 99
+ 100 101 102 103 104 105 106 107 108 109 110 111 112 113 114 115 116 117 118
+ 119 120 121 122 123 124 125 126 127 128 129 130 131 132 133 134 135 136 137
+ 138 139 140 141 142 143 144 145 146 147 148 149 150 151 152 153 154 155 156
+ 157 158 159 160 161 162 163 164 165 166 167 168 169 170 171 172 173 174 175
+ 176 177 178 179 180 181 182 183 184 185 186 187 188 189 190 191 192 193 194
+ 195 196 197 198 199 200 201 202 203 204 205 206 207 208 209 210 211 212 213
+ 214 215 216 217 218 219 220 221 222 223 224 225 226 227 228 229 230 231 232
+ 233 234 235 236 237 238 239 240 241 242 243 244 245 246 247 248 249 250 251
+ 252 253 254 255 256 257 258 259 260 261 262 263 264 265 266 267 268 269 270
+ 271 272 273 274 275 276 277 278 279 280 281 282 283 284 285 286 287 288 289
+ 290 293 294
* cell instance $1 r0 *1 12.775,174.94
X$1 3 1 M3_M2_CDNS_40661956134157
* cell instance $2 r0 *1 5.915,158.77
X$2 4 2 M3_M2_CDNS_40661956134157
* cell instance $3 r0 *1 20.835,168.575
X$3 6 5 M3_M2_CDNS_40661956134158
* cell instance $4 r0 *1 19.595,169.21
X$4 9 7 M3_M2_CDNS_40661956134159
* cell instance $5 r0 *1 20.215,168.855
X$5 10 8 M3_M2_CDNS_40661956134159
* cell instance $6 r0 *1 18.975,169.42
X$6 12 11 M3_M2_CDNS_40661956134160
* cell instance $7 r0 *1 18.355,169.625
X$7 14 13 M3_M2_CDNS_40661956134161
* cell instance $8 r0 *1 17.735,169.98
X$8 16 15 M3_M2_CDNS_40661956134162
* cell instance $9 r0 *1 6.535,158.15
X$9 31 17 M3_M2_CDNS_40661956134163
* cell instance $10 r0 *1 9.635,155.05
X$10 32 18 M3_M2_CDNS_40661956134163
* cell instance $11 r0 *1 10.255,154.43
X$11 33 19 M3_M2_CDNS_40661956134163
* cell instance $12 r0 *1 13.395,174.32
X$12 34 20 M3_M2_CDNS_40661956134163
* cell instance $13 r0 *1 15.255,172.46
X$13 35 21 M3_M2_CDNS_40661956134163
* cell instance $14 r0 *1 15.875,171.84
X$14 36 22 M3_M2_CDNS_40661956134163
* cell instance $15 r0 *1 17.115,170.6
X$15 37 23 M3_M2_CDNS_40661956134163
* cell instance $16 r0 *1 7.155,157.53
X$16 38 24 M3_M2_CDNS_40661956134163
* cell instance $17 r0 *1 8.395,156.29
X$17 39 25 M3_M2_CDNS_40661956134163
* cell instance $18 r0 *1 9.015,155.67
X$18 40 26 M3_M2_CDNS_40661956134163
* cell instance $19 r0 *1 7.775,156.91
X$19 41 27 M3_M2_CDNS_40661956134163
* cell instance $20 r0 *1 14.015,173.7
X$20 42 28 M3_M2_CDNS_40661956134163
* cell instance $21 r0 *1 14.635,173.08
X$21 43 29 M3_M2_CDNS_40661956134163
* cell instance $22 r0 *1 16.495,171.22
X$22 44 30 M3_M2_CDNS_40661956134163
* cell instance $23 r0 *1 5.66,221.795
X$23 47 45 M3_M2_CDNS_40661956134164
* cell instance $24 r0 *1 5.775,142.055
X$24 48 46 M3_M2_CDNS_40661956134164
* cell instance $25 r0 *1 7.015,140.815
X$25 58 49 M3_M2_CDNS_40661956134165
* cell instance $26 r0 *1 6.395,141.435
X$26 59 50 M3_M2_CDNS_40661956134165
* cell instance $27 r0 *1 6.9,220.555
X$27 60 51 M3_M2_CDNS_40661956134165
* cell instance $28 r0 *1 9.38,218.075
X$28 61 52 M3_M2_CDNS_40661956134165
* cell instance $29 r0 *1 10,217.455
X$29 62 53 M3_M2_CDNS_40661956134165
* cell instance $30 r0 *1 8.76,218.695
X$30 63 54 M3_M2_CDNS_40661956134165
* cell instance $31 r0 *1 8.14,219.315
X$31 64 55 M3_M2_CDNS_40661956134165
* cell instance $32 r0 *1 7.52,219.935
X$32 65 56 M3_M2_CDNS_40661956134165
* cell instance $33 r0 *1 6.28,221.175
X$33 66 57 M3_M2_CDNS_40661956134165
* cell instance $34 r0 *1 57.875,71.48
X$34 84 67 M3_M2_CDNS_40661956134156
* cell instance $35 r0 *1 48.235,39.48
X$35 85 68 M3_M2_CDNS_40661956134156
* cell instance $36 r0 *1 48.235,23.48
X$36 86 69 M3_M2_CDNS_40661956134156
* cell instance $37 r0 *1 48.235,7.48
X$37 87 70 M3_M2_CDNS_40661956134156
* cell instance $38 r0 *1 57.875,87.48
X$38 88 71 M3_M2_CDNS_40661956134156
* cell instance $39 r0 *1 48.235,167.48
X$39 89 72 M3_M2_CDNS_40661956134156
* cell instance $40 r0 *1 57.875,151.48
X$40 90 73 M3_M2_CDNS_40661956134156
* cell instance $41 r0 *1 57.875,103.48
X$41 91 74 M3_M2_CDNS_40661956134156
* cell instance $42 r0 *1 26.655,87.48
X$42 92 75 M3_M2_CDNS_40661956134156
* cell instance $43 r0 *1 26.655,151.48
X$43 93 76 M3_M2_CDNS_40661956134156
* cell instance $44 r0 *1 26.655,71.48
X$44 94 77 M3_M2_CDNS_40661956134156
* cell instance $45 r0 *1 17.015,39.48
X$45 95 78 M3_M2_CDNS_40661956134156
* cell instance $46 r0 *1 17.015,23.48
X$46 96 79 M3_M2_CDNS_40661956134156
* cell instance $47 r0 *1 17.015,7.48
X$47 97 80 M3_M2_CDNS_40661956134156
* cell instance $48 r0 *1 26.655,119.48
X$48 98 81 M3_M2_CDNS_40661956134156
* cell instance $49 r0 *1 57.875,119.48
X$49 99 82 M3_M2_CDNS_40661956134156
* cell instance $50 r0 *1 26.655,103.48
X$50 100 83 M3_M2_CDNS_40661956134156
* cell instance $51 r0 *1 66.88,23.48
X$51 118 101 M3_M2_CDNS_40661956134155
* cell instance $52 r0 *1 66.88,7.48
X$52 119 102 M3_M2_CDNS_40661956134155
* cell instance $53 r0 *1 40.43,151.48
X$53 120 103 M3_M2_CDNS_40661956134155
* cell instance $54 r0 *1 40.43,71.48
X$54 121 104 M3_M2_CDNS_40661956134155
* cell instance $55 r0 *1 66.88,39.48
X$55 122 105 M3_M2_CDNS_40661956134155
* cell instance $56 r0 *1 40.43,87.48
X$56 123 106 M3_M2_CDNS_40661956134155
* cell instance $57 r0 *1 40.43,103.48
X$57 124 107 M3_M2_CDNS_40661956134155
* cell instance $58 r0 *1 40.43,119.48
X$58 125 108 M3_M2_CDNS_40661956134155
* cell instance $59 r0 *1 66.88,167.48
X$59 126 109 M3_M2_CDNS_40661956134155
* cell instance $60 r0 *1 34.46,167.48
X$60 127 110 M3_M2_CDNS_40661956134155
* cell instance $61 r0 *1 34.46,23.48
X$61 128 111 M3_M2_CDNS_40661956134155
* cell instance $62 r0 *1 34.46,7.48
X$62 129 112 M3_M2_CDNS_40661956134155
* cell instance $63 r0 *1 8.01,119.48
X$63 130 113 M3_M2_CDNS_40661956134155
* cell instance $64 r0 *1 8.01,103.48
X$64 131 114 M3_M2_CDNS_40661956134155
* cell instance $65 r0 *1 8.01,87.48
X$65 132 115 M3_M2_CDNS_40661956134155
* cell instance $66 r0 *1 8.01,71.48
X$66 133 116 M3_M2_CDNS_40661956134155
* cell instance $67 r0 *1 34.46,39.48
X$67 134 117 M3_M2_CDNS_40661956134155
* cell instance $68 r0 *1 22.49,215.95
X$68 138 135 M3_M2_CDNS_40661956134120
* cell instance $69 r0 *1 22.49,227.445
X$69 139 136 M3_M2_CDNS_40661956134120
* cell instance $70 r0 *1 22.49,204.775
X$70 140 137 M3_M2_CDNS_40661956134120
* cell instance $71 r0 *1 9.495,139.455
X$71 143 141 M3_M2_CDNS_40661956134121
* cell instance $72 r0 *1 10.115,139.445
X$72 144 142 M3_M2_CDNS_40661956134121
* cell instance $73 r0 *1 30.55,219.385
X$73 193 145 M3_M2_CDNS_40661956134122
* cell instance $74 r0 *1 26.21,223.725
X$74 194 146 M3_M2_CDNS_40661956134122
* cell instance $75 r0 *1 25.59,212.85
X$75 195 147 M3_M2_CDNS_40661956134122
* cell instance $76 r0 *1 24.35,214.09
X$76 196 148 M3_M2_CDNS_40661956134122
* cell instance $77 r0 *1 34.59,226.7
X$77 197 149 M3_M2_CDNS_40661956134122
* cell instance $78 r0 *1 33.97,227.32
X$78 198 150 M3_M2_CDNS_40661956134122
* cell instance $79 r0 *1 33.35,227.94
X$79 199 151 M3_M2_CDNS_40661956134122
* cell instance $80 r0 *1 23.11,215.33
X$80 200 152 M3_M2_CDNS_40661956134122
* cell instance $81 r0 *1 24.97,224.965
X$81 201 153 M3_M2_CDNS_40661956134122
* cell instance $82 r0 *1 26.83,223.105
X$82 202 154 M3_M2_CDNS_40661956134122
* cell instance $83 r0 *1 32.11,229.18
X$83 203 155 M3_M2_CDNS_40661956134122
* cell instance $84 r0 *1 25.59,224.345
X$84 204 156 M3_M2_CDNS_40661956134122
* cell instance $85 r0 *1 28.69,198.575
X$85 205 157 M3_M2_CDNS_40661956134122
* cell instance $86 r0 *1 29.31,197.955
X$86 206 158 M3_M2_CDNS_40661956134122
* cell instance $87 r0 *1 29.93,197.335
X$87 207 159 M3_M2_CDNS_40661956134122
* cell instance $88 r0 *1 30.55,196.715
X$88 208 160 M3_M2_CDNS_40661956134122
* cell instance $89 r0 *1 23.11,204.155
X$89 209 161 M3_M2_CDNS_40661956134122
* cell instance $90 r0 *1 23.73,203.535
X$90 210 162 M3_M2_CDNS_40661956134122
* cell instance $91 r0 *1 24.35,202.915
X$91 211 163 M3_M2_CDNS_40661956134122
* cell instance $92 r0 *1 27.45,222.485
X$92 212 164 M3_M2_CDNS_40661956134122
* cell instance $93 r0 *1 25.59,201.675
X$93 213 165 M3_M2_CDNS_40661956134122
* cell instance $94 r0 *1 26.21,201.055
X$94 214 166 M3_M2_CDNS_40661956134122
* cell instance $95 r0 *1 26.83,200.435
X$95 215 167 M3_M2_CDNS_40661956134122
* cell instance $96 r0 *1 27.45,199.815
X$96 216 168 M3_M2_CDNS_40661956134122
* cell instance $97 r0 *1 28.07,199.195
X$97 217 169 M3_M2_CDNS_40661956134122
* cell instance $98 r0 *1 28.07,210.37
X$98 218 170 M3_M2_CDNS_40661956134122
* cell instance $99 r0 *1 7.635,140.44
X$99 219 171 M3_M2_CDNS_40661956134122
* cell instance $100 r0 *1 32.73,228.56
X$100 220 172 M3_M2_CDNS_40661956134122
* cell instance $101 r0 *1 24.97,202.295
X$101 221 173 M3_M2_CDNS_40661956134122
* cell instance $102 r0 *1 29.93,208.51
X$102 222 174 M3_M2_CDNS_40661956134122
* cell instance $103 r0 *1 30.55,207.89
X$103 223 175 M3_M2_CDNS_40661956134122
* cell instance $104 r0 *1 26.83,211.61
X$104 224 176 M3_M2_CDNS_40661956134122
* cell instance $105 r0 *1 36.45,224.84
X$105 225 177 M3_M2_CDNS_40661956134122
* cell instance $106 r0 *1 27.45,210.99
X$106 226 178 M3_M2_CDNS_40661956134122
* cell instance $107 r0 *1 35.21,226.08
X$107 227 179 M3_M2_CDNS_40661956134122
* cell instance $108 r0 *1 28.69,209.75
X$108 228 180 M3_M2_CDNS_40661956134122
* cell instance $109 r0 *1 29.93,220.005
X$109 229 181 M3_M2_CDNS_40661956134122
* cell instance $110 r0 *1 29.31,220.625
X$110 230 182 M3_M2_CDNS_40661956134122
* cell instance $111 r0 *1 23.73,226.205
X$111 231 183 M3_M2_CDNS_40661956134122
* cell instance $112 r0 *1 35.83,225.46
X$112 232 184 M3_M2_CDNS_40661956134122
* cell instance $113 r0 *1 24.35,225.585
X$113 233 185 M3_M2_CDNS_40661956134122
* cell instance $114 r0 *1 26.21,212.23
X$114 234 186 M3_M2_CDNS_40661956134122
* cell instance $115 r0 *1 29.31,209.13
X$115 235 187 M3_M2_CDNS_40661956134122
* cell instance $116 r0 *1 28.07,221.865
X$116 236 188 M3_M2_CDNS_40661956134122
* cell instance $117 r0 *1 23.73,214.71
X$117 237 189 M3_M2_CDNS_40661956134122
* cell instance $118 r0 *1 23.11,226.825
X$118 238 190 M3_M2_CDNS_40661956134122
* cell instance $119 r0 *1 24.97,213.47
X$119 239 191 M3_M2_CDNS_40661956134122
* cell instance $120 r0 *1 28.69,221.245
X$120 240 192 M3_M2_CDNS_40661956134122
* cell instance $121 r0 *1 8.255,140.18
X$121 242 241 M3_M2_CDNS_40661956134123
* cell instance $122 r0 *1 8.875,139.715
X$122 244 243 M3_M2_CDNS_40661956134124
* cell instance $123 r0 *1 66.88,131.48
X$123 245 268 M3_M2_CDNS_40661956134118
* cell instance $124 r0 *1 66.88,219.48
X$124 246 269 M3_M2_CDNS_40661956134118
* cell instance $125 r0 *1 34.46,131.48
X$125 247 270 M3_M2_CDNS_40661956134118
* cell instance $126 r0 *1 40.43,51.48
X$126 248 271 M3_M2_CDNS_40661956134118
* cell instance $127 r0 *1 40.43,195.48
X$127 249 272 M3_M2_CDNS_40661956134118
* cell instance $128 r0 *1 40.43,203.48
X$128 250 273 M3_M2_CDNS_40661956134118
* cell instance $129 r0 *1 40.43,139.48
X$129 251 274 M3_M2_CDNS_40661956134118
* cell instance $130 r0 *1 40.43,211.48
X$130 252 275 M3_M2_CDNS_40661956134118
* cell instance $131 r0 *1 66.88,59.48
X$131 253 276 M3_M2_CDNS_40661956134118
* cell instance $132 r0 *1 34.46,59.48
X$132 254 277 M3_M2_CDNS_40661956134118
* cell instance $133 r0 *1 8.01,51.48
X$133 255 278 M3_M2_CDNS_40661956134118
* cell instance $134 r0 *1 17.015,59.48
X$134 256 279 M3_M2_CDNS_40661956134119
* cell instance $135 r0 *1 26.655,139.48
X$135 257 280 M3_M2_CDNS_40661956134119
* cell instance $136 r0 *1 17.015,131.48
X$136 258 281 M3_M2_CDNS_40661956134119
* cell instance $137 r0 *1 48.235,59.48
X$137 259 282 M3_M2_CDNS_40661956134119
* cell instance $138 r0 *1 26.655,51.48
X$138 260 283 M3_M2_CDNS_40661956134119
* cell instance $139 r0 *1 57.875,195.48
X$139 261 284 M3_M2_CDNS_40661956134119
* cell instance $140 r0 *1 57.875,203.48
X$140 262 285 M3_M2_CDNS_40661956134119
* cell instance $141 r0 *1 57.875,211.48
X$141 263 286 M3_M2_CDNS_40661956134119
* cell instance $142 r0 *1 48.235,219.48
X$142 264 287 M3_M2_CDNS_40661956134119
* cell instance $143 r0 *1 57.875,51.48
X$143 265 288 M3_M2_CDNS_40661956134119
* cell instance $144 r0 *1 48.235,131.48
X$144 266 289 M3_M2_CDNS_40661956134119
* cell instance $145 r0 *1 57.875,139.48
X$145 267 290 M3_M2_CDNS_40661956134119
* cell instance $146 r0 *1 73.975,179.48
X$146 293 291 M3_M2_CDNS_40661956134114
* cell instance $147 r0 *1 73.975,179.48
X$147 293 291 M2_M1_CDNS_40661956134115
* cell instance $148 r0 *1 73.975,251.48
X$148 294 292 M3_M2_CDNS_40661956134114
* cell instance $149 r0 *1 73.975,251.48
X$149 294 292 M2_M1_CDNS_40661956134115
.ENDS power_via_cor_5

* cell power_via_cor_3
* pin
* pin
* pin
* pin
* pin
* pin
* pin
* pin
* pin
* pin
* pin
* pin
* pin
* pin
* pin
* pin
* pin
* pin
* pin
* pin
* pin
* pin
* pin
* pin
* pin
* pin
* pin
* pin
* pin
* pin
* pin
* pin
* pin
* pin
* pin
* pin
* pin
* pin
* pin
* pin
* pin
* pin
* pin
* pin
* pin
* pin
* pin
* pin
* pin
* pin
* pin
* pin
* pin
* pin
* pin
* pin
* pin
* pin
* pin
* pin
* pin
* pin
* pin
* pin
* pin
* pin
* pin
* pin
* pin
* pin
* pin
* pin
* pin
* pin
* pin
* pin
* pin
* pin
* pin
* pin
* pin
* pin
* pin
* pin
* pin
* pin
* pin
* pin
* pin
* pin
* pin
* pin
* pin
* pin
* pin
* pin
.SUBCKT power_via_cor_3 1 2 3 4 5 6 7 8 9 10 11 12 13 14 15 16 17 18 19 20 21
+ 22 23 24 25 26 27 28 29 30 31 32 33 34 35 36 37 38 39 40 41 42 43 44 45 46 47
+ 48 49 50 51 52 53 54 55 56 57 58 59 60 61 62 63 64 65 66 67 68 69 70 71 72 73
+ 74 75 76 77 78 79 80 81 82 83 84 85 86 87 88 89 90 91 92 93 94 97 98
* cell instance $1 r0 *1 57.875,243.49
X$1 4 1 M3_M2_CDNS_40661956134119
* cell instance $2 r0 *1 66.88,251.45
X$2 5 2 M3_M2_CDNS_40661956134118
* cell instance $3 r0 *1 45.75,260.755
X$3 6 3 M3_M2_CDNS_40661956134112
* cell instance $4 r0 *1 40.25,254.95
X$4 8 7 M3_M2_CDNS_40661956134113
* cell instance $5 r0 *1 32.96,274.22
X$5 10 9 M3_M2_CDNS_40661956134116
* cell instance $6 r0 *1 40.25,273.035
X$6 12 11 M3_M2_CDNS_40661956134117
* cell instance $7 r0 *1 12.775,191.855
X$7 16 13 M3_M2_CDNS_40661956134120
* cell instance $8 r0 *1 22.49,193.45
X$8 17 14 M3_M2_CDNS_40661956134120
* cell instance $9 r0 *1 5.66,210.28
X$9 18 15 M3_M2_CDNS_40661956134120
* cell instance $10 r0 *1 29.31,187.57
X$10 22 19 M3_M2_CDNS_40661956134121
* cell instance $11 r0 *1 29.93,187.465
X$11 23 20 M3_M2_CDNS_40661956134121
* cell instance $12 r0 *1 30.55,187.46
X$12 24 21 M3_M2_CDNS_40661956134121
* cell instance $13 r0 *1 27.45,188.49
X$13 53 25 M3_M2_CDNS_40661956134122
* cell instance $14 r0 *1 17.735,186.895
X$14 54 26 M3_M2_CDNS_40661956134122
* cell instance $15 r0 *1 18.975,185.655
X$15 55 27 M3_M2_CDNS_40661956134122
* cell instance $16 r0 *1 19.595,185.035
X$16 56 28 M3_M2_CDNS_40661956134122
* cell instance $17 r0 *1 18.355,186.275
X$17 57 29 M3_M2_CDNS_40661956134122
* cell instance $18 r0 *1 10,205.94
X$18 58 30 M3_M2_CDNS_40661956134122
* cell instance $19 r0 *1 9.38,206.56
X$19 59 31 M3_M2_CDNS_40661956134122
* cell instance $20 r0 *1 8.76,207.18
X$20 60 32 M3_M2_CDNS_40661956134122
* cell instance $21 r0 *1 8.14,207.8
X$21 61 33 M3_M2_CDNS_40661956134122
* cell instance $22 r0 *1 7.52,208.42
X$22 62 34 M3_M2_CDNS_40661956134122
* cell instance $23 r0 *1 6.9,209.04
X$23 63 35 M3_M2_CDNS_40661956134122
* cell instance $24 r0 *1 6.28,209.66
X$24 64 36 M3_M2_CDNS_40661956134122
* cell instance $25 r0 *1 26.21,189.73
X$25 65 37 M3_M2_CDNS_40661956134122
* cell instance $26 r0 *1 26.83,189.11
X$26 66 38 M3_M2_CDNS_40661956134122
* cell instance $27 r0 *1 15.255,189.375
X$27 67 39 M3_M2_CDNS_40661956134122
* cell instance $28 r0 *1 15.875,188.755
X$28 68 40 M3_M2_CDNS_40661956134122
* cell instance $29 r0 *1 16.495,188.135
X$29 69 41 M3_M2_CDNS_40661956134122
* cell instance $30 r0 *1 23.11,192.83
X$30 70 42 M3_M2_CDNS_40661956134122
* cell instance $31 r0 *1 17.115,187.515
X$31 71 43 M3_M2_CDNS_40661956134122
* cell instance $32 r0 *1 20.215,184.415
X$32 72 44 M3_M2_CDNS_40661956134122
* cell instance $33 r0 *1 20.835,183.795
X$33 73 45 M3_M2_CDNS_40661956134122
* cell instance $34 r0 *1 23.73,192.21
X$34 74 46 M3_M2_CDNS_40661956134122
* cell instance $35 r0 *1 24.35,191.59
X$35 75 47 M3_M2_CDNS_40661956134122
* cell instance $36 r0 *1 24.97,190.97
X$36 76 48 M3_M2_CDNS_40661956134122
* cell instance $37 r0 *1 25.59,190.35
X$37 77 49 M3_M2_CDNS_40661956134122
* cell instance $38 r0 *1 14.015,190.615
X$38 78 50 M3_M2_CDNS_40661956134122
* cell instance $39 r0 *1 13.395,191.235
X$39 79 51 M3_M2_CDNS_40661956134122
* cell instance $40 r0 *1 14.635,189.995
X$40 80 52 M3_M2_CDNS_40661956134122
* cell instance $41 r0 *1 28.07,188.15
X$41 82 81 M3_M2_CDNS_40661956134123
* cell instance $42 r0 *1 28.69,187.815
X$42 84 83 M3_M2_CDNS_40661956134124
* cell instance $43 r0 *1 66.88,179.48
X$43 85 90 M3_M2_CDNS_40661956134118
* cell instance $44 r0 *1 40.43,187.48
X$44 86 91 M3_M2_CDNS_40661956134118
* cell instance $45 r0 *1 34.46,179.48
X$45 87 92 M3_M2_CDNS_40661956134118
* cell instance $46 r0 *1 57.875,187.48
X$46 88 93 M3_M2_CDNS_40661956134119
* cell instance $47 r0 *1 48.235,179.48
X$47 89 94 M3_M2_CDNS_40661956134119
* cell instance $48 r0 *1 73.975,179.48
X$48 97 95 M2_M1_CDNS_40661956134115
* cell instance $49 r0 *1 73.975,179.48
X$49 97 95 M3_M2_CDNS_40661956134114
* cell instance $50 r0 *1 73.975,251.48
X$50 98 96 M2_M1_CDNS_40661956134115
* cell instance $51 r0 *1 73.975,251.48
X$51 98 96 M3_M2_CDNS_40661956134114
.ENDS power_via_cor_3

* cell top_routing_cor
* pin DVDD
* pin DVSS
* pin VDD
* pin VSS
.SUBCKT top_routing_cor 1 2 3 4
* net 1 DVDD
* net 2 DVSS
* net 3 VDD
* net 4 VSS
.ENDS top_routing_cor

* cell comp018green_esd_clamp_v5p0_2
* pin
* pin
* pin gf180mcu_gnd
* pin
* pin
* pin
* pin
* pin
* pin
* pin
* pin
.SUBCKT comp018green_esd_clamp_v5p0_2 1 4 10 11 12 13 14 15 16 17 18
* net 10 gf180mcu_gnd
* cell instance $1 r0 *1 20.645,130.03
X$1 1 5 2 10 nmos_6p0_CDNS_406619561347
* cell instance $2 r0 *1 33.275,130.03
X$2 20 1 6 1 6 1 6 1 7 7 7 7 7 7 nmos_6p0_CDNS_406619561346
* cell instance $3 r0 *1 25.955,130.03
X$3 20 1 7 1 7 1 7 1 5 5 5 5 5 5 nmos_6p0_CDNS_406619561346
* cell instance $4 m0 *1 -1.78,232.535
X$4 4 2 1 10 comp018green_esd_rc_v5p0
* cell instance $5 r0 *1 0.215,128.085
X$5 1 18 17 15 16 13 14 12 11 1 4 top_route_1
* cell instance $6 m0 *1 11.49,132.61
X$6 1 3 M1_PSUB_CDNS_40661956134125
* cell instance $7 m0 *1 53.32,132.61
X$7 1 3 M1_PSUB_CDNS_40661956134125
* cell instance $8 r0 *1 0,0
X$8 6 4 1 18 17 22 16 15 14 13 12 21 11 10 nmos_clamp_20_50_4
* cell instance $9 r0 *1 15.505,137.795
X$9 2 M1_POLY2_CDNS_40661956134127
* cell instance $10 r0 *1 20.71,135.54
X$10 2 M1_POLY2_CDNS_40661956134128
* cell instance $11 r0 *1 13.325,138.945
X$11 19 5 4 5 4 4 2 2 2 2 9 4 pmos_6p0_CDNS_406619561344
* cell instance $12 r0 *1 11.49,141.595
X$12 4 8 9 4 M1_NWELL_CDNS_40661956134133
* cell instance $13 r0 *1 53.32,141.595
X$13 4 8 9 4 M1_NWELL_CDNS_40661956134133
* cell instance $14 r0 *1 22.725,138.945
X$14 4 6 4 6 4 6 4 6 4 6 4 6 4 6 4 6 4 6 4 6 4 6 4 6 4 7 7 7 7 7 7 7 7 7 7 7 7
+ 7 7 7 7 7 7 7 7 7 7 7 7 9 4 pmos_6p0_CDNS_406619561342
* cell instance $15 r0 *1 18.205,138.945
X$15 19 7 4 4 7 5 5 5 9 4 pmos_6p0_CDNS_406619561343
* cell instance $16 r0 *1 32.405,145.185
X$16 4 8 9 4 M1_NWELL_CDNS_40661956134129
* cell instance $17 r0 *1 19.775,137.795
X$17 5 M1_POLY2_CDNS_40661956134130
* cell instance $18 r0 *1 29.355,136.18
X$18 5 M1_POLY2_CDNS_40661956134131
* cell instance $19 r0 *1 6.565,127.585
X$19 6 22 M2_M1_CDNS_40661956134126
* cell instance $20 r0 *1 58.245,127.585
X$20 6 21 M2_M1_CDNS_40661956134126
* cell instance $21 r0 *1 37.105,137.795
X$21 7 M1_POLY2_CDNS_40661956134132
* cell instance $22 r0 *1 36.675,136.18
X$22 7 M1_POLY2_CDNS_40661956134131
* device instance $1 r0 *1 13.675,141.445 pmos_6p0
M$1 5 2 4 4 pmos_6p0 L=0.7U W=5U AS=2.2P AD=1.3P PS=10.88U PD=5.52U
* device instance $2 r0 *1 14.895,141.445 pmos_6p0
M$2 4 2 5 4 pmos_6p0 L=0.7U W=5U AS=1.3P AD=1.3P PS=5.52U PD=5.52U
* device instance $3 r0 *1 16.115,141.445 pmos_6p0
M$3 5 2 4 4 pmos_6p0 L=0.7U W=5U AS=1.3P AD=1.3P PS=5.52U PD=5.52U
* device instance $4 r0 *1 17.335,141.445 pmos_6p0
M$4 4 2 5 4 pmos_6p0 L=0.7U W=5U AS=1.3P AD=1.3P PS=5.52U PD=5.52U
* device instance $5 r0 *1 18.555,141.445 pmos_6p0
M$5 7 5 4 4 pmos_6p0 L=0.7U W=5U AS=1.3P AD=1.3P PS=5.52U PD=5.52U
* device instance $6 r0 *1 19.775,141.445 pmos_6p0
M$6 4 5 7 4 pmos_6p0 L=0.7U W=5U AS=1.3P AD=1.3P PS=5.52U PD=5.52U
* device instance $7 r0 *1 20.995,141.445 pmos_6p0
M$7 7 5 4 4 pmos_6p0 L=0.7U W=5U AS=1.3P AD=2.2P PS=5.52U PD=10.88U
* device instance $8 r0 *1 23.075,141.445 pmos_6p0
M$8 6 7 4 4 pmos_6p0 L=0.7U W=5U AS=2.2P AD=1.3P PS=10.88U PD=5.52U
* device instance $9 r0 *1 24.295,141.445 pmos_6p0
M$9 4 7 6 4 pmos_6p0 L=0.7U W=5U AS=1.3P AD=1.3P PS=5.52U PD=5.52U
* device instance $10 r0 *1 25.515,141.445 pmos_6p0
M$10 6 7 4 4 pmos_6p0 L=0.7U W=5U AS=1.3P AD=1.3P PS=5.52U PD=5.52U
* device instance $11 r0 *1 26.735,141.445 pmos_6p0
M$11 4 7 6 4 pmos_6p0 L=0.7U W=5U AS=1.3P AD=1.3P PS=5.52U PD=5.52U
* device instance $12 r0 *1 27.955,141.445 pmos_6p0
M$12 6 7 4 4 pmos_6p0 L=0.7U W=5U AS=1.3P AD=1.3P PS=5.52U PD=5.52U
* device instance $13 r0 *1 29.175,141.445 pmos_6p0
M$13 4 7 6 4 pmos_6p0 L=0.7U W=5U AS=1.3P AD=1.3P PS=5.52U PD=5.52U
* device instance $14 r0 *1 30.395,141.445 pmos_6p0
M$14 6 7 4 4 pmos_6p0 L=0.7U W=5U AS=1.3P AD=1.3P PS=5.52U PD=5.52U
* device instance $15 r0 *1 31.615,141.445 pmos_6p0
M$15 4 7 6 4 pmos_6p0 L=0.7U W=5U AS=1.3P AD=1.3P PS=5.52U PD=5.52U
* device instance $16 r0 *1 32.835,141.445 pmos_6p0
M$16 6 7 4 4 pmos_6p0 L=0.7U W=5U AS=1.3P AD=1.3P PS=5.52U PD=5.52U
* device instance $17 r0 *1 34.055,141.445 pmos_6p0
M$17 4 7 6 4 pmos_6p0 L=0.7U W=5U AS=1.3P AD=1.3P PS=5.52U PD=5.52U
* device instance $18 r0 *1 35.275,141.445 pmos_6p0
M$18 6 7 4 4 pmos_6p0 L=0.7U W=5U AS=1.3P AD=1.3P PS=5.52U PD=5.52U
* device instance $19 r0 *1 36.495,141.445 pmos_6p0
M$19 4 7 6 4 pmos_6p0 L=0.7U W=5U AS=1.3P AD=1.3P PS=5.52U PD=5.52U
* device instance $20 r0 *1 37.715,141.445 pmos_6p0
M$20 6 7 4 4 pmos_6p0 L=0.7U W=5U AS=1.3P AD=1.3P PS=5.52U PD=5.52U
* device instance $21 r0 *1 38.935,141.445 pmos_6p0
M$21 4 7 6 4 pmos_6p0 L=0.7U W=5U AS=1.3P AD=1.3P PS=5.52U PD=5.52U
* device instance $22 r0 *1 40.155,141.445 pmos_6p0
M$22 6 7 4 4 pmos_6p0 L=0.7U W=5U AS=1.3P AD=1.3P PS=5.52U PD=5.52U
* device instance $23 r0 *1 41.375,141.445 pmos_6p0
M$23 4 7 6 4 pmos_6p0 L=0.7U W=5U AS=1.3P AD=1.3P PS=5.52U PD=5.52U
* device instance $24 r0 *1 42.595,141.445 pmos_6p0
M$24 6 7 4 4 pmos_6p0 L=0.7U W=5U AS=1.3P AD=1.3P PS=5.52U PD=5.52U
* device instance $25 r0 *1 43.815,141.445 pmos_6p0
M$25 4 7 6 4 pmos_6p0 L=0.7U W=5U AS=1.3P AD=1.3P PS=5.52U PD=5.52U
* device instance $26 r0 *1 45.035,141.445 pmos_6p0
M$26 6 7 4 4 pmos_6p0 L=0.7U W=5U AS=1.3P AD=1.3P PS=5.52U PD=5.52U
* device instance $27 r0 *1 46.255,141.445 pmos_6p0
M$27 4 7 6 4 pmos_6p0 L=0.7U W=5U AS=1.3P AD=1.3P PS=5.52U PD=5.52U
* device instance $28 r0 *1 47.475,141.445 pmos_6p0
M$28 6 7 4 4 pmos_6p0 L=0.7U W=5U AS=1.3P AD=1.3P PS=5.52U PD=5.52U
* device instance $29 r0 *1 48.695,141.445 pmos_6p0
M$29 4 7 6 4 pmos_6p0 L=0.7U W=5U AS=1.3P AD=1.3P PS=5.52U PD=5.52U
* device instance $30 r0 *1 49.915,141.445 pmos_6p0
M$30 6 7 4 4 pmos_6p0 L=0.7U W=5U AS=1.3P AD=1.3P PS=5.52U PD=5.52U
* device instance $31 r0 *1 51.135,141.445 pmos_6p0
M$31 4 7 6 4 pmos_6p0 L=0.7U W=5U AS=1.3P AD=2.2P PS=5.52U PD=10.88U
* device instance $32 r0 *1 26.305,132.53 nmos_6p0
M$32 7 5 1 10 nmos_6p0 L=0.7U W=5U AS=2.2P AD=1.3P PS=10.88U PD=5.52U
* device instance $33 r0 *1 27.525,132.53 nmos_6p0
M$33 1 5 7 10 nmos_6p0 L=0.7U W=5U AS=1.3P AD=1.3P PS=5.52U PD=5.52U
* device instance $34 r0 *1 28.745,132.53 nmos_6p0
M$34 7 5 1 10 nmos_6p0 L=0.7U W=5U AS=1.3P AD=1.3P PS=5.52U PD=5.52U
* device instance $35 r0 *1 29.965,132.53 nmos_6p0
M$35 1 5 7 10 nmos_6p0 L=0.7U W=5U AS=1.3P AD=1.3P PS=5.52U PD=5.52U
* device instance $36 r0 *1 31.185,132.53 nmos_6p0
M$36 7 5 1 10 nmos_6p0 L=0.7U W=5U AS=1.3P AD=1.3P PS=5.52U PD=5.52U
* device instance $37 r0 *1 32.405,132.53 nmos_6p0
M$37 1 5 7 10 nmos_6p0 L=0.7U W=5U AS=1.3P AD=1.3P PS=5.52U PD=5.52U
* device instance $38 r0 *1 33.625,132.53 nmos_6p0
M$38 6 7 1 10 nmos_6p0 L=0.7U W=5U AS=1.3P AD=1.3P PS=5.52U PD=5.52U
* device instance $39 r0 *1 34.845,132.53 nmos_6p0
M$39 1 7 6 10 nmos_6p0 L=0.7U W=5U AS=1.3P AD=1.3P PS=5.52U PD=5.52U
* device instance $40 r0 *1 36.065,132.53 nmos_6p0
M$40 6 7 1 10 nmos_6p0 L=0.7U W=5U AS=1.3P AD=1.3P PS=5.52U PD=5.52U
* device instance $41 r0 *1 37.285,132.53 nmos_6p0
M$41 1 7 6 10 nmos_6p0 L=0.7U W=5U AS=1.3P AD=1.3P PS=5.52U PD=5.52U
* device instance $42 r0 *1 38.505,132.53 nmos_6p0
M$42 6 7 1 10 nmos_6p0 L=0.7U W=5U AS=1.3P AD=1.3P PS=5.52U PD=5.52U
* device instance $43 r0 *1 39.725,132.53 nmos_6p0
M$43 1 7 6 10 nmos_6p0 L=0.7U W=5U AS=1.3P AD=2.2P PS=5.52U PD=10.88U
.ENDS comp018green_esd_clamp_v5p0_2

* cell comp018green_esd_clamp_v5p0_1
* pin
* pin
* pin gf180mcu_gnd
* pin
* pin
* pin
* pin
* pin
* pin
* pin
* pin
.SUBCKT comp018green_esd_clamp_v5p0_1 1 4 10 11 12 13 14 15 16 17 18
* net 10 gf180mcu_gnd
* cell instance $1 r0 *1 20.645,130.03
X$1 1 5 2 10 nmos_6p0_CDNS_406619561347
* cell instance $2 m0 *1 53.32,132.61
X$2 1 3 M1_PSUB_CDNS_40661956134125
* cell instance $3 r0 *1 0.215,128.085
X$3 15 16 12 11 1 4 1 18 17 13 14 top_route
* cell instance $4 r0 *1 0,0
X$4 6 4 1 18 17 22 16 15 14 13 12 21 11 10 nmos_clamp_20_50_4
* cell instance $5 m0 *1 11.49,132.61
X$5 1 3 M1_PSUB_CDNS_40661956134125
* cell instance $6 m0 *1 -1.78,232.535
X$6 4 2 1 10 comp018green_esd_rc_v5p0_1
* cell instance $7 r0 *1 33.275,130.03
X$7 20 1 6 1 6 1 6 1 7 7 7 7 7 7 nmos_6p0_CDNS_406619561346
* cell instance $8 r0 *1 25.955,130.03
X$8 20 1 7 1 7 1 7 1 5 5 5 5 5 5 nmos_6p0_CDNS_406619561346
* cell instance $9 r0 *1 20.71,135.54
X$9 2 M1_POLY2_CDNS_40661956134128
* cell instance $10 r0 *1 15.505,137.795
X$10 2 M1_POLY2_CDNS_40661956134127
* cell instance $11 r0 *1 13.325,138.945
X$11 19 5 4 5 4 4 2 2 2 2 9 4 pmos_6p0_CDNS_406619561344
* cell instance $12 r0 *1 11.49,141.595
X$12 4 8 9 4 M1_NWELL_CDNS_40661956134133
* cell instance $13 r0 *1 53.32,141.595
X$13 4 8 9 4 M1_NWELL_CDNS_40661956134133
* cell instance $14 r0 *1 32.405,145.185
X$14 4 8 9 4 M1_NWELL_CDNS_40661956134129
* cell instance $15 r0 *1 22.725,138.945
X$15 4 6 4 6 4 6 4 6 4 6 4 6 4 6 4 6 4 6 4 6 4 6 4 6 4 7 7 7 7 7 7 7 7 7 7 7 7
+ 7 7 7 7 7 7 7 7 7 7 7 7 9 4 pmos_6p0_CDNS_406619561342
* cell instance $16 r0 *1 18.205,138.945
X$16 19 7 4 4 7 5 5 5 9 4 pmos_6p0_CDNS_406619561343
* cell instance $17 r0 *1 29.355,136.18
X$17 5 M1_POLY2_CDNS_40661956134131
* cell instance $18 r0 *1 19.775,137.795
X$18 5 M1_POLY2_CDNS_40661956134130
* cell instance $19 r0 *1 6.565,127.585
X$19 6 22 M2_M1_CDNS_40661956134126
* cell instance $20 r0 *1 58.245,127.585
X$20 6 21 M2_M1_CDNS_40661956134126
* cell instance $21 r0 *1 36.675,136.18
X$21 7 M1_POLY2_CDNS_40661956134131
* cell instance $22 r0 *1 37.105,137.795
X$22 7 M1_POLY2_CDNS_40661956134132
* device instance $1 r0 *1 13.675,141.445 pmos_6p0
M$1 5 2 4 4 pmos_6p0 L=0.7U W=5U AS=2.2P AD=1.3P PS=10.88U PD=5.52U
* device instance $2 r0 *1 14.895,141.445 pmos_6p0
M$2 4 2 5 4 pmos_6p0 L=0.7U W=5U AS=1.3P AD=1.3P PS=5.52U PD=5.52U
* device instance $3 r0 *1 16.115,141.445 pmos_6p0
M$3 5 2 4 4 pmos_6p0 L=0.7U W=5U AS=1.3P AD=1.3P PS=5.52U PD=5.52U
* device instance $4 r0 *1 17.335,141.445 pmos_6p0
M$4 4 2 5 4 pmos_6p0 L=0.7U W=5U AS=1.3P AD=1.3P PS=5.52U PD=5.52U
* device instance $5 r0 *1 18.555,141.445 pmos_6p0
M$5 7 5 4 4 pmos_6p0 L=0.7U W=5U AS=1.3P AD=1.3P PS=5.52U PD=5.52U
* device instance $6 r0 *1 19.775,141.445 pmos_6p0
M$6 4 5 7 4 pmos_6p0 L=0.7U W=5U AS=1.3P AD=1.3P PS=5.52U PD=5.52U
* device instance $7 r0 *1 20.995,141.445 pmos_6p0
M$7 7 5 4 4 pmos_6p0 L=0.7U W=5U AS=1.3P AD=2.2P PS=5.52U PD=10.88U
* device instance $8 r0 *1 23.075,141.445 pmos_6p0
M$8 6 7 4 4 pmos_6p0 L=0.7U W=5U AS=2.2P AD=1.3P PS=10.88U PD=5.52U
* device instance $9 r0 *1 24.295,141.445 pmos_6p0
M$9 4 7 6 4 pmos_6p0 L=0.7U W=5U AS=1.3P AD=1.3P PS=5.52U PD=5.52U
* device instance $10 r0 *1 25.515,141.445 pmos_6p0
M$10 6 7 4 4 pmos_6p0 L=0.7U W=5U AS=1.3P AD=1.3P PS=5.52U PD=5.52U
* device instance $11 r0 *1 26.735,141.445 pmos_6p0
M$11 4 7 6 4 pmos_6p0 L=0.7U W=5U AS=1.3P AD=1.3P PS=5.52U PD=5.52U
* device instance $12 r0 *1 27.955,141.445 pmos_6p0
M$12 6 7 4 4 pmos_6p0 L=0.7U W=5U AS=1.3P AD=1.3P PS=5.52U PD=5.52U
* device instance $13 r0 *1 29.175,141.445 pmos_6p0
M$13 4 7 6 4 pmos_6p0 L=0.7U W=5U AS=1.3P AD=1.3P PS=5.52U PD=5.52U
* device instance $14 r0 *1 30.395,141.445 pmos_6p0
M$14 6 7 4 4 pmos_6p0 L=0.7U W=5U AS=1.3P AD=1.3P PS=5.52U PD=5.52U
* device instance $15 r0 *1 31.615,141.445 pmos_6p0
M$15 4 7 6 4 pmos_6p0 L=0.7U W=5U AS=1.3P AD=1.3P PS=5.52U PD=5.52U
* device instance $16 r0 *1 32.835,141.445 pmos_6p0
M$16 6 7 4 4 pmos_6p0 L=0.7U W=5U AS=1.3P AD=1.3P PS=5.52U PD=5.52U
* device instance $17 r0 *1 34.055,141.445 pmos_6p0
M$17 4 7 6 4 pmos_6p0 L=0.7U W=5U AS=1.3P AD=1.3P PS=5.52U PD=5.52U
* device instance $18 r0 *1 35.275,141.445 pmos_6p0
M$18 6 7 4 4 pmos_6p0 L=0.7U W=5U AS=1.3P AD=1.3P PS=5.52U PD=5.52U
* device instance $19 r0 *1 36.495,141.445 pmos_6p0
M$19 4 7 6 4 pmos_6p0 L=0.7U W=5U AS=1.3P AD=1.3P PS=5.52U PD=5.52U
* device instance $20 r0 *1 37.715,141.445 pmos_6p0
M$20 6 7 4 4 pmos_6p0 L=0.7U W=5U AS=1.3P AD=1.3P PS=5.52U PD=5.52U
* device instance $21 r0 *1 38.935,141.445 pmos_6p0
M$21 4 7 6 4 pmos_6p0 L=0.7U W=5U AS=1.3P AD=1.3P PS=5.52U PD=5.52U
* device instance $22 r0 *1 40.155,141.445 pmos_6p0
M$22 6 7 4 4 pmos_6p0 L=0.7U W=5U AS=1.3P AD=1.3P PS=5.52U PD=5.52U
* device instance $23 r0 *1 41.375,141.445 pmos_6p0
M$23 4 7 6 4 pmos_6p0 L=0.7U W=5U AS=1.3P AD=1.3P PS=5.52U PD=5.52U
* device instance $24 r0 *1 42.595,141.445 pmos_6p0
M$24 6 7 4 4 pmos_6p0 L=0.7U W=5U AS=1.3P AD=1.3P PS=5.52U PD=5.52U
* device instance $25 r0 *1 43.815,141.445 pmos_6p0
M$25 4 7 6 4 pmos_6p0 L=0.7U W=5U AS=1.3P AD=1.3P PS=5.52U PD=5.52U
* device instance $26 r0 *1 45.035,141.445 pmos_6p0
M$26 6 7 4 4 pmos_6p0 L=0.7U W=5U AS=1.3P AD=1.3P PS=5.52U PD=5.52U
* device instance $27 r0 *1 46.255,141.445 pmos_6p0
M$27 4 7 6 4 pmos_6p0 L=0.7U W=5U AS=1.3P AD=1.3P PS=5.52U PD=5.52U
* device instance $28 r0 *1 47.475,141.445 pmos_6p0
M$28 6 7 4 4 pmos_6p0 L=0.7U W=5U AS=1.3P AD=1.3P PS=5.52U PD=5.52U
* device instance $29 r0 *1 48.695,141.445 pmos_6p0
M$29 4 7 6 4 pmos_6p0 L=0.7U W=5U AS=1.3P AD=1.3P PS=5.52U PD=5.52U
* device instance $30 r0 *1 49.915,141.445 pmos_6p0
M$30 6 7 4 4 pmos_6p0 L=0.7U W=5U AS=1.3P AD=1.3P PS=5.52U PD=5.52U
* device instance $31 r0 *1 51.135,141.445 pmos_6p0
M$31 4 7 6 4 pmos_6p0 L=0.7U W=5U AS=1.3P AD=2.2P PS=5.52U PD=10.88U
* device instance $32 r0 *1 26.305,132.53 nmos_6p0
M$32 7 5 1 10 nmos_6p0 L=0.7U W=5U AS=2.2P AD=1.3P PS=10.88U PD=5.52U
* device instance $33 r0 *1 27.525,132.53 nmos_6p0
M$33 1 5 7 10 nmos_6p0 L=0.7U W=5U AS=1.3P AD=1.3P PS=5.52U PD=5.52U
* device instance $34 r0 *1 28.745,132.53 nmos_6p0
M$34 7 5 1 10 nmos_6p0 L=0.7U W=5U AS=1.3P AD=1.3P PS=5.52U PD=5.52U
* device instance $35 r0 *1 29.965,132.53 nmos_6p0
M$35 1 5 7 10 nmos_6p0 L=0.7U W=5U AS=1.3P AD=1.3P PS=5.52U PD=5.52U
* device instance $36 r0 *1 31.185,132.53 nmos_6p0
M$36 7 5 1 10 nmos_6p0 L=0.7U W=5U AS=1.3P AD=1.3P PS=5.52U PD=5.52U
* device instance $37 r0 *1 32.405,132.53 nmos_6p0
M$37 1 5 7 10 nmos_6p0 L=0.7U W=5U AS=1.3P AD=1.3P PS=5.52U PD=5.52U
* device instance $38 r0 *1 33.625,132.53 nmos_6p0
M$38 6 7 1 10 nmos_6p0 L=0.7U W=5U AS=1.3P AD=1.3P PS=5.52U PD=5.52U
* device instance $39 r0 *1 34.845,132.53 nmos_6p0
M$39 1 7 6 10 nmos_6p0 L=0.7U W=5U AS=1.3P AD=1.3P PS=5.52U PD=5.52U
* device instance $40 r0 *1 36.065,132.53 nmos_6p0
M$40 6 7 1 10 nmos_6p0 L=0.7U W=5U AS=1.3P AD=1.3P PS=5.52U PD=5.52U
* device instance $41 r0 *1 37.285,132.53 nmos_6p0
M$41 1 7 6 10 nmos_6p0 L=0.7U W=5U AS=1.3P AD=1.3P PS=5.52U PD=5.52U
* device instance $42 r0 *1 38.505,132.53 nmos_6p0
M$42 6 7 1 10 nmos_6p0 L=0.7U W=5U AS=1.3P AD=1.3P PS=5.52U PD=5.52U
* device instance $43 r0 *1 39.725,132.53 nmos_6p0
M$43 1 7 6 10 nmos_6p0 L=0.7U W=5U AS=1.3P AD=2.2P PS=5.52U PD=10.88U
.ENDS comp018green_esd_clamp_v5p0_1

* cell M1_PSUB_CDNS_4066195613418
* pin
.SUBCKT M1_PSUB_CDNS_4066195613418 1
.ENDS M1_PSUB_CDNS_4066195613418

* cell M3_M2_CDNS_40661956134108
* pin
* pin
.SUBCKT M3_M2_CDNS_40661956134108 1 2
.ENDS M3_M2_CDNS_40661956134108

* cell M3_M2_CDNS_4066195613491
* pin
* pin
.SUBCKT M3_M2_CDNS_4066195613491 1 2
.ENDS M3_M2_CDNS_4066195613491

* cell M2_M1_CDNS_4066195613492
* pin
* pin
.SUBCKT M2_M1_CDNS_4066195613492 1 2
.ENDS M2_M1_CDNS_4066195613492

* cell M2_M1_CDNS_4066195613470
* pin
* pin
.SUBCKT M2_M1_CDNS_4066195613470 1 2
.ENDS M2_M1_CDNS_4066195613470

* cell M3_M2_CDNS_4066195613493
* pin
* pin
.SUBCKT M3_M2_CDNS_4066195613493 1 2
.ENDS M3_M2_CDNS_4066195613493

* cell M2_M1_CDNS_4066195613494
* pin
* pin
.SUBCKT M2_M1_CDNS_4066195613494 1 2
.ENDS M2_M1_CDNS_4066195613494

* cell M2_M1_CDNS_40661956134109
* pin
* pin
.SUBCKT M2_M1_CDNS_40661956134109 1 2
.ENDS M2_M1_CDNS_40661956134109

* cell M2_M1_CDNS_40661956134110
* pin
* pin
.SUBCKT M2_M1_CDNS_40661956134110 1 2
.ENDS M2_M1_CDNS_40661956134110

* cell M3_M2_CDNS_40661956134111
* pin
* pin
.SUBCKT M3_M2_CDNS_40661956134111 1 2
.ENDS M3_M2_CDNS_40661956134111

* cell M2_M1_CDNS_40661956134104
* pin
* pin
.SUBCKT M2_M1_CDNS_40661956134104 1 2
.ENDS M2_M1_CDNS_40661956134104

* cell M3_M2_CDNS_40661956134105
* pin
* pin
.SUBCKT M3_M2_CDNS_40661956134105 1 2
.ENDS M3_M2_CDNS_40661956134105

* cell M3_M2_CDNS_40661956134106
* pin
* pin
.SUBCKT M3_M2_CDNS_40661956134106 1 2
.ENDS M3_M2_CDNS_40661956134106

* cell M2_M1_CDNS_40661956134107
* pin
* pin
.SUBCKT M2_M1_CDNS_40661956134107 1 2
.ENDS M2_M1_CDNS_40661956134107

* cell M1_PSUB_CDNS_4066195613455
* pin
.SUBCKT M1_PSUB_CDNS_4066195613455 1
.ENDS M1_PSUB_CDNS_4066195613455

* cell M1_PSUB_CDNS_4066195613458
* pin
* pin
.SUBCKT M1_PSUB_CDNS_4066195613458 1 2
.ENDS M1_PSUB_CDNS_4066195613458

* cell M1_PSUB_CDNS_4066195613448
* pin
* pin
.SUBCKT M1_PSUB_CDNS_4066195613448 1 2
.ENDS M1_PSUB_CDNS_4066195613448

* cell M2_M1_CDNS_4066195613471
* pin
* pin
.SUBCKT M2_M1_CDNS_4066195613471 1 2
.ENDS M2_M1_CDNS_4066195613471

* cell M1_PSUB_CDNS_4066195613450
* pin
* pin
.SUBCKT M1_PSUB_CDNS_4066195613450 1 2
.ENDS M1_PSUB_CDNS_4066195613450

* cell M3_M2_CDNS_4066195613472
* pin
* pin
.SUBCKT M3_M2_CDNS_4066195613472 1 2
.ENDS M3_M2_CDNS_4066195613472

* cell M1_PSUB_CDNS_4066195613456
* pin
* pin
.SUBCKT M1_PSUB_CDNS_4066195613456 1 2
.ENDS M1_PSUB_CDNS_4066195613456

* cell M2_M1_CDNS_4066195613478
* pin
* pin
.SUBCKT M2_M1_CDNS_4066195613478 1 2
.ENDS M2_M1_CDNS_4066195613478

* cell M3_M2_CDNS_4066195613479
* pin
* pin
.SUBCKT M3_M2_CDNS_4066195613479 1 2
.ENDS M3_M2_CDNS_4066195613479

* cell M3_M2_CDNS_4066195613473
* pin
* pin
.SUBCKT M3_M2_CDNS_4066195613473 1 2
.ENDS M3_M2_CDNS_4066195613473

* cell M3_M2_CDNS_4066195613488
* pin
* pin
.SUBCKT M3_M2_CDNS_4066195613488 1 2
.ENDS M3_M2_CDNS_4066195613488

* cell M2_M1_CDNS_4066195613486
* pin
* pin
.SUBCKT M2_M1_CDNS_4066195613486 1 2
.ENDS M2_M1_CDNS_4066195613486

* cell M2_M1_CDNS_40661956134102
* pin
* pin
.SUBCKT M2_M1_CDNS_40661956134102 1 2
.ENDS M2_M1_CDNS_40661956134102

* cell M3_M2_CDNS_40661956134103
* pin
* pin
.SUBCKT M3_M2_CDNS_40661956134103 1 2
.ENDS M3_M2_CDNS_40661956134103

* cell M1_PSUB_CDNS_4066195613451
* pin
* pin
.SUBCKT M1_PSUB_CDNS_4066195613451 1 2
.ENDS M1_PSUB_CDNS_4066195613451

* cell M3_M2_CDNS_4066195613495
* pin
* pin
.SUBCKT M3_M2_CDNS_4066195613495 1 2
.ENDS M3_M2_CDNS_4066195613495

* cell M2_M1_CDNS_4066195613496
* pin
* pin
.SUBCKT M2_M1_CDNS_4066195613496 1 2
.ENDS M2_M1_CDNS_4066195613496

* cell M3_M2_CDNS_4066195613497
* pin
* pin
.SUBCKT M3_M2_CDNS_4066195613497 1 2
.ENDS M3_M2_CDNS_4066195613497

* cell M2_M1_CDNS_4066195613498
* pin
* pin
.SUBCKT M2_M1_CDNS_4066195613498 1 2
.ENDS M2_M1_CDNS_4066195613498

* cell M3_M2_CDNS_4066195613462
* pin
* pin
.SUBCKT M3_M2_CDNS_4066195613462 1 2
.ENDS M3_M2_CDNS_4066195613462

* cell M2_M1_CDNS_4066195613463
* pin
* pin
.SUBCKT M2_M1_CDNS_4066195613463 1 2
.ENDS M2_M1_CDNS_4066195613463

* cell M3_M2_CDNS_40661956134101
* pin
* pin
.SUBCKT M3_M2_CDNS_40661956134101 1 2
.ENDS M3_M2_CDNS_40661956134101

* cell M2_M1_CDNS_4066195613487
* pin
* pin
.SUBCKT M2_M1_CDNS_4066195613487 1 2
.ENDS M2_M1_CDNS_4066195613487

* cell M1_PSUB_CDNS_4066195613434
* pin
* pin
.SUBCKT M1_PSUB_CDNS_4066195613434 1 2
.ENDS M1_PSUB_CDNS_4066195613434

* cell M2_M1_CDNS_4066195613460
* pin
* pin
.SUBCKT M2_M1_CDNS_4066195613460 1 2
.ENDS M2_M1_CDNS_4066195613460

* cell M3_M2_CDNS_4066195613461
* pin
* pin
.SUBCKT M3_M2_CDNS_4066195613461 1 2
.ENDS M3_M2_CDNS_4066195613461

* cell M2_M1_CDNS_4066195613466
* pin
* pin
.SUBCKT M2_M1_CDNS_4066195613466 1 2
.ENDS M2_M1_CDNS_4066195613466

* cell M2_M1_CDNS_4066195613421
* pin
* pin
.SUBCKT M2_M1_CDNS_4066195613421 1 2
.ENDS M2_M1_CDNS_4066195613421

* cell M2_M1_CDNS_4066195613483
* pin
.SUBCKT M2_M1_CDNS_4066195613483 1
.ENDS M2_M1_CDNS_4066195613483

* cell M3_M2_CDNS_4066195613482
* pin
* pin
.SUBCKT M3_M2_CDNS_4066195613482 1 2
.ENDS M3_M2_CDNS_4066195613482

* cell M1_PSUB_CDNS_4066195613431
* pin
* pin
.SUBCKT M1_PSUB_CDNS_4066195613431 1 2
.ENDS M1_PSUB_CDNS_4066195613431

* cell M3_M2_CDNS_4066195613454
* pin
* pin
.SUBCKT M3_M2_CDNS_4066195613454 1 2
.ENDS M3_M2_CDNS_4066195613454

* cell M2_M1_CDNS_4066195613459
* pin
* pin
.SUBCKT M2_M1_CDNS_4066195613459 1 2
.ENDS M2_M1_CDNS_4066195613459

* cell M2_M1_CDNS_4066195613464
* pin
* pin
.SUBCKT M2_M1_CDNS_4066195613464 1 2
.ENDS M2_M1_CDNS_4066195613464

* cell M3_M2_CDNS_4066195613465
* pin
* pin
.SUBCKT M3_M2_CDNS_4066195613465 1 2
.ENDS M3_M2_CDNS_4066195613465

* cell M2_M1_CDNS_4066195613469
* pin
* pin
.SUBCKT M2_M1_CDNS_4066195613469 1 2
.ENDS M2_M1_CDNS_4066195613469

* cell M3_M2_CDNS_4066195613474
* pin
* pin
.SUBCKT M3_M2_CDNS_4066195613474 1 2
.ENDS M3_M2_CDNS_4066195613474

* cell M2_M1_CDNS_4066195613475
* pin
* pin
.SUBCKT M2_M1_CDNS_4066195613475 1 2
.ENDS M2_M1_CDNS_4066195613475

* cell M3_M2_CDNS_4066195613476
* pin
* pin
.SUBCKT M3_M2_CDNS_4066195613476 1 2
.ENDS M3_M2_CDNS_4066195613476

* cell M3_M2_CDNS_4066195613477
* pin
* pin
.SUBCKT M3_M2_CDNS_4066195613477 1 2
.ENDS M3_M2_CDNS_4066195613477

* cell M2_M1_CDNS_4066195613484
* pin
* pin
.SUBCKT M2_M1_CDNS_4066195613484 1 2
.ENDS M2_M1_CDNS_4066195613484

* cell M3_M2_CDNS_4066195613485
* pin
* pin
.SUBCKT M3_M2_CDNS_4066195613485 1 2
.ENDS M3_M2_CDNS_4066195613485

* cell M2_M1_CDNS_4066195613419
* pin
* pin
.SUBCKT M2_M1_CDNS_4066195613419 1 2
.ENDS M2_M1_CDNS_4066195613419

* cell M2_M1_CDNS_4066195613420
* pin
* pin
.SUBCKT M2_M1_CDNS_4066195613420 1 2
.ENDS M2_M1_CDNS_4066195613420

* cell M3_M2_CDNS_4066195613422
* pin
* pin
.SUBCKT M3_M2_CDNS_4066195613422 1 2
.ENDS M3_M2_CDNS_4066195613422

* cell M3_M2_CDNS_4066195613423
* pin
* pin
.SUBCKT M3_M2_CDNS_4066195613423 1 2
.ENDS M3_M2_CDNS_4066195613423

* cell M3_M2_CDNS_4066195613424
* pin
* pin
.SUBCKT M3_M2_CDNS_4066195613424 1 2
.ENDS M3_M2_CDNS_4066195613424

* cell M2_M1_CDNS_4066195613425
* pin
* pin
.SUBCKT M2_M1_CDNS_4066195613425 1 2
.ENDS M2_M1_CDNS_4066195613425

* cell M3_M2_CDNS_4066195613426
* pin
* pin
.SUBCKT M3_M2_CDNS_4066195613426 1 2
.ENDS M3_M2_CDNS_4066195613426

* cell M2_M1_CDNS_4066195613428
* pin
* pin
.SUBCKT M2_M1_CDNS_4066195613428 1 2
.ENDS M2_M1_CDNS_4066195613428

* cell M3_M2_CDNS_4066195613499
* pin
* pin
.SUBCKT M3_M2_CDNS_4066195613499 1 2
.ENDS M3_M2_CDNS_4066195613499

* cell M3_M2_CDNS_4066195613430
* pin
* pin
.SUBCKT M3_M2_CDNS_4066195613430 1 2
.ENDS M3_M2_CDNS_4066195613430

* cell M2_M1_CDNS_4066195613432
* pin
* pin
.SUBCKT M2_M1_CDNS_4066195613432 1 2
.ENDS M2_M1_CDNS_4066195613432

* cell M2_M1_CDNS_4066195613457
* pin
* pin
.SUBCKT M2_M1_CDNS_4066195613457 1 2
.ENDS M2_M1_CDNS_4066195613457

* cell M2_M1_CDNS_40661956134100
* pin
* pin
.SUBCKT M2_M1_CDNS_40661956134100 1 2
.ENDS M2_M1_CDNS_40661956134100

* cell M1_PSUB_CDNS_4066195613429
* pin
* pin
.SUBCKT M1_PSUB_CDNS_4066195613429 1 2
.ENDS M1_PSUB_CDNS_4066195613429

* cell M1_PSUB_CDNS_4066195613433
* pin
* pin
.SUBCKT M1_PSUB_CDNS_4066195613433 1 2
.ENDS M1_PSUB_CDNS_4066195613433

* cell M1_PSUB_CDNS_4066195613435
* pin
* pin
.SUBCKT M1_PSUB_CDNS_4066195613435 1 2
.ENDS M1_PSUB_CDNS_4066195613435

* cell M1_PSUB_CDNS_4066195613436
* pin
* pin
.SUBCKT M1_PSUB_CDNS_4066195613436 1 2
.ENDS M1_PSUB_CDNS_4066195613436

* cell M1_PSUB_CDNS_4066195613437
* pin
* pin
.SUBCKT M1_PSUB_CDNS_4066195613437 1 2
.ENDS M1_PSUB_CDNS_4066195613437

* cell M1_PSUB_CDNS_4066195613438
* pin
* pin
.SUBCKT M1_PSUB_CDNS_4066195613438 1 2
.ENDS M1_PSUB_CDNS_4066195613438

* cell M1_PSUB_CDNS_4066195613439
* pin
* pin
.SUBCKT M1_PSUB_CDNS_4066195613439 1 2
.ENDS M1_PSUB_CDNS_4066195613439

* cell M1_PSUB_CDNS_4066195613440
* pin
* pin
.SUBCKT M1_PSUB_CDNS_4066195613440 1 2
.ENDS M1_PSUB_CDNS_4066195613440

* cell M1_PSUB_CDNS_4066195613441
* pin
* pin
.SUBCKT M1_PSUB_CDNS_4066195613441 1 2
.ENDS M1_PSUB_CDNS_4066195613441

* cell M1_PSUB_CDNS_4066195613442
* pin
* pin
.SUBCKT M1_PSUB_CDNS_4066195613442 1 2
.ENDS M1_PSUB_CDNS_4066195613442

* cell M1_PSUB_CDNS_4066195613443
* pin
* pin
.SUBCKT M1_PSUB_CDNS_4066195613443 1 2
.ENDS M1_PSUB_CDNS_4066195613443

* cell M1_PSUB_CDNS_4066195613444
* pin
* pin
.SUBCKT M1_PSUB_CDNS_4066195613444 1 2
.ENDS M1_PSUB_CDNS_4066195613444

* cell M1_PSUB_CDNS_4066195613445
* pin
* pin
.SUBCKT M1_PSUB_CDNS_4066195613445 1 2
.ENDS M1_PSUB_CDNS_4066195613445

* cell M1_PSUB_CDNS_4066195613446
* pin
* pin
.SUBCKT M1_PSUB_CDNS_4066195613446 1 2
.ENDS M1_PSUB_CDNS_4066195613446

* cell M1_PSUB_CDNS_4066195613447
* pin
* pin
.SUBCKT M1_PSUB_CDNS_4066195613447 1 2
.ENDS M1_PSUB_CDNS_4066195613447

* cell M1_PSUB_CDNS_4066195613449
* pin
* pin
.SUBCKT M1_PSUB_CDNS_4066195613449 1 2
.ENDS M1_PSUB_CDNS_4066195613449

* cell M1_PSUB_CDNS_4066195613452
* pin
* pin
.SUBCKT M1_PSUB_CDNS_4066195613452 1 2
.ENDS M1_PSUB_CDNS_4066195613452

* cell M1_PSUB_CDNS_4066195613453
* pin
* pin
.SUBCKT M1_PSUB_CDNS_4066195613453 1 2
.ENDS M1_PSUB_CDNS_4066195613453

* cell M2_M1_CDNS_4066195613467
* pin
* pin
.SUBCKT M2_M1_CDNS_4066195613467 1 2
.ENDS M2_M1_CDNS_4066195613467

* cell M2_M1_CDNS_4066195613468
* pin
* pin
.SUBCKT M2_M1_CDNS_4066195613468 1 2
.ENDS M2_M1_CDNS_4066195613468

* cell M2_M1_CDNS_4066195613480
* pin
* pin
.SUBCKT M2_M1_CDNS_4066195613480 1 2
.ENDS M2_M1_CDNS_4066195613480

* cell M3_M2_CDNS_4066195613481
* pin
* pin
.SUBCKT M3_M2_CDNS_4066195613481 1 2
.ENDS M3_M2_CDNS_4066195613481

* cell M3_M2_CDNS_4066195613489
* pin
* pin
.SUBCKT M3_M2_CDNS_4066195613489 1 2
.ENDS M3_M2_CDNS_4066195613489

* cell M2_M1_CDNS_4066195613490
* pin
* pin
.SUBCKT M2_M1_CDNS_4066195613490 1 2
.ENDS M2_M1_CDNS_4066195613490

* cell M3_M2_CDNS_4066195613427
* pin
* pin
.SUBCKT M3_M2_CDNS_4066195613427 1 2
.ENDS M3_M2_CDNS_4066195613427

* cell M2_M1_CDNS_40661956134513
* pin
* pin
.SUBCKT M2_M1_CDNS_40661956134513 1 2
.ENDS M2_M1_CDNS_40661956134513

* cell M2_M1_CDNS_40661956134509
* pin
* pin
.SUBCKT M2_M1_CDNS_40661956134509 1 2
.ENDS M2_M1_CDNS_40661956134509

* cell M2_M1_CDNS_40661956134511
* pin
* pin
.SUBCKT M2_M1_CDNS_40661956134511 1 2
.ENDS M2_M1_CDNS_40661956134511

* cell M1_NWELL_CDNS_40661956134321
* pin
* pin
* pin
* pin
.SUBCKT M1_NWELL_CDNS_40661956134321 1 2 3 4
.ENDS M1_NWELL_CDNS_40661956134321

* cell M1_NWELL_CDNS_40661956134503
* pin
* pin
* pin
* pin
.SUBCKT M1_NWELL_CDNS_40661956134503 1 2 3 4
.ENDS M1_NWELL_CDNS_40661956134503

* cell M1_PSUB_CDNS_40661956134512
* pin
* pin
.SUBCKT M1_PSUB_CDNS_40661956134512 1 2
.ENDS M1_PSUB_CDNS_40661956134512

* cell M2_M1_CDNS_40661956134517
* pin
* pin
.SUBCKT M2_M1_CDNS_40661956134517 1 2
.ENDS M2_M1_CDNS_40661956134517

* cell M2_M1_CDNS_40661956134488
* pin
* pin
.SUBCKT M2_M1_CDNS_40661956134488 1 2
.ENDS M2_M1_CDNS_40661956134488

* cell M2_M1_CDNS_40661956134489
* pin
* pin
.SUBCKT M2_M1_CDNS_40661956134489 1 2
.ENDS M2_M1_CDNS_40661956134489

* cell M2_M1_CDNS_40661956134496
* pin
* pin
.SUBCKT M2_M1_CDNS_40661956134496 1 2
.ENDS M2_M1_CDNS_40661956134496

* cell M2_M1_CDNS_40661956134516
* pin
* pin
.SUBCKT M2_M1_CDNS_40661956134516 1 2
.ENDS M2_M1_CDNS_40661956134516

* cell M1_PSUB_CDNS_40661956134505
* pin
* pin
.SUBCKT M1_PSUB_CDNS_40661956134505 1 2
.ENDS M1_PSUB_CDNS_40661956134505

* cell M1_NWELL_CDNS_40661956134515
* pin
* pin
* pin
* pin
.SUBCKT M1_NWELL_CDNS_40661956134515 1 2 3 4
.ENDS M1_NWELL_CDNS_40661956134515

* cell M1_PSUB_CDNS_40661956134507
* pin
* pin
.SUBCKT M1_PSUB_CDNS_40661956134507 1 2
.ENDS M1_PSUB_CDNS_40661956134507

* cell np_6p0_CDNS_4066195613453
* pin
.SUBCKT np_6p0_CDNS_4066195613453 1
.ENDS np_6p0_CDNS_4066195613453

* cell pn_6p0_CDNS_4066195613452
* pin
* pin
* pin
.SUBCKT pn_6p0_CDNS_4066195613452 1 3 4
.ENDS pn_6p0_CDNS_4066195613452

* cell M1_PSUB_CDNS_40661956134514
* pin
* pin
.SUBCKT M1_PSUB_CDNS_40661956134514 1 2
.ENDS M1_PSUB_CDNS_40661956134514

* cell M1_PSUB_CDNS_40661956134508
* pin
* pin
.SUBCKT M1_PSUB_CDNS_40661956134508 1 2
.ENDS M1_PSUB_CDNS_40661956134508

* cell M1_PSUB_CDNS_40661956134506
* pin
* pin
.SUBCKT M1_PSUB_CDNS_40661956134506 1 2
.ENDS M1_PSUB_CDNS_40661956134506

* cell M1_PSUB_CDNS_40661956134504
* pin
* pin
.SUBCKT M1_PSUB_CDNS_40661956134504 1 2
.ENDS M1_PSUB_CDNS_40661956134504

* cell M1_NWELL_CDNS_40661956134510
* pin
* pin
* pin
* pin
.SUBCKT M1_NWELL_CDNS_40661956134510 1 2 3 4
.ENDS M1_NWELL_CDNS_40661956134510

* cell M1_NWELL_CDNS_40661956134502
* pin
* pin
* pin
* pin
.SUBCKT M1_NWELL_CDNS_40661956134502 1 2 3 4
.ENDS M1_NWELL_CDNS_40661956134502

* cell M1_NWELL_CDNS_40661956134501
* pin
* pin
* pin
* pin
.SUBCKT M1_NWELL_CDNS_40661956134501 1 2 3 4
.ENDS M1_NWELL_CDNS_40661956134501

* cell M1_NWELL_CDNS_40661956134500
* pin
* pin
* pin
* pin
.SUBCKT M1_NWELL_CDNS_40661956134500 1 2 3 4
.ENDS M1_NWELL_CDNS_40661956134500

* cell M1_PSUB_CDNS_40661956134192
* pin
* pin
.SUBCKT M1_PSUB_CDNS_40661956134192 1 2
.ENDS M1_PSUB_CDNS_40661956134192

* cell M1_PSUB_CDNS_40661956134176
* pin
* pin
.SUBCKT M1_PSUB_CDNS_40661956134176 1 2
.ENDS M1_PSUB_CDNS_40661956134176

* cell M3_M2_CDNS_40661956134157
* pin
* pin
.SUBCKT M3_M2_CDNS_40661956134157 1 2
.ENDS M3_M2_CDNS_40661956134157

* cell M3_M2_CDNS_40661956134158
* pin
* pin
.SUBCKT M3_M2_CDNS_40661956134158 1 2
.ENDS M3_M2_CDNS_40661956134158

* cell M3_M2_CDNS_40661956134159
* pin
* pin
.SUBCKT M3_M2_CDNS_40661956134159 1 2
.ENDS M3_M2_CDNS_40661956134159

* cell M3_M2_CDNS_40661956134160
* pin
* pin
.SUBCKT M3_M2_CDNS_40661956134160 1 2
.ENDS M3_M2_CDNS_40661956134160

* cell M3_M2_CDNS_40661956134161
* pin
* pin
.SUBCKT M3_M2_CDNS_40661956134161 1 2
.ENDS M3_M2_CDNS_40661956134161

* cell M3_M2_CDNS_40661956134162
* pin
* pin
.SUBCKT M3_M2_CDNS_40661956134162 1 2
.ENDS M3_M2_CDNS_40661956134162

* cell M3_M2_CDNS_40661956134163
* pin
* pin
.SUBCKT M3_M2_CDNS_40661956134163 1 2
.ENDS M3_M2_CDNS_40661956134163

* cell M3_M2_CDNS_40661956134164
* pin
* pin
.SUBCKT M3_M2_CDNS_40661956134164 1 2
.ENDS M3_M2_CDNS_40661956134164

* cell M3_M2_CDNS_40661956134165
* pin
* pin
.SUBCKT M3_M2_CDNS_40661956134165 1 2
.ENDS M3_M2_CDNS_40661956134165

* cell M3_M2_CDNS_40661956134155
* pin
* pin
.SUBCKT M3_M2_CDNS_40661956134155 1 2
.ENDS M3_M2_CDNS_40661956134155

* cell M3_M2_CDNS_40661956134112
* pin
* pin
.SUBCKT M3_M2_CDNS_40661956134112 1 2
.ENDS M3_M2_CDNS_40661956134112

* cell M3_M2_CDNS_40661956134113
* pin
* pin
.SUBCKT M3_M2_CDNS_40661956134113 1 2
.ENDS M3_M2_CDNS_40661956134113

* cell M3_M2_CDNS_40661956134116
* pin
* pin
.SUBCKT M3_M2_CDNS_40661956134116 1 2
.ENDS M3_M2_CDNS_40661956134116

* cell M3_M2_CDNS_40661956134117
* pin
* pin
.SUBCKT M3_M2_CDNS_40661956134117 1 2
.ENDS M3_M2_CDNS_40661956134117

* cell M3_M2_CDNS_40661956134118
* pin
* pin
.SUBCKT M3_M2_CDNS_40661956134118 1 2
.ENDS M3_M2_CDNS_40661956134118

* cell M3_M2_CDNS_40661956134120
* pin
* pin
.SUBCKT M3_M2_CDNS_40661956134120 1 2
.ENDS M3_M2_CDNS_40661956134120

* cell M3_M2_CDNS_40661956134121
* pin
* pin
.SUBCKT M3_M2_CDNS_40661956134121 1 2
.ENDS M3_M2_CDNS_40661956134121

* cell M3_M2_CDNS_40661956134122
* pin
* pin
.SUBCKT M3_M2_CDNS_40661956134122 1 2
.ENDS M3_M2_CDNS_40661956134122

* cell M3_M2_CDNS_40661956134123
* pin
* pin
.SUBCKT M3_M2_CDNS_40661956134123 1 2
.ENDS M3_M2_CDNS_40661956134123

* cell M3_M2_CDNS_40661956134124
* pin
* pin
.SUBCKT M3_M2_CDNS_40661956134124 1 2
.ENDS M3_M2_CDNS_40661956134124

* cell M2_M1_CDNS_40661956134248
* pin
* pin
.SUBCKT M2_M1_CDNS_40661956134248 1 2
.ENDS M2_M1_CDNS_40661956134248

* cell M2_M1_CDNS_40661956134246
* pin
* pin
.SUBCKT M2_M1_CDNS_40661956134246 1 2
.ENDS M2_M1_CDNS_40661956134246

* cell M3_M2_CDNS_40661956134156
* pin
* pin
.SUBCKT M3_M2_CDNS_40661956134156 1 2
.ENDS M3_M2_CDNS_40661956134156

* cell M3_M2_CDNS_40661956134119
* pin
* pin
.SUBCKT M3_M2_CDNS_40661956134119 1 2
.ENDS M3_M2_CDNS_40661956134119

* cell M2_M1_CDNS_40661956134247
* pin
* pin
.SUBCKT M2_M1_CDNS_40661956134247 1 2
.ENDS M2_M1_CDNS_40661956134247

* cell M2_M1_CDNS_40661956134249
* pin
* pin
.SUBCKT M2_M1_CDNS_40661956134249 1 2
.ENDS M2_M1_CDNS_40661956134249

* cell M2_M1_CDNS_40661956134206
* pin
* pin
.SUBCKT M2_M1_CDNS_40661956134206 1 2
.ENDS M2_M1_CDNS_40661956134206

* cell M2_M1_CDNS_40661956134268
* pin
* pin
.SUBCKT M2_M1_CDNS_40661956134268 1 2
.ENDS M2_M1_CDNS_40661956134268

* cell M2_M1_CDNS_40661956134217
* pin
* pin
.SUBCKT M2_M1_CDNS_40661956134217 1 2
.ENDS M2_M1_CDNS_40661956134217

* cell M2_M1_CDNS_40661956134218
* pin
* pin
.SUBCKT M2_M1_CDNS_40661956134218 1 2
.ENDS M2_M1_CDNS_40661956134218

* cell M2_M1_CDNS_40661956134255
* pin
* pin
.SUBCKT M2_M1_CDNS_40661956134255 1 2
.ENDS M2_M1_CDNS_40661956134255

* cell top_route_1
* pin
* pin
* pin
* pin
* pin
* pin
* pin
* pin
* pin
* pin
* pin
.SUBCKT top_route_1 1 2 3 4 5 6 7 8 9 10 11
* cell instance $1 r0 *1 43.43,1.03
X$1 1 7 M2_M1_CDNS_40661956134152
* cell instance $2 r0 *1 61.625,1.03
X$2 1 9 M2_M1_CDNS_40661956134147
* cell instance $3 r0 *1 42.98,50.225
X$3 1 7 M2_M1_CDNS_40661956134150
* cell instance $4 r0 *1 42.98,19.77
X$4 1 7 M2_M1_CDNS_40661956134143
* cell instance $5 r0 *1 42.98,80.19
X$5 1 7 M2_M1_CDNS_40661956134143
* cell instance $6 r0 *1 3.04,17.43
X$6 11 2 M2_M1_CDNS_40661956134149
* cell instance $7 r0 *1 3.035,82.645
X$7 11 2 M2_M1_CDNS_40661956134166
* cell instance $8 r0 *1 11.76,50.225
X$8 10 3 M2_M1_CDNS_40661956134150
* cell instance $9 r0 *1 11.76,1.03
X$9 10 3 M2_M1_CDNS_40661956134143
* cell instance $10 r0 *1 11.76,80.19
X$10 10 3 M2_M1_CDNS_40661956134143
* cell instance $11 r0 *1 11.76,19.77
X$11 10 3 M2_M1_CDNS_40661956134143
* cell instance $12 r0 *1 21.4,17.43
X$12 11 4 M2_M1_CDNS_40661956134143
* cell instance $13 r0 *1 29.205,50.225
X$13 10 5 M2_M1_CDNS_40661956134151
* cell instance $14 r0 *1 29.205,80.19
X$14 10 5 M2_M1_CDNS_40661956134147
* cell instance $15 r0 *1 29.205,1.03
X$15 10 5 M2_M1_CDNS_40661956134147
* cell instance $16 r0 *1 29.205,19.77
X$16 10 5 M2_M1_CDNS_40661956134147
* cell instance $17 r0 *1 35.175,17.43
X$17 11 6 M2_M1_CDNS_40661956134147
* cell instance $18 r0 *1 52.62,17.43
X$18 11 8 M2_M1_CDNS_40661956134143
.ENDS top_route_1

* cell comp018green_esd_rc_v5p0
* pin VPLUS
* pin VRC
* pin VMINUS
* pin gf180mcu_gnd
.SUBCKT comp018green_esd_rc_v5p0 1 15 16 18
* net 1 VPLUS
* net 15 VRC
* net 16 VMINUS
* net 18 gf180mcu_gnd
* cell instance $1 m135 *1 34.185,3.095
X$1 1 10 1 11 M1_NWELL_CDNS_40661956134153
* cell instance $2 m0 *1 0.385,12.445
X$2 1 11 10 1 M1_NWELL_CDNS_40661956134154
* cell instance $3 m0 *1 1.765,5.145
X$3 4 1 18 ppolyf_u_CDNS_406619561345
* cell instance $4 m0 *1 67.985,12.445
X$4 1 11 10 1 M1_NWELL_CDNS_40661956134154
* cell instance $5 m90 *1 66.64,8.545
X$5 2 5 18 ppolyf_u_CDNS_406619561345
* cell instance $6 r0 *1 1.765,9.945
X$6 8 2 18 ppolyf_u_CDNS_406619561345
* cell instance $7 m90 *1 66.64,5.745
X$7 3 4 18 ppolyf_u_CDNS_406619561345
* cell instance $8 r0 *1 1.765,7.145
X$8 5 3 18 ppolyf_u_CDNS_406619561345
* cell instance $9 m90 *1 66.64,14.145
X$9 6 9 18 ppolyf_u_CDNS_406619561345
* cell instance $10 r0 *1 1.765,15.545
X$10 12 6 18 ppolyf_u_CDNS_406619561345
* cell instance $11 m90 *1 66.64,11.345
X$11 7 8 18 ppolyf_u_CDNS_406619561345
* cell instance $12 r0 *1 1.765,12.745
X$12 9 7 18 ppolyf_u_CDNS_406619561345
* cell instance $13 m90 *1 66.64,16.945
X$13 14 12 18 ppolyf_u_CDNS_406619561345
* cell instance $14 r0 *1 1.765,18.345
X$14 13 14 18 ppolyf_u_CDNS_406619561345
* cell instance $15 m90 *1 66.64,19.745
X$15 15 13 18 ppolyf_u_CDNS_406619561345
* cell instance $16 r0 *1 10.9,56.755
X$16 16 15 nmoscap_6p0_CDNS_406619561340
* cell instance $17 m0 *1 23.08,51.695
X$17 16 15 nmoscap_6p0_CDNS_406619561340
* cell instance $18 m0 *1 10.9,51.695
X$18 16 15 nmoscap_6p0_CDNS_406619561340
* cell instance $19 m0 *1 47.44,51.695
X$19 16 15 nmoscap_6p0_CDNS_406619561340
* cell instance $20 m0 *1 35.26,51.695
X$20 16 15 nmoscap_6p0_CDNS_406619561340
* cell instance $21 r0 *1 47.44,56.755
X$21 16 15 nmoscap_6p0_CDNS_406619561340
* cell instance $22 r0 *1 35.26,56.755
X$22 16 15 nmoscap_6p0_CDNS_406619561340
* cell instance $23 r0 *1 23.08,56.755
X$23 16 15 nmoscap_6p0_CDNS_406619561340
* cell instance $24 r0 *1 60.035,54.47
X$24 16 17 M1_PSUB_CDNS_406619561349
* cell instance $25 r90 *1 34.185,54.225
X$25 16 17 M1_PSUB_CDNS_4066195613411
* cell instance $26 r90 *1 34.185,84.68
X$26 16 17 M1_PSUB_CDNS_4066195613411
* cell instance $27 r90 *1 34.185,24.26
X$27 16 17 M1_PSUB_CDNS_4066195613411
.ENDS comp018green_esd_rc_v5p0

* cell top_route
* pin
* pin
* pin
* pin
* pin
* pin
* pin
* pin
* pin
* pin
* pin
.SUBCKT top_route 1 2 3 4 5 6 7 8 9 10 11
* cell instance $1 r0 *1 21.4,17.43
X$1 6 1 M2_M1_CDNS_40661956134143
* cell instance $2 r0 *1 29.205,1.03
X$2 7 2 M2_M1_CDNS_40661956134147
* cell instance $3 r0 *1 29.205,19.77
X$3 7 2 M2_M1_CDNS_40661956134147
* cell instance $4 r0 *1 29.205,80.19
X$4 7 2 M2_M1_CDNS_40661956134147
* cell instance $5 r0 *1 29.205,50.225
X$5 7 2 M2_M1_CDNS_40661956134151
* cell instance $6 r0 *1 52.62,17.43
X$6 6 3 M2_M1_CDNS_40661956134143
* cell instance $7 r0 *1 61.625,1.03
X$7 5 4 M2_M1_CDNS_40661956134147
* cell instance $8 r0 *1 42.98,50.225
X$8 5 11 M2_M1_CDNS_40661956134150
* cell instance $9 r0 *1 42.98,19.77
X$9 5 11 M2_M1_CDNS_40661956134143
* cell instance $10 r0 *1 42.98,80.19
X$10 5 11 M2_M1_CDNS_40661956134143
* cell instance $11 r0 *1 43.43,1.03
X$11 5 11 M2_M1_CDNS_40661956134152
* cell instance $12 r0 *1 3.04,17.43
X$12 6 8 M2_M1_CDNS_40661956134149
* cell instance $13 r0 *1 2.755,83.74
X$13 6 8 M2_M1_CDNS_40661956134147
* cell instance $14 r0 *1 35.175,17.43
X$14 6 10 M2_M1_CDNS_40661956134147
* cell instance $15 r0 *1 11.76,50.225
X$15 7 9 M2_M1_CDNS_40661956134150
* cell instance $16 r0 *1 11.76,1.03
X$16 7 9 M2_M1_CDNS_40661956134143
* cell instance $17 r0 *1 11.76,19.77
X$17 7 9 M2_M1_CDNS_40661956134143
* cell instance $18 r0 *1 11.76,80.19
X$18 7 9 M2_M1_CDNS_40661956134143
.ENDS top_route

* cell comp018green_esd_rc_v5p0_1
* pin VPLUS
* pin VRC
* pin VMINUS
* pin gf180mcu_gnd
.SUBCKT comp018green_esd_rc_v5p0_1 1 4 10 18
* net 1 VPLUS
* net 4 VRC
* net 10 VMINUS
* net 18 gf180mcu_gnd
* cell instance $1 r90 *1 -16.47,21.625
X$1 12 1 18 ppolyf_u_CDNS_406619561345
* cell instance $2 r90 *1 -9.17,87.845
X$2 1 3 2 1 M1_NWELL_CDNS_40661956134154
* cell instance $3 r90 *1 -9.17,20.245
X$3 1 3 2 1 M1_NWELL_CDNS_40661956134154
* cell instance $4 r180 *1 -18.52,54.045
X$4 1 2 1 3 M1_NWELL_CDNS_40661956134153
* cell instance $5 m0 *1 23.08,51.695
X$5 10 4 nmoscap_6p0_CDNS_406619561340
* cell instance $6 m0 *1 10.9,51.695
X$6 10 4 nmoscap_6p0_CDNS_406619561340
* cell instance $7 m0 *1 47.44,51.695
X$7 10 4 nmoscap_6p0_CDNS_406619561340
* cell instance $8 m0 *1 35.26,51.695
X$8 10 4 nmoscap_6p0_CDNS_406619561340
* cell instance $9 r0 *1 47.44,56.755
X$9 10 4 nmoscap_6p0_CDNS_406619561340
* cell instance $10 r0 *1 35.26,56.755
X$10 10 4 nmoscap_6p0_CDNS_406619561340
* cell instance $11 r0 *1 23.08,56.755
X$11 10 4 nmoscap_6p0_CDNS_406619561340
* cell instance $12 r0 *1 10.9,56.755
X$12 10 4 nmoscap_6p0_CDNS_406619561340
* cell instance $13 r270 *1 -1.87,86.5
X$13 4 17 18 ppolyf_u_CDNS_406619561345
* cell instance $14 r270 *1 -4.67,86.5
X$14 5 15 18 ppolyf_u_CDNS_406619561345
* cell instance $15 m45 *1 -3.27,21.625
X$15 17 5 18 ppolyf_u_CDNS_406619561345
* cell instance $16 r270 *1 -7.47,86.5
X$16 6 16 18 ppolyf_u_CDNS_406619561345
* cell instance $17 m45 *1 -6.07,21.625
X$17 15 6 18 ppolyf_u_CDNS_406619561345
* cell instance $18 r270 *1 -10.27,86.5
X$18 7 13 18 ppolyf_u_CDNS_406619561345
* cell instance $19 m45 *1 -8.87,21.625
X$19 16 7 18 ppolyf_u_CDNS_406619561345
* cell instance $20 r270 *1 -13.07,86.5
X$20 8 14 18 ppolyf_u_CDNS_406619561345
* cell instance $21 m45 *1 -11.67,21.625
X$21 13 8 18 ppolyf_u_CDNS_406619561345
* cell instance $22 r270 *1 -15.87,86.5
X$22 9 12 18 ppolyf_u_CDNS_406619561345
* cell instance $23 m45 *1 -14.47,21.625
X$23 14 9 18 ppolyf_u_CDNS_406619561345
* cell instance $24 r90 *1 34.185,84.68
X$24 10 11 M1_PSUB_CDNS_4066195613411
* cell instance $25 r90 *1 34.185,24.26
X$25 10 11 M1_PSUB_CDNS_4066195613411
* cell instance $26 r90 *1 34.185,54.225
X$26 10 11 M1_PSUB_CDNS_4066195613411
* cell instance $27 r0 *1 60.035,54.47
X$27 10 11 M1_PSUB_CDNS_406619561349
.ENDS comp018green_esd_rc_v5p0_1

* cell nmos_clamp_20_50_4
* pin
* pin
* pin
* pin
* pin
* pin
* pin
* pin
* pin
* pin
* pin
* pin
* pin
* pin gf180mcu_gnd
.SUBCKT nmos_clamp_20_50_4 1 3 5 6 7 8 9 10 11 12 13 14 15 16
* net 16 gf180mcu_gnd
* cell instance $1 r90 *1 57.405,7.405
X$1 3 5 3 5 3 5 3 5 3 5 3 5 3 5 3 5 3 5 3 5 3 1 1 1 1 1 1 1 1 1 1 1 1 1 1 1 1 1
+ 1 1 1 16 nmos_6p0_CDNS_406619561341
* cell instance $2 r90 *1 57.405,36.765
X$2 3 5 3 5 3 5 3 5 3 5 3 5 3 5 3 5 3 5 3 5 3 1 1 1 1 1 1 1 1 1 1 1 1 1 1 1 1 1
+ 1 1 1 16 nmos_6p0_CDNS_406619561341
* cell instance $3 r90 *1 57.405,66.125
X$3 3 5 3 5 3 5 3 5 3 5 3 5 3 5 3 5 3 5 3 5 3 1 1 1 1 1 1 1 1 1 1 1 1 1 1 1 1 1
+ 1 1 1 16 nmos_6p0_CDNS_406619561341
* cell instance $4 r90 *1 57.405,95.485
X$4 3 5 3 5 3 5 3 5 3 5 3 5 3 5 3 5 3 5 3 5 3 1 1 1 1 1 1 1 1 1 1 1 1 1 1 1 1 1
+ 1 1 1 16 nmos_6p0_CDNS_406619561341
* cell instance $5 r0 *1 6.645,19.345
X$5 1 M1_POLY2_CDNS_40661956134136
* cell instance $6 r0 *1 6.565,19.345
X$6 1 8 M2_M1_CDNS_40661956134141
* cell instance $7 r0 *1 58.245,107.425
X$7 1 14 M2_M1_CDNS_40661956134141
* cell instance $8 m90 *1 58.165,107.425
X$8 1 M1_POLY2_CDNS_40661956134136
* cell instance $9 r0 *1 58.245,78.065
X$9 1 14 M2_M1_CDNS_40661956134141
* cell instance $10 m90 *1 58.165,78.065
X$10 1 M1_POLY2_CDNS_40661956134136
* cell instance $11 r0 *1 58.245,19.345
X$11 1 14 M2_M1_CDNS_40661956134141
* cell instance $12 m90 *1 58.165,19.345
X$12 1 M1_POLY2_CDNS_40661956134136
* cell instance $13 r0 *1 58.245,48.705
X$13 1 14 M2_M1_CDNS_40661956134141
* cell instance $14 m90 *1 58.165,48.705
X$14 1 M1_POLY2_CDNS_40661956134136
* cell instance $15 r0 *1 6.645,107.425
X$15 1 M1_POLY2_CDNS_40661956134136
* cell instance $16 r0 *1 6.565,107.425
X$16 1 8 M2_M1_CDNS_40661956134141
* cell instance $17 r0 *1 6.645,48.705
X$17 1 M1_POLY2_CDNS_40661956134136
* cell instance $18 r0 *1 6.565,48.705
X$18 1 8 M2_M1_CDNS_40661956134141
* cell instance $19 r0 *1 6.645,78.065
X$19 1 M1_POLY2_CDNS_40661956134136
* cell instance $20 r0 *1 6.565,78.065
X$20 1 8 M2_M1_CDNS_40661956134141
* cell instance $21 r0 *1 1.135,63.385
X$21 3 2 3 17 M1_NWELL_CDNS_40661956134135
* cell instance $22 r0 *1 32.405,1.135
X$22 3 17 3 2 M1_NWELL_CDNS_40661956134139
* cell instance $23 r0 *1 32.405,125.635
X$23 3 17 3 2 M1_NWELL_CDNS_40661956134139
* cell instance $24 r0 *1 63.675,63.385
X$24 3 2 3 17 M1_NWELL_CDNS_40661956134135
* cell instance $25 r0 *1 21.615,7.145
X$25 3 10 M2_M1_CDNS_40661956134140
* cell instance $26 r0 *1 35.39,7.145
X$26 3 12 M2_M1_CDNS_40661956134142
* cell instance $27 r0 *1 52.835,7.145
X$27 3 13 M2_M1_CDNS_40661956134140
* cell instance $28 r0 *1 21.615,80.505
X$28 3 10 M2_M1_CDNS_40661956134140
* cell instance $29 r0 *1 35.39,80.505
X$29 3 12 M2_M1_CDNS_40661956134142
* cell instance $30 r0 *1 52.835,80.505
X$30 3 13 M2_M1_CDNS_40661956134140
* cell instance $31 r0 *1 21.615,68.305
X$31 3 10 M2_M1_CDNS_40661956134140
* cell instance $32 r0 *1 35.39,68.305
X$32 3 12 M2_M1_CDNS_40661956134142
* cell instance $33 r0 *1 52.835,68.305
X$33 3 13 M2_M1_CDNS_40661956134140
* cell instance $34 r0 *1 21.615,95.225
X$34 3 10 M2_M1_CDNS_40661956134140
* cell instance $35 r0 *1 35.39,95.225
X$35 3 12 M2_M1_CDNS_40661956134142
* cell instance $36 r0 *1 52.835,95.225
X$36 3 13 M2_M1_CDNS_40661956134140
* cell instance $37 r0 *1 21.615,65.865
X$37 3 10 M2_M1_CDNS_40661956134140
* cell instance $38 r0 *1 35.39,65.865
X$38 3 12 M2_M1_CDNS_40661956134142
* cell instance $39 r0 *1 52.835,65.865
X$39 3 13 M2_M1_CDNS_40661956134140
* cell instance $40 r0 *1 21.615,70.745
X$40 3 10 M2_M1_CDNS_40661956134140
* cell instance $41 r0 *1 35.39,70.745
X$41 3 12 M2_M1_CDNS_40661956134142
* cell instance $42 r0 *1 52.835,70.745
X$42 3 13 M2_M1_CDNS_40661956134140
* cell instance $43 r0 *1 21.615,73.185
X$43 3 10 M2_M1_CDNS_40661956134140
* cell instance $44 r0 *1 35.39,73.185
X$44 3 12 M2_M1_CDNS_40661956134142
* cell instance $45 r0 *1 52.835,73.185
X$45 3 13 M2_M1_CDNS_40661956134140
* cell instance $46 r0 *1 21.615,78.065
X$46 3 10 M2_M1_CDNS_40661956134140
* cell instance $47 r0 *1 35.39,78.065
X$47 3 12 M2_M1_CDNS_40661956134142
* cell instance $48 r0 *1 52.835,78.065
X$48 3 13 M2_M1_CDNS_40661956134140
* cell instance $49 r0 *1 21.615,75.625
X$49 3 10 M2_M1_CDNS_40661956134140
* cell instance $50 r0 *1 35.39,75.625
X$50 3 12 M2_M1_CDNS_40661956134142
* cell instance $51 r0 *1 52.835,75.625
X$51 3 13 M2_M1_CDNS_40661956134140
* cell instance $52 r0 *1 21.615,119.625
X$52 3 10 M2_M1_CDNS_40661956134140
* cell instance $53 r0 *1 35.39,119.625
X$53 3 12 M2_M1_CDNS_40661956134142
* cell instance $54 r0 *1 52.835,119.625
X$54 3 13 M2_M1_CDNS_40661956134140
* cell instance $55 r0 *1 21.615,117.185
X$55 3 10 M2_M1_CDNS_40661956134140
* cell instance $56 r0 *1 35.39,117.185
X$56 3 12 M2_M1_CDNS_40661956134142
* cell instance $57 r0 *1 52.835,117.185
X$57 3 13 M2_M1_CDNS_40661956134140
* cell instance $58 r0 *1 21.615,114.745
X$58 3 10 M2_M1_CDNS_40661956134140
* cell instance $59 r0 *1 35.39,114.745
X$59 3 12 M2_M1_CDNS_40661956134142
* cell instance $60 r0 *1 52.835,114.745
X$60 3 13 M2_M1_CDNS_40661956134140
* cell instance $61 r0 *1 21.615,112.305
X$61 3 10 M2_M1_CDNS_40661956134140
* cell instance $62 r0 *1 35.39,112.305
X$62 3 12 M2_M1_CDNS_40661956134142
* cell instance $63 r0 *1 52.835,112.305
X$63 3 13 M2_M1_CDNS_40661956134140
* cell instance $64 r0 *1 21.615,26.665
X$64 3 10 M2_M1_CDNS_40661956134140
* cell instance $65 r0 *1 35.39,26.665
X$65 3 12 M2_M1_CDNS_40661956134142
* cell instance $66 r0 *1 52.835,26.665
X$66 3 13 M2_M1_CDNS_40661956134140
* cell instance $67 r0 *1 21.615,24.225
X$67 3 10 M2_M1_CDNS_40661956134140
* cell instance $68 r0 *1 35.39,24.225
X$68 3 12 M2_M1_CDNS_40661956134142
* cell instance $69 r0 *1 52.835,24.225
X$69 3 13 M2_M1_CDNS_40661956134140
* cell instance $70 r0 *1 21.615,21.785
X$70 3 10 M2_M1_CDNS_40661956134140
* cell instance $71 r0 *1 35.39,21.785
X$71 3 12 M2_M1_CDNS_40661956134142
* cell instance $72 r0 *1 52.835,21.785
X$72 3 13 M2_M1_CDNS_40661956134140
* cell instance $73 r0 *1 21.615,19.345
X$73 3 10 M2_M1_CDNS_40661956134140
* cell instance $74 r0 *1 35.39,19.345
X$74 3 12 M2_M1_CDNS_40661956134142
* cell instance $75 r0 *1 52.835,19.345
X$75 3 13 M2_M1_CDNS_40661956134140
* cell instance $76 r0 *1 21.615,16.905
X$76 3 10 M2_M1_CDNS_40661956134140
* cell instance $77 r0 *1 35.39,16.905
X$77 3 12 M2_M1_CDNS_40661956134142
* cell instance $78 r0 *1 52.835,16.905
X$78 3 13 M2_M1_CDNS_40661956134140
* cell instance $79 r0 *1 21.615,14.465
X$79 3 10 M2_M1_CDNS_40661956134140
* cell instance $80 r0 *1 35.39,14.465
X$80 3 12 M2_M1_CDNS_40661956134142
* cell instance $81 r0 *1 52.835,14.465
X$81 3 13 M2_M1_CDNS_40661956134140
* cell instance $82 r0 *1 21.615,12.025
X$82 3 10 M2_M1_CDNS_40661956134140
* cell instance $83 r0 *1 35.39,12.025
X$83 3 12 M2_M1_CDNS_40661956134142
* cell instance $84 r0 *1 52.835,12.025
X$84 3 13 M2_M1_CDNS_40661956134140
* cell instance $85 r0 *1 21.615,9.585
X$85 3 10 M2_M1_CDNS_40661956134140
* cell instance $86 r0 *1 35.39,9.585
X$86 3 12 M2_M1_CDNS_40661956134142
* cell instance $87 r0 *1 52.835,9.585
X$87 3 13 M2_M1_CDNS_40661956134140
* cell instance $88 r0 *1 21.615,29.105
X$88 3 10 M2_M1_CDNS_40661956134140
* cell instance $89 r0 *1 35.39,29.105
X$89 3 12 M2_M1_CDNS_40661956134142
* cell instance $90 r0 *1 52.835,29.105
X$90 3 13 M2_M1_CDNS_40661956134140
* cell instance $91 r0 *1 21.615,31.545
X$91 3 10 M2_M1_CDNS_40661956134140
* cell instance $92 r0 *1 35.39,31.545
X$92 3 12 M2_M1_CDNS_40661956134142
* cell instance $93 r0 *1 52.835,31.545
X$93 3 13 M2_M1_CDNS_40661956134140
* cell instance $94 r0 *1 21.615,109.865
X$94 3 10 M2_M1_CDNS_40661956134140
* cell instance $95 r0 *1 35.39,109.865
X$95 3 12 M2_M1_CDNS_40661956134142
* cell instance $96 r0 *1 52.835,109.865
X$96 3 13 M2_M1_CDNS_40661956134140
* cell instance $97 r0 *1 21.615,107.425
X$97 3 10 M2_M1_CDNS_40661956134140
* cell instance $98 r0 *1 35.39,107.425
X$98 3 12 M2_M1_CDNS_40661956134142
* cell instance $99 r0 *1 52.835,107.425
X$99 3 13 M2_M1_CDNS_40661956134140
* cell instance $100 r0 *1 21.615,102.545
X$100 3 10 M2_M1_CDNS_40661956134140
* cell instance $101 r0 *1 35.39,102.545
X$101 3 12 M2_M1_CDNS_40661956134142
* cell instance $102 r0 *1 52.835,102.545
X$102 3 13 M2_M1_CDNS_40661956134140
* cell instance $103 r0 *1 21.615,100.105
X$103 3 10 M2_M1_CDNS_40661956134140
* cell instance $104 r0 *1 35.39,100.105
X$104 3 12 M2_M1_CDNS_40661956134142
* cell instance $105 r0 *1 52.835,100.105
X$105 3 13 M2_M1_CDNS_40661956134140
* cell instance $106 r0 *1 21.615,97.665
X$106 3 10 M2_M1_CDNS_40661956134140
* cell instance $107 r0 *1 35.39,97.665
X$107 3 12 M2_M1_CDNS_40661956134142
* cell instance $108 r0 *1 52.835,97.665
X$108 3 13 M2_M1_CDNS_40661956134140
* cell instance $109 r0 *1 21.615,90.265
X$109 3 10 M2_M1_CDNS_40661956134140
* cell instance $110 r0 *1 35.39,90.265
X$110 3 12 M2_M1_CDNS_40661956134142
* cell instance $111 r0 *1 52.835,90.265
X$111 3 13 M2_M1_CDNS_40661956134140
* cell instance $112 r0 *1 21.615,87.825
X$112 3 10 M2_M1_CDNS_40661956134140
* cell instance $113 r0 *1 35.39,87.825
X$113 3 12 M2_M1_CDNS_40661956134142
* cell instance $114 r0 *1 52.835,87.825
X$114 3 13 M2_M1_CDNS_40661956134140
* cell instance $115 r0 *1 21.615,85.385
X$115 3 10 M2_M1_CDNS_40661956134140
* cell instance $116 r0 *1 35.39,85.385
X$116 3 12 M2_M1_CDNS_40661956134142
* cell instance $117 r0 *1 52.835,85.385
X$117 3 13 M2_M1_CDNS_40661956134140
* cell instance $118 r0 *1 21.615,104.985
X$118 3 10 M2_M1_CDNS_40661956134140
* cell instance $119 r0 *1 35.39,104.985
X$119 3 12 M2_M1_CDNS_40661956134142
* cell instance $120 r0 *1 52.835,104.985
X$120 3 13 M2_M1_CDNS_40661956134140
* cell instance $121 r0 *1 21.615,82.945
X$121 3 10 M2_M1_CDNS_40661956134140
* cell instance $122 r0 *1 35.39,82.945
X$122 3 12 M2_M1_CDNS_40661956134142
* cell instance $123 r0 *1 52.835,82.945
X$123 3 13 M2_M1_CDNS_40661956134140
* cell instance $124 r0 *1 21.615,58.465
X$124 3 10 M2_M1_CDNS_40661956134140
* cell instance $125 r0 *1 35.39,58.465
X$125 3 12 M2_M1_CDNS_40661956134142
* cell instance $126 r0 *1 52.835,58.465
X$126 3 13 M2_M1_CDNS_40661956134140
* cell instance $127 r0 *1 21.615,56.025
X$127 3 10 M2_M1_CDNS_40661956134140
* cell instance $128 r0 *1 35.39,56.025
X$128 3 12 M2_M1_CDNS_40661956134142
* cell instance $129 r0 *1 52.835,56.025
X$129 3 13 M2_M1_CDNS_40661956134140
* cell instance $130 r0 *1 21.615,53.585
X$130 3 10 M2_M1_CDNS_40661956134140
* cell instance $131 r0 *1 35.39,53.585
X$131 3 12 M2_M1_CDNS_40661956134142
* cell instance $132 r0 *1 52.835,53.585
X$132 3 13 M2_M1_CDNS_40661956134140
* cell instance $133 r0 *1 21.615,51.145
X$133 3 10 M2_M1_CDNS_40661956134140
* cell instance $134 r0 *1 35.39,51.145
X$134 3 12 M2_M1_CDNS_40661956134142
* cell instance $135 r0 *1 52.835,51.145
X$135 3 13 M2_M1_CDNS_40661956134140
* cell instance $136 r0 *1 21.615,48.705
X$136 3 10 M2_M1_CDNS_40661956134140
* cell instance $137 r0 *1 35.39,48.705
X$137 3 12 M2_M1_CDNS_40661956134142
* cell instance $138 r0 *1 52.835,48.705
X$138 3 13 M2_M1_CDNS_40661956134140
* cell instance $139 r0 *1 21.615,46.265
X$139 3 10 M2_M1_CDNS_40661956134140
* cell instance $140 r0 *1 35.39,46.265
X$140 3 12 M2_M1_CDNS_40661956134142
* cell instance $141 r0 *1 52.835,46.265
X$141 3 13 M2_M1_CDNS_40661956134140
* cell instance $142 r0 *1 21.615,43.825
X$142 3 10 M2_M1_CDNS_40661956134140
* cell instance $143 r0 *1 35.39,43.825
X$143 3 12 M2_M1_CDNS_40661956134142
* cell instance $144 r0 *1 52.835,43.825
X$144 3 13 M2_M1_CDNS_40661956134140
* cell instance $145 r0 *1 21.615,41.385
X$145 3 10 M2_M1_CDNS_40661956134140
* cell instance $146 r0 *1 35.39,41.385
X$146 3 12 M2_M1_CDNS_40661956134142
* cell instance $147 r0 *1 52.835,41.385
X$147 3 13 M2_M1_CDNS_40661956134140
* cell instance $148 r0 *1 21.615,38.945
X$148 3 10 M2_M1_CDNS_40661956134140
* cell instance $149 r0 *1 35.39,38.945
X$149 3 12 M2_M1_CDNS_40661956134142
* cell instance $150 r0 *1 52.835,38.945
X$150 3 13 M2_M1_CDNS_40661956134140
* cell instance $151 r0 *1 21.615,36.505
X$151 3 10 M2_M1_CDNS_40661956134140
* cell instance $152 r0 *1 35.39,36.505
X$152 3 12 M2_M1_CDNS_40661956134142
* cell instance $153 r0 *1 52.835,36.505
X$153 3 13 M2_M1_CDNS_40661956134140
* cell instance $154 r0 *1 21.615,60.905
X$154 3 10 M2_M1_CDNS_40661956134140
* cell instance $155 r0 *1 35.39,60.905
X$155 3 12 M2_M1_CDNS_40661956134142
* cell instance $156 r0 *1 52.835,60.905
X$156 3 13 M2_M1_CDNS_40661956134140
* cell instance $157 r0 *1 2.97,1.135
X$157 3 6 M2_M1_CDNS_40661956134145
* cell instance $158 r0 *1 21.615,1.135
X$158 3 10 M2_M1_CDNS_40661956134144
* cell instance $159 r0 *1 35.39,1.135
X$159 3 12 M2_M1_CDNS_40661956134145
* cell instance $160 r0 *1 52.835,1.135
X$160 3 13 M2_M1_CDNS_40661956134144
* cell instance $161 r0 *1 1.135,63.385
X$161 3 6 M2_M1_CDNS_40661956134148
* cell instance $162 r0 *1 2.97,125.635
X$162 3 6 M2_M1_CDNS_40661956134145
* cell instance $163 r0 *1 21.615,125.635
X$163 3 10 M2_M1_CDNS_40661956134144
* cell instance $164 r0 *1 35.39,125.635
X$164 3 12 M2_M1_CDNS_40661956134145
* cell instance $165 r0 *1 52.835,125.635
X$165 3 13 M2_M1_CDNS_40661956134144
* cell instance $166 r0 *1 3.885,63.385
X$166 5 4 M1_PSUB_CDNS_40661956134137
* cell instance $167 r0 *1 32.405,4.135
X$167 5 4 M1_PSUB_CDNS_40661956134138
* cell instance $168 r0 *1 32.405,34.025
X$168 5 4 M1_PSUB_CDNS_40661956134134
* cell instance $169 r0 *1 32.405,92.745
X$169 5 4 M1_PSUB_CDNS_40661956134134
* cell instance $170 r0 *1 32.405,63.385
X$170 5 4 M1_PSUB_CDNS_40661956134134
* cell instance $171 r0 *1 32.405,122.635
X$171 5 4 M1_PSUB_CDNS_40661956134138
* cell instance $172 r0 *1 60.925,63.385
X$172 5 4 M1_PSUB_CDNS_40661956134137
* cell instance $173 r0 *1 60.925,63.385
X$173 5 15 M2_M1_CDNS_40661956134146
* cell instance $174 r0 *1 11.975,69.525
X$174 5 7 M2_M1_CDNS_40661956134140
* cell instance $175 r0 *1 29.42,69.525
X$175 5 9 M2_M1_CDNS_40661956134142
* cell instance $176 r0 *1 43.195,69.525
X$176 5 11 M2_M1_CDNS_40661956134140
* cell instance $177 r0 *1 11.975,81.725
X$177 5 7 M2_M1_CDNS_40661956134140
* cell instance $178 r0 *1 29.42,81.725
X$178 5 9 M2_M1_CDNS_40661956134142
* cell instance $179 r0 *1 43.195,81.725
X$179 5 11 M2_M1_CDNS_40661956134140
* cell instance $180 r0 *1 11.975,71.965
X$180 5 7 M2_M1_CDNS_40661956134140
* cell instance $181 r0 *1 29.42,71.965
X$181 5 9 M2_M1_CDNS_40661956134142
* cell instance $182 r0 *1 43.195,71.965
X$182 5 11 M2_M1_CDNS_40661956134140
* cell instance $183 r0 *1 11.975,76.845
X$183 5 7 M2_M1_CDNS_40661956134140
* cell instance $184 r0 *1 29.42,76.845
X$184 5 9 M2_M1_CDNS_40661956134142
* cell instance $185 r0 *1 43.195,76.845
X$185 5 11 M2_M1_CDNS_40661956134140
* cell instance $186 r0 *1 11.975,74.405
X$186 5 7 M2_M1_CDNS_40661956134140
* cell instance $187 r0 *1 29.42,74.405
X$187 5 9 M2_M1_CDNS_40661956134142
* cell instance $188 r0 *1 43.195,74.405
X$188 5 11 M2_M1_CDNS_40661956134140
* cell instance $189 r0 *1 11.975,79.285
X$189 5 7 M2_M1_CDNS_40661956134140
* cell instance $190 r0 *1 29.42,79.285
X$190 5 9 M2_M1_CDNS_40661956134142
* cell instance $191 r0 *1 43.195,79.285
X$191 5 11 M2_M1_CDNS_40661956134140
* cell instance $192 r0 *1 11.975,67.085
X$192 5 7 M2_M1_CDNS_40661956134140
* cell instance $193 r0 *1 29.42,67.085
X$193 5 9 M2_M1_CDNS_40661956134142
* cell instance $194 r0 *1 43.195,67.085
X$194 5 11 M2_M1_CDNS_40661956134140
* cell instance $195 r0 *1 11.975,118.405
X$195 5 7 M2_M1_CDNS_40661956134140
* cell instance $196 r0 *1 29.42,118.405
X$196 5 9 M2_M1_CDNS_40661956134142
* cell instance $197 r0 *1 43.195,118.405
X$197 5 11 M2_M1_CDNS_40661956134140
* cell instance $198 r0 *1 11.975,115.965
X$198 5 7 M2_M1_CDNS_40661956134140
* cell instance $199 r0 *1 29.42,115.965
X$199 5 9 M2_M1_CDNS_40661956134142
* cell instance $200 r0 *1 43.195,115.965
X$200 5 11 M2_M1_CDNS_40661956134140
* cell instance $201 r0 *1 11.975,113.525
X$201 5 7 M2_M1_CDNS_40661956134140
* cell instance $202 r0 *1 29.42,113.525
X$202 5 9 M2_M1_CDNS_40661956134142
* cell instance $203 r0 *1 43.195,113.525
X$203 5 11 M2_M1_CDNS_40661956134140
* cell instance $204 r0 *1 11.975,111.085
X$204 5 7 M2_M1_CDNS_40661956134140
* cell instance $205 r0 *1 29.42,111.085
X$205 5 9 M2_M1_CDNS_40661956134142
* cell instance $206 r0 *1 43.195,111.085
X$206 5 11 M2_M1_CDNS_40661956134140
* cell instance $207 r0 *1 11.975,30.325
X$207 5 7 M2_M1_CDNS_40661956134140
* cell instance $208 r0 *1 29.42,30.325
X$208 5 9 M2_M1_CDNS_40661956134142
* cell instance $209 r0 *1 43.195,30.325
X$209 5 11 M2_M1_CDNS_40661956134140
* cell instance $210 r0 *1 11.975,23.005
X$210 5 7 M2_M1_CDNS_40661956134140
* cell instance $211 r0 *1 29.42,23.005
X$211 5 9 M2_M1_CDNS_40661956134142
* cell instance $212 r0 *1 43.195,23.005
X$212 5 11 M2_M1_CDNS_40661956134140
* cell instance $213 r0 *1 11.975,20.565
X$213 5 7 M2_M1_CDNS_40661956134140
* cell instance $214 r0 *1 29.42,20.565
X$214 5 9 M2_M1_CDNS_40661956134142
* cell instance $215 r0 *1 43.195,20.565
X$215 5 11 M2_M1_CDNS_40661956134140
* cell instance $216 r0 *1 11.975,18.125
X$216 5 7 M2_M1_CDNS_40661956134140
* cell instance $217 r0 *1 29.42,18.125
X$217 5 9 M2_M1_CDNS_40661956134142
* cell instance $218 r0 *1 43.195,18.125
X$218 5 11 M2_M1_CDNS_40661956134140
* cell instance $219 r0 *1 11.975,15.685
X$219 5 7 M2_M1_CDNS_40661956134140
* cell instance $220 r0 *1 29.42,15.685
X$220 5 9 M2_M1_CDNS_40661956134142
* cell instance $221 r0 *1 43.195,15.685
X$221 5 11 M2_M1_CDNS_40661956134140
* cell instance $222 r0 *1 11.975,13.245
X$222 5 7 M2_M1_CDNS_40661956134140
* cell instance $223 r0 *1 29.42,13.245
X$223 5 9 M2_M1_CDNS_40661956134142
* cell instance $224 r0 *1 43.195,13.245
X$224 5 11 M2_M1_CDNS_40661956134140
* cell instance $225 r0 *1 11.975,10.805
X$225 5 7 M2_M1_CDNS_40661956134140
* cell instance $226 r0 *1 29.42,10.805
X$226 5 9 M2_M1_CDNS_40661956134142
* cell instance $227 r0 *1 43.195,10.805
X$227 5 11 M2_M1_CDNS_40661956134140
* cell instance $228 r0 *1 11.975,8.365
X$228 5 7 M2_M1_CDNS_40661956134140
* cell instance $229 r0 *1 29.42,8.365
X$229 5 9 M2_M1_CDNS_40661956134142
* cell instance $230 r0 *1 43.195,8.365
X$230 5 11 M2_M1_CDNS_40661956134140
* cell instance $231 r0 *1 11.975,96.445
X$231 5 7 M2_M1_CDNS_40661956134140
* cell instance $232 r0 *1 29.42,96.445
X$232 5 9 M2_M1_CDNS_40661956134142
* cell instance $233 r0 *1 43.195,96.445
X$233 5 11 M2_M1_CDNS_40661956134140
* cell instance $234 r0 *1 11.975,106.205
X$234 5 7 M2_M1_CDNS_40661956134140
* cell instance $235 r0 *1 29.42,106.205
X$235 5 9 M2_M1_CDNS_40661956134142
* cell instance $236 r0 *1 43.195,106.205
X$236 5 11 M2_M1_CDNS_40661956134140
* cell instance $237 r0 *1 11.975,25.445
X$237 5 7 M2_M1_CDNS_40661956134140
* cell instance $238 r0 *1 29.42,25.445
X$238 5 9 M2_M1_CDNS_40661956134142
* cell instance $239 r0 *1 43.195,25.445
X$239 5 11 M2_M1_CDNS_40661956134140
* cell instance $240 r0 *1 11.975,101.325
X$240 5 7 M2_M1_CDNS_40661956134140
* cell instance $241 r0 *1 29.42,101.325
X$241 5 9 M2_M1_CDNS_40661956134142
* cell instance $242 r0 *1 43.195,101.325
X$242 5 11 M2_M1_CDNS_40661956134140
* cell instance $243 r0 *1 11.975,98.885
X$243 5 7 M2_M1_CDNS_40661956134140
* cell instance $244 r0 *1 29.42,98.885
X$244 5 9 M2_M1_CDNS_40661956134142
* cell instance $245 r0 *1 43.195,98.885
X$245 5 11 M2_M1_CDNS_40661956134140
* cell instance $246 r0 *1 11.975,108.645
X$246 5 7 M2_M1_CDNS_40661956134140
* cell instance $247 r0 *1 29.42,108.645
X$247 5 9 M2_M1_CDNS_40661956134142
* cell instance $248 r0 *1 43.195,108.645
X$248 5 11 M2_M1_CDNS_40661956134140
* cell instance $249 r0 *1 11.975,89.045
X$249 5 7 M2_M1_CDNS_40661956134140
* cell instance $250 r0 *1 29.42,89.045
X$250 5 9 M2_M1_CDNS_40661956134142
* cell instance $251 r0 *1 43.195,89.045
X$251 5 11 M2_M1_CDNS_40661956134140
* cell instance $252 r0 *1 11.975,86.605
X$252 5 7 M2_M1_CDNS_40661956134140
* cell instance $253 r0 *1 29.42,86.605
X$253 5 9 M2_M1_CDNS_40661956134142
* cell instance $254 r0 *1 43.195,86.605
X$254 5 11 M2_M1_CDNS_40661956134140
* cell instance $255 r0 *1 11.975,84.165
X$255 5 7 M2_M1_CDNS_40661956134140
* cell instance $256 r0 *1 29.42,84.165
X$256 5 9 M2_M1_CDNS_40661956134142
* cell instance $257 r0 *1 43.195,84.165
X$257 5 11 M2_M1_CDNS_40661956134140
* cell instance $258 r0 *1 11.975,103.765
X$258 5 7 M2_M1_CDNS_40661956134140
* cell instance $259 r0 *1 29.42,103.765
X$259 5 9 M2_M1_CDNS_40661956134142
* cell instance $260 r0 *1 43.195,103.765
X$260 5 11 M2_M1_CDNS_40661956134140
* cell instance $261 r0 *1 11.975,59.685
X$261 5 7 M2_M1_CDNS_40661956134140
* cell instance $262 r0 *1 29.42,59.685
X$262 5 9 M2_M1_CDNS_40661956134142
* cell instance $263 r0 *1 43.195,59.685
X$263 5 11 M2_M1_CDNS_40661956134140
* cell instance $264 r0 *1 11.975,57.245
X$264 5 7 M2_M1_CDNS_40661956134140
* cell instance $265 r0 *1 29.42,57.245
X$265 5 9 M2_M1_CDNS_40661956134142
* cell instance $266 r0 *1 43.195,57.245
X$266 5 11 M2_M1_CDNS_40661956134140
* cell instance $267 r0 *1 11.975,54.805
X$267 5 7 M2_M1_CDNS_40661956134140
* cell instance $268 r0 *1 29.42,54.805
X$268 5 9 M2_M1_CDNS_40661956134142
* cell instance $269 r0 *1 43.195,54.805
X$269 5 11 M2_M1_CDNS_40661956134140
* cell instance $270 r0 *1 11.975,52.365
X$270 5 7 M2_M1_CDNS_40661956134140
* cell instance $271 r0 *1 29.42,52.365
X$271 5 9 M2_M1_CDNS_40661956134142
* cell instance $272 r0 *1 43.195,52.365
X$272 5 11 M2_M1_CDNS_40661956134140
* cell instance $273 r0 *1 11.975,47.485
X$273 5 7 M2_M1_CDNS_40661956134140
* cell instance $274 r0 *1 29.42,47.485
X$274 5 9 M2_M1_CDNS_40661956134142
* cell instance $275 r0 *1 43.195,47.485
X$275 5 11 M2_M1_CDNS_40661956134140
* cell instance $276 r0 *1 11.975,45.045
X$276 5 7 M2_M1_CDNS_40661956134140
* cell instance $277 r0 *1 29.42,45.045
X$277 5 9 M2_M1_CDNS_40661956134142
* cell instance $278 r0 *1 43.195,45.045
X$278 5 11 M2_M1_CDNS_40661956134140
* cell instance $279 r0 *1 11.975,27.885
X$279 5 7 M2_M1_CDNS_40661956134140
* cell instance $280 r0 *1 29.42,27.885
X$280 5 9 M2_M1_CDNS_40661956134142
* cell instance $281 r0 *1 43.195,27.885
X$281 5 11 M2_M1_CDNS_40661956134140
* cell instance $282 r0 *1 11.975,42.605
X$282 5 7 M2_M1_CDNS_40661956134140
* cell instance $283 r0 *1 29.42,42.605
X$283 5 9 M2_M1_CDNS_40661956134142
* cell instance $284 r0 *1 43.195,42.605
X$284 5 11 M2_M1_CDNS_40661956134140
* cell instance $285 r0 *1 11.975,40.165
X$285 5 7 M2_M1_CDNS_40661956134140
* cell instance $286 r0 *1 29.42,40.165
X$286 5 9 M2_M1_CDNS_40661956134142
* cell instance $287 r0 *1 43.195,40.165
X$287 5 11 M2_M1_CDNS_40661956134140
* cell instance $288 r0 *1 11.975,37.725
X$288 5 7 M2_M1_CDNS_40661956134140
* cell instance $289 r0 *1 29.42,37.725
X$289 5 9 M2_M1_CDNS_40661956134142
* cell instance $290 r0 *1 43.195,37.725
X$290 5 11 M2_M1_CDNS_40661956134140
* cell instance $291 r0 *1 11.975,49.925
X$291 5 7 M2_M1_CDNS_40661956134140
* cell instance $292 r0 *1 29.42,49.925
X$292 5 9 M2_M1_CDNS_40661956134142
* cell instance $293 r0 *1 43.195,49.925
X$293 5 11 M2_M1_CDNS_40661956134140
* cell instance $294 r0 *1 11.975,4.135
X$294 5 7 M2_M1_CDNS_40661956134144
* cell instance $295 r0 *1 29.42,4.135
X$295 5 9 M2_M1_CDNS_40661956134145
* cell instance $296 r0 *1 43.195,4.135
X$296 5 11 M2_M1_CDNS_40661956134144
* cell instance $297 r0 *1 11.975,122.635
X$297 5 7 M2_M1_CDNS_40661956134144
* cell instance $298 r0 *1 29.42,122.635
X$298 5 9 M2_M1_CDNS_40661956134145
* cell instance $299 r0 *1 43.195,122.635
X$299 5 11 M2_M1_CDNS_40661956134144
* cell instance $300 r0 *1 11.975,63.385
X$300 5 7 M2_M1_CDNS_40661956134143
* cell instance $301 r0 *1 29.42,63.385
X$301 5 9 M2_M1_CDNS_40661956134147
* cell instance $302 r0 *1 43.195,63.385
X$302 5 11 M2_M1_CDNS_40661956134143
* cell instance $303 r0 *1 11.975,34.025
X$303 5 7 M2_M1_CDNS_40661956134143
* cell instance $304 r0 *1 29.42,34.025
X$304 5 9 M2_M1_CDNS_40661956134147
* cell instance $305 r0 *1 43.195,34.025
X$305 5 11 M2_M1_CDNS_40661956134143
* cell instance $306 r0 *1 11.975,92.745
X$306 5 7 M2_M1_CDNS_40661956134143
* cell instance $307 r0 *1 29.42,92.745
X$307 5 9 M2_M1_CDNS_40661956134147
* cell instance $308 r0 *1 43.195,92.745
X$308 5 11 M2_M1_CDNS_40661956134143
.ENDS nmos_clamp_20_50_4

* cell M1_PSUB_CDNS_40661956134125
* pin
* pin
.SUBCKT M1_PSUB_CDNS_40661956134125 1 2
.ENDS M1_PSUB_CDNS_40661956134125

* cell M2_M1_CDNS_40661956134126
* pin
* pin
.SUBCKT M2_M1_CDNS_40661956134126 1 2
.ENDS M2_M1_CDNS_40661956134126

* cell M1_POLY2_CDNS_40661956134127
* pin
.SUBCKT M1_POLY2_CDNS_40661956134127 1
.ENDS M1_POLY2_CDNS_40661956134127

* cell M1_POLY2_CDNS_40661956134128
* pin
.SUBCKT M1_POLY2_CDNS_40661956134128 1
.ENDS M1_POLY2_CDNS_40661956134128

* cell M1_NWELL_CDNS_40661956134129
* pin
* pin
* pin
* pin
.SUBCKT M1_NWELL_CDNS_40661956134129 1 2 3 4
.ENDS M1_NWELL_CDNS_40661956134129

* cell M1_POLY2_CDNS_40661956134130
* pin
.SUBCKT M1_POLY2_CDNS_40661956134130 1
.ENDS M1_POLY2_CDNS_40661956134130

* cell M1_POLY2_CDNS_40661956134131
* pin
.SUBCKT M1_POLY2_CDNS_40661956134131 1
.ENDS M1_POLY2_CDNS_40661956134131

* cell M1_POLY2_CDNS_40661956134132
* pin
.SUBCKT M1_POLY2_CDNS_40661956134132 1
.ENDS M1_POLY2_CDNS_40661956134132

* cell pmos_6p0_CDNS_406619561342
* pin
* pin
* pin
* pin
* pin
* pin
* pin
* pin
* pin
* pin
* pin
* pin
* pin
* pin
* pin
* pin
* pin
* pin
* pin
* pin
* pin
* pin
* pin
* pin
* pin
* pin
* pin
* pin
* pin
* pin
* pin
* pin
* pin
* pin
* pin
* pin
* pin
* pin
* pin
* pin
* pin
* pin
* pin
* pin
* pin
* pin
* pin
* pin
* pin
* pin
* pin
.SUBCKT pmos_6p0_CDNS_406619561342 2 3 4 5 6 7 8 9 10 11 12 13 14 15 16 17 18
+ 19 20 21 22 23 24 25 26 27 28 29 30 31 32 33 34 35 36 37 38 39 40 41 42 43 44
+ 45 46 47 48 49 50 51 52
.ENDS pmos_6p0_CDNS_406619561342

* cell pmos_6p0_CDNS_406619561343
* pin
* pin
* pin
* pin
* pin
* pin
* pin
* pin
* pin
* pin
.SUBCKT pmos_6p0_CDNS_406619561343 1 2 3 4 5 6 7 8 9 10
.ENDS pmos_6p0_CDNS_406619561343

* cell pmos_6p0_CDNS_406619561344
* pin
* pin
* pin
* pin
* pin
* pin
* pin
* pin
* pin
* pin
* pin
* pin
.SUBCKT pmos_6p0_CDNS_406619561344 1 2 3 4 5 6 7 8 9 10 11 12
.ENDS pmos_6p0_CDNS_406619561344

* cell nmos_6p0_CDNS_406619561346
* pin
* pin
* pin
* pin
* pin
* pin
* pin
* pin
* pin
* pin
* pin
* pin
* pin
* pin
.SUBCKT nmos_6p0_CDNS_406619561346 1 2 3 4 5 6 7 8 9 10 11 12 13 14
.ENDS nmos_6p0_CDNS_406619561346

* cell nmos_6p0_CDNS_406619561347
* pin
* pin
* pin
* pin gf180mcu_gnd
.SUBCKT nmos_6p0_CDNS_406619561347 2 3 4 5
* net 5 gf180mcu_gnd
* device instance $1 r0 *1 0.35,2.5 nmos_6p0
M$1 3 4 2 5 nmos_6p0 L=0.7U W=5U AS=2.2P AD=2.2P PS=10.88U PD=10.88U
.ENDS nmos_6p0_CDNS_406619561347

* cell M1_NWELL_CDNS_40661956134133
* pin
* pin
* pin
* pin
.SUBCKT M1_NWELL_CDNS_40661956134133 1 2 3 4
.ENDS M1_NWELL_CDNS_40661956134133

* cell M3_M2_CDNS_40661956134114
* pin
* pin
.SUBCKT M3_M2_CDNS_40661956134114 1 2
.ENDS M3_M2_CDNS_40661956134114

* cell M2_M1_CDNS_40661956134115
* pin
* pin
.SUBCKT M2_M1_CDNS_40661956134115 1 2
.ENDS M2_M1_CDNS_40661956134115

* cell M2_M1_CDNS_40661956134250
* pin
* pin
.SUBCKT M2_M1_CDNS_40661956134250 1 2
.ENDS M2_M1_CDNS_40661956134250

* cell M2_M1_CDNS_40661956134207
* pin
* pin
.SUBCKT M2_M1_CDNS_40661956134207 1 2
.ENDS M2_M1_CDNS_40661956134207

* cell M2_M1_CDNS_40661956134166
* pin
* pin
.SUBCKT M2_M1_CDNS_40661956134166 1 2
.ENDS M2_M1_CDNS_40661956134166

* cell M2_M1_CDNS_40661956134149
* pin
* pin
.SUBCKT M2_M1_CDNS_40661956134149 1 2
.ENDS M2_M1_CDNS_40661956134149

* cell M2_M1_CDNS_40661956134150
* pin
* pin
.SUBCKT M2_M1_CDNS_40661956134150 1 2
.ENDS M2_M1_CDNS_40661956134150

* cell M2_M1_CDNS_40661956134151
* pin
* pin
.SUBCKT M2_M1_CDNS_40661956134151 1 2
.ENDS M2_M1_CDNS_40661956134151

* cell M2_M1_CDNS_40661956134152
* pin
* pin
.SUBCKT M2_M1_CDNS_40661956134152 1 2
.ENDS M2_M1_CDNS_40661956134152

* cell ppolyf_u_CDNS_406619561345
* pin
* pin
* pin gf180mcu_gnd
.SUBCKT ppolyf_u_CDNS_406619561345 1 2 3
* net 3 gf180mcu_gnd
* device instance $1 r0 *1 32.437,0.4 ppolyf_u
R$1 2 1 3 27936.5625 ppolyf_u L=63.855U W=0.8U
.ENDS ppolyf_u_CDNS_406619561345

* cell nmoscap_6p0_CDNS_406619561340
* pin
* pin
.SUBCKT nmoscap_6p0_CDNS_406619561340 1 2
* device instance $1 r0 *1 5,12.5 nmoscap_6p0
C$1 2 1 5.75e-13 nmoscap_6p0 A=250P P=70U
.ENDS nmoscap_6p0_CDNS_406619561340

* cell M1_PSUB_CDNS_4066195613411
* pin
* pin
.SUBCKT M1_PSUB_CDNS_4066195613411 1 2
.ENDS M1_PSUB_CDNS_4066195613411

* cell M1_PSUB_CDNS_406619561349
* pin
* pin
.SUBCKT M1_PSUB_CDNS_406619561349 1 2
.ENDS M1_PSUB_CDNS_406619561349

* cell M1_NWELL_CDNS_40661956134154
* pin
* pin
* pin
* pin
.SUBCKT M1_NWELL_CDNS_40661956134154 1 2 3 4
.ENDS M1_NWELL_CDNS_40661956134154

* cell M1_NWELL_CDNS_40661956134153
* pin
* pin
* pin
* pin
.SUBCKT M1_NWELL_CDNS_40661956134153 1 2 3 4
.ENDS M1_NWELL_CDNS_40661956134153

* cell M2_M1_CDNS_40661956134142
* pin
* pin
.SUBCKT M2_M1_CDNS_40661956134142 1 2
.ENDS M2_M1_CDNS_40661956134142

* cell M2_M1_CDNS_40661956134144
* pin
* pin
.SUBCKT M2_M1_CDNS_40661956134144 1 2
.ENDS M2_M1_CDNS_40661956134144

* cell M2_M1_CDNS_40661956134141
* pin
* pin
.SUBCKT M2_M1_CDNS_40661956134141 1 2
.ENDS M2_M1_CDNS_40661956134141

* cell M1_POLY2_CDNS_40661956134136
* pin
.SUBCKT M1_POLY2_CDNS_40661956134136 1
.ENDS M1_POLY2_CDNS_40661956134136

* cell M2_M1_CDNS_40661956134145
* pin
* pin
.SUBCKT M2_M1_CDNS_40661956134145 1 2
.ENDS M2_M1_CDNS_40661956134145

* cell M2_M1_CDNS_40661956134140
* pin
* pin
.SUBCKT M2_M1_CDNS_40661956134140 1 2
.ENDS M2_M1_CDNS_40661956134140

* cell M2_M1_CDNS_40661956134146
* pin
* pin
.SUBCKT M2_M1_CDNS_40661956134146 1 2
.ENDS M2_M1_CDNS_40661956134146

* cell M2_M1_CDNS_40661956134148
* pin
* pin
.SUBCKT M2_M1_CDNS_40661956134148 1 2
.ENDS M2_M1_CDNS_40661956134148

* cell M2_M1_CDNS_40661956134143
* pin
* pin
.SUBCKT M2_M1_CDNS_40661956134143 1 2
.ENDS M2_M1_CDNS_40661956134143

* cell M2_M1_CDNS_40661956134147
* pin
* pin
.SUBCKT M2_M1_CDNS_40661956134147 1 2
.ENDS M2_M1_CDNS_40661956134147

* cell nmos_6p0_CDNS_406619561341
* pin
* pin
* pin
* pin
* pin
* pin
* pin
* pin
* pin
* pin
* pin
* pin
* pin
* pin
* pin
* pin
* pin
* pin
* pin
* pin
* pin
* pin
* pin
* pin
* pin
* pin
* pin
* pin
* pin
* pin
* pin
* pin
* pin
* pin
* pin
* pin
* pin
* pin
* pin
* pin
* pin
* pin gf180mcu_gnd
.SUBCKT nmos_6p0_CDNS_406619561341 2 3 4 5 6 7 8 9 10 11 12 13 14 15 16 17 18
+ 19 20 21 22 23 24 25 26 27 28 29 30 31 32 33 34 35 36 37 38 39 40 41 42 43
* net 43 gf180mcu_gnd
* device instance $1 r0 *1 0.35,25 nmos_6p0
M$1 3 23 2 43 nmos_6p0 L=0.7U W=50U AS=22P AD=13P PS=100.88U PD=50.52U
* device instance $2 r0 *1 1.57,25 nmos_6p0
M$2 4 24 3 43 nmos_6p0 L=0.7U W=50U AS=13P AD=13P PS=50.52U PD=50.52U
* device instance $3 r0 *1 2.79,25 nmos_6p0
M$3 5 25 4 43 nmos_6p0 L=0.7U W=50U AS=13P AD=13P PS=50.52U PD=50.52U
* device instance $4 r0 *1 4.01,25 nmos_6p0
M$4 6 26 5 43 nmos_6p0 L=0.7U W=50U AS=13P AD=13P PS=50.52U PD=50.52U
* device instance $5 r0 *1 5.23,25 nmos_6p0
M$5 7 27 6 43 nmos_6p0 L=0.7U W=50U AS=13P AD=13P PS=50.52U PD=50.52U
* device instance $6 r0 *1 6.45,25 nmos_6p0
M$6 8 28 7 43 nmos_6p0 L=0.7U W=50U AS=13P AD=13P PS=50.52U PD=50.52U
* device instance $7 r0 *1 7.67,25 nmos_6p0
M$7 9 29 8 43 nmos_6p0 L=0.7U W=50U AS=13P AD=13P PS=50.52U PD=50.52U
* device instance $8 r0 *1 8.89,25 nmos_6p0
M$8 10 30 9 43 nmos_6p0 L=0.7U W=50U AS=13P AD=13P PS=50.52U PD=50.52U
* device instance $9 r0 *1 10.11,25 nmos_6p0
M$9 11 31 10 43 nmos_6p0 L=0.7U W=50U AS=13P AD=13P PS=50.52U PD=50.52U
* device instance $10 r0 *1 11.33,25 nmos_6p0
M$10 12 32 11 43 nmos_6p0 L=0.7U W=50U AS=13P AD=13P PS=50.52U PD=50.52U
* device instance $11 r0 *1 12.55,25 nmos_6p0
M$11 13 33 12 43 nmos_6p0 L=0.7U W=50U AS=13P AD=13P PS=50.52U PD=50.52U
* device instance $12 r0 *1 13.77,25 nmos_6p0
M$12 14 34 13 43 nmos_6p0 L=0.7U W=50U AS=13P AD=13P PS=50.52U PD=50.52U
* device instance $13 r0 *1 14.99,25 nmos_6p0
M$13 15 35 14 43 nmos_6p0 L=0.7U W=50U AS=13P AD=13P PS=50.52U PD=50.52U
* device instance $14 r0 *1 16.21,25 nmos_6p0
M$14 16 36 15 43 nmos_6p0 L=0.7U W=50U AS=13P AD=13P PS=50.52U PD=50.52U
* device instance $15 r0 *1 17.43,25 nmos_6p0
M$15 17 37 16 43 nmos_6p0 L=0.7U W=50U AS=13P AD=13P PS=50.52U PD=50.52U
* device instance $16 r0 *1 18.65,25 nmos_6p0
M$16 18 38 17 43 nmos_6p0 L=0.7U W=50U AS=13P AD=13P PS=50.52U PD=50.52U
* device instance $17 r0 *1 19.87,25 nmos_6p0
M$17 19 39 18 43 nmos_6p0 L=0.7U W=50U AS=13P AD=13P PS=50.52U PD=50.52U
* device instance $18 r0 *1 21.09,25 nmos_6p0
M$18 20 40 19 43 nmos_6p0 L=0.7U W=50U AS=13P AD=13P PS=50.52U PD=50.52U
* device instance $19 r0 *1 22.31,25 nmos_6p0
M$19 21 41 20 43 nmos_6p0 L=0.7U W=50U AS=13P AD=13P PS=50.52U PD=50.52U
* device instance $20 r0 *1 23.53,25 nmos_6p0
M$20 22 42 21 43 nmos_6p0 L=0.7U W=50U AS=13P AD=22P PS=50.52U PD=100.88U
.ENDS nmos_6p0_CDNS_406619561341

* cell M1_PSUB_CDNS_40661956134138
* pin
* pin
.SUBCKT M1_PSUB_CDNS_40661956134138 1 2
.ENDS M1_PSUB_CDNS_40661956134138

* cell M1_PSUB_CDNS_40661956134137
* pin
* pin
.SUBCKT M1_PSUB_CDNS_40661956134137 1 2
.ENDS M1_PSUB_CDNS_40661956134137

* cell M1_PSUB_CDNS_40661956134134
* pin
* pin
.SUBCKT M1_PSUB_CDNS_40661956134134 1 2
.ENDS M1_PSUB_CDNS_40661956134134

* cell M1_NWELL_CDNS_40661956134139
* pin
* pin
* pin
* pin
.SUBCKT M1_NWELL_CDNS_40661956134139 1 2 3 4
.ENDS M1_NWELL_CDNS_40661956134139

* cell M1_NWELL_CDNS_40661956134135
* pin
* pin
* pin
* pin
.SUBCKT M1_NWELL_CDNS_40661956134135 1 2 3 4
.ENDS M1_NWELL_CDNS_40661956134135
