* cell PAD_RING_TOP
.SUBCKT PAD_RING_TOP
* net 2 gf180mcu_gnd
* cell instance $1 r0 *1 355.16,0
X$1 379 315 51 1 50 49 47 gf180mcu_fd_io__fill10
* cell instance $2 r0 *1 0,0
X$2 21 20 19 1 2 18 gf180mcu_fd_io__cor
* cell instance $3 r0 *1 365.16,0
X$3 379 51 316 1 50 49 47 gf180mcu_fd_io__fill10
* cell instance $4 r0 *1 375.16,0
X$4 379 316 317 1 50 49 47 gf180mcu_fd_io__fill10
* cell instance $5 r0 *1 385.16,0
X$5 379 317 318 1 50 49 47 gf180mcu_fd_io__fill10
* cell instance $6 r0 *1 395.16,0
X$6 379 318 358 1 50 49 47 gf180mcu_fd_io__fill10
* cell instance $7 r0 *1 405.16,0
X$7 379 358 359 1 50 49 47 gf180mcu_fd_io__fill10
* cell instance $8 r0 *1 415.16,0
X$8 379 359 360 1 50 49 47 gf180mcu_fd_io__fill10
* cell instance $9 r0 *1 425.16,0
X$9 379 360 361 1 50 49 47 gf180mcu_fd_io__fill10
* cell instance $10 r0 *1 435.16,0
X$10 379 361 362 1 50 49 47 gf180mcu_fd_io__fill10
* cell instance $11 r0 *1 445.16,0
X$11 379 362 363 1 50 49 47 gf180mcu_fd_io__fill10
* cell instance $12 r0 *1 455.16,0
X$12 379 363 364 1 50 49 47 gf180mcu_fd_io__fill10
* cell instance $13 r0 *1 465.16,0
X$13 379 364 377 1 50 49 47 gf180mcu_fd_io__fill10
* cell instance $14 r0 *1 475.16,0
X$14 379 377 366 1 50 49 47 gf180mcu_fd_io__fill10
* cell instance $15 r0 *1 485.16,0
X$15 379 366 314 1 50 49 47 gf180mcu_fd_io__fill10
* cell instance $16 r0 *1 495.16,0
X$16 379 314 218 1 50 49 47 gf180mcu_fd_io__fill10
* cell instance $17 r0 *1 505.16,0
X$17 1 50 49 47 379 218 218 gf180mcu_fd_io__fill1
* cell instance $18 r0 *1 506.16,0
X$18 1 50 49 47 379 218 218 gf180mcu_fd_io__fill1
* cell instance $19 r0 *1 507.16,0
X$19 1 50 49 47 379 218 218 1 1 1 gf180mcu_fd_io__fillnc
* cell instance $20 r0 *1 507.26,0
X$20 1 50 49 47 379 218 218 1 1 1 gf180mcu_fd_io__fillnc
* cell instance $21 r0 *1 507.36,0
X$21 1 50 49 47 379 218 218 1 1 1 gf180mcu_fd_io__fillnc
* cell instance $22 r0 *1 507.46,0
X$22 1 50 49 47 379 218 218 1 1 1 gf180mcu_fd_io__fillnc
* cell instance $23 r0 *1 507.56,0
X$23 1 50 49 47 379 218 218 1 1 1 gf180mcu_fd_io__fillnc
* cell instance $24 r0 *1 507.66,0
X$24 49 47 50 1 2 365 365 218 218 379 gf180mcu_fd_io__in_s
* cell instance $25 r0 *1 582.66,0
X$25 379 365 333 1 50 49 47 gf180mcu_fd_io__fill10
* cell instance $26 r0 *1 592.66,0
X$26 379 333 334 1 50 49 47 gf180mcu_fd_io__fill10
* cell instance $27 r0 *1 602.66,0
X$27 379 334 335 1 50 49 47 gf180mcu_fd_io__fill10
* cell instance $28 r0 *1 612.66,0
X$28 379 335 336 1 50 49 47 gf180mcu_fd_io__fill10
* cell instance $29 r0 *1 622.66,0
X$29 379 336 337 1 50 49 47 gf180mcu_fd_io__fill10
* cell instance $30 r0 *1 632.66,0
X$30 379 337 338 1 50 49 47 gf180mcu_fd_io__fill10
* cell instance $31 r0 *1 642.66,0
X$31 379 338 339 1 50 49 47 gf180mcu_fd_io__fill10
* cell instance $32 r0 *1 652.66,0
X$32 379 339 340 1 50 49 47 gf180mcu_fd_io__fill10
* cell instance $33 r0 *1 662.66,0
X$33 379 340 341 1 50 49 47 gf180mcu_fd_io__fill10
* cell instance $34 r0 *1 672.66,0
X$34 379 341 343 1 50 49 47 gf180mcu_fd_io__fill10
* cell instance $35 r0 *1 682.66,0
X$35 379 343 344 1 50 49 47 gf180mcu_fd_io__fill10
* cell instance $36 r0 *1 692.66,0
X$36 379 344 345 1 50 49 47 gf180mcu_fd_io__fill10
* cell instance $37 r0 *1 702.66,0
X$37 379 345 346 1 50 49 47 gf180mcu_fd_io__fill10
* cell instance $38 r0 *1 712.66,0
X$38 379 346 347 1 50 49 47 gf180mcu_fd_io__fill10
* cell instance $39 r0 *1 722.66,0
X$39 379 347 43 1 50 49 47 gf180mcu_fd_io__fill10
* cell instance $40 r0 *1 732.66,0
X$40 1 50 49 47 379 43 43 gf180mcu_fd_io__fill1
* cell instance $41 r0 *1 733.66,0
X$41 1 50 49 47 379 43 43 gf180mcu_fd_io__fill1
* cell instance $42 r0 *1 734.66,0
X$42 1 50 49 47 379 43 43 1 1 1 gf180mcu_fd_io__fillnc
* cell instance $43 r0 *1 734.76,0
X$43 1 50 49 47 379 43 43 1 1 1 gf180mcu_fd_io__fillnc
* cell instance $44 r0 *1 734.86,0
X$44 1 50 49 47 379 43 43 1 1 1 gf180mcu_fd_io__fillnc
* cell instance $45 r0 *1 734.96,0
X$45 1 50 49 47 379 43 43 1 1 1 gf180mcu_fd_io__fillnc
* cell instance $46 r0 *1 735.06,0
X$46 1 50 49 47 379 43 43 1 1 1 gf180mcu_fd_io__fillnc
* cell instance $47 r0 *1 735.16,0
X$47 49 47 50 1 2 348 348 43 43 379 gf180mcu_fd_io__in_s
* cell instance $48 r0 *1 810.16,0
X$48 379 348 349 1 50 49 47 gf180mcu_fd_io__fill10
* cell instance $49 r0 *1 820.16,0
X$49 379 349 350 1 50 49 47 gf180mcu_fd_io__fill10
* cell instance $50 r0 *1 830.16,0
X$50 379 350 351 1 50 49 47 gf180mcu_fd_io__fill10
* cell instance $51 r0 *1 840.16,0
X$51 379 351 352 1 50 49 47 gf180mcu_fd_io__fill10
* cell instance $52 r0 *1 850.16,0
X$52 379 352 368 1 50 49 47 gf180mcu_fd_io__fill10
* cell instance $53 r0 *1 860.16,0
X$53 379 368 369 1 50 49 47 gf180mcu_fd_io__fill10
* cell instance $54 r0 *1 870.16,0
X$54 379 369 370 1 50 49 47 gf180mcu_fd_io__fill10
* cell instance $55 r0 *1 880.16,0
X$55 379 370 371 1 50 49 47 gf180mcu_fd_io__fill10
* cell instance $56 r0 *1 890.16,0
X$56 379 371 372 1 50 49 47 gf180mcu_fd_io__fill10
* cell instance $57 r0 *1 900.16,0
X$57 379 372 373 1 50 49 47 gf180mcu_fd_io__fill10
* cell instance $58 r0 *1 910.16,0
X$58 379 373 374 1 50 49 47 gf180mcu_fd_io__fill10
* cell instance $59 r0 *1 920.16,0
X$59 379 374 375 1 50 49 47 gf180mcu_fd_io__fill10
* cell instance $60 r0 *1 930.16,0
X$60 379 375 376 1 50 49 47 gf180mcu_fd_io__fill10
* cell instance $61 r0 *1 940.16,0
X$61 379 376 342 1 50 49 47 gf180mcu_fd_io__fill10
* cell instance $62 r0 *1 950.16,0
X$62 379 342 42 1 50 49 47 gf180mcu_fd_io__fill10
* cell instance $63 r0 *1 960.16,0
X$63 1 50 49 47 379 42 42 gf180mcu_fd_io__fill1
* cell instance $64 r0 *1 961.16,0
X$64 1 50 49 47 379 42 42 gf180mcu_fd_io__fill1
* cell instance $65 r0 *1 962.16,0
X$65 1 50 49 47 379 42 42 1 1 1 gf180mcu_fd_io__fillnc
* cell instance $66 r0 *1 962.26,0
X$66 1 50 49 47 379 42 42 1 1 1 gf180mcu_fd_io__fillnc
* cell instance $67 r0 *1 962.36,0
X$67 1 50 49 47 379 42 42 1 1 1 gf180mcu_fd_io__fillnc
* cell instance $68 r0 *1 962.46,0
X$68 1 50 49 47 379 42 42 1 1 1 gf180mcu_fd_io__fillnc
* cell instance $69 r0 *1 962.56,0
X$69 1 50 49 47 379 42 42 1 1 1 gf180mcu_fd_io__fillnc
* cell instance $70 r0 *1 962.66,0
X$70 49 47 50 1 2 292 292 42 42 379 gf180mcu_fd_io__in_s
* cell instance $71 r0 *1 1037.66,0
X$71 379 292 298 1 50 49 47 gf180mcu_fd_io__fill10
* cell instance $72 r0 *1 1047.66,0
X$72 379 298 297 1 50 49 47 gf180mcu_fd_io__fill10
* cell instance $73 r0 *1 1057.66,0
X$73 379 297 296 1 50 49 47 gf180mcu_fd_io__fill10
* cell instance $74 r0 *1 1067.66,0
X$74 379 296 295 1 50 49 47 gf180mcu_fd_io__fill10
* cell instance $75 r0 *1 1077.66,0
X$75 379 295 294 1 50 49 47 gf180mcu_fd_io__fill10
* cell instance $76 r0 *1 1087.66,0
X$76 379 294 293 1 50 49 47 gf180mcu_fd_io__fill10
* cell instance $77 r0 *1 1097.66,0
X$77 379 293 291 1 50 49 47 gf180mcu_fd_io__fill10
* cell instance $78 r0 *1 1107.66,0
X$78 379 291 290 1 50 49 47 gf180mcu_fd_io__fill10
* cell instance $79 r0 *1 1117.66,0
X$79 379 290 310 1 50 49 47 gf180mcu_fd_io__fill10
* cell instance $80 r0 *1 1127.66,0
X$80 379 310 289 1 50 49 47 gf180mcu_fd_io__fill10
* cell instance $81 r0 *1 1137.66,0
X$81 379 289 330 1 50 49 47 gf180mcu_fd_io__fill10
* cell instance $82 r0 *1 1147.66,0
X$82 379 330 329 1 50 49 47 gf180mcu_fd_io__fill10
* cell instance $83 r0 *1 1157.66,0
X$83 379 329 328 1 50 49 47 gf180mcu_fd_io__fill10
* cell instance $84 r0 *1 1167.66,0
X$84 379 328 327 1 50 49 47 gf180mcu_fd_io__fill10
* cell instance $85 r0 *1 1177.66,0
X$85 379 327 44 1 50 49 47 gf180mcu_fd_io__fill10
* cell instance $86 r0 *1 1187.66,0
X$86 1 50 49 47 379 44 44 gf180mcu_fd_io__fill1
* cell instance $87 r0 *1 1188.66,0
X$87 1 50 49 47 379 44 44 gf180mcu_fd_io__fill1
* cell instance $88 r0 *1 1189.66,0
X$88 1 50 49 47 379 44 44 1 1 1 gf180mcu_fd_io__fillnc
* cell instance $89 r0 *1 1189.76,0
X$89 1 50 49 47 379 44 44 1 1 1 gf180mcu_fd_io__fillnc
* cell instance $90 r0 *1 1189.86,0
X$90 1 50 49 47 379 44 44 1 1 1 gf180mcu_fd_io__fillnc
* cell instance $91 r0 *1 1189.96,0
X$91 1 50 49 47 379 44 44 1 1 1 gf180mcu_fd_io__fillnc
* cell instance $92 r0 *1 1190.06,0
X$92 1 50 49 47 379 44 44 1 1 1 gf180mcu_fd_io__fillnc
* cell instance $93 r0 *1 1190.16,0
X$93 49 47 50 1 2 367 367 44 44 379 gf180mcu_fd_io__in_s
* cell instance $94 r0 *1 1265.16,0
X$94 379 367 357 1 50 49 47 gf180mcu_fd_io__fill10
* cell instance $95 r0 *1 1275.16,0
X$95 379 357 356 1 50 49 47 gf180mcu_fd_io__fill10
* cell instance $96 r0 *1 1285.16,0
X$96 379 356 355 1 50 49 47 gf180mcu_fd_io__fill10
* cell instance $97 r0 *1 1295.16,0
X$97 379 355 309 1 50 49 47 gf180mcu_fd_io__fill10
* cell instance $98 r0 *1 1305.16,0
X$98 379 309 320 1 50 49 47 gf180mcu_fd_io__fill10
* cell instance $99 r0 *1 1315.16,0
X$99 379 320 308 1 50 49 47 gf180mcu_fd_io__fill10
* cell instance $100 r0 *1 1325.16,0
X$100 379 308 307 1 50 49 47 gf180mcu_fd_io__fill10
* cell instance $101 r0 *1 1335.16,0
X$101 379 307 306 1 50 49 47 gf180mcu_fd_io__fill10
* cell instance $102 r0 *1 1345.16,0
X$102 379 306 305 1 50 49 47 gf180mcu_fd_io__fill10
* cell instance $103 r0 *1 1355.16,0
X$103 379 305 304 1 50 49 47 gf180mcu_fd_io__fill10
* cell instance $104 r0 *1 1365.16,0
X$104 379 304 303 1 50 49 47 gf180mcu_fd_io__fill10
* cell instance $105 r0 *1 1375.16,0
X$105 379 303 302 1 50 49 47 gf180mcu_fd_io__fill10
* cell instance $106 r0 *1 1385.16,0
X$106 379 302 301 1 50 49 47 gf180mcu_fd_io__fill10
* cell instance $107 r0 *1 1395.16,0
X$107 379 301 300 1 50 49 47 gf180mcu_fd_io__fill10
* cell instance $108 r0 *1 1405.16,0
X$108 379 300 45 1 50 49 47 gf180mcu_fd_io__fill10
* cell instance $109 r0 *1 1415.16,0
X$109 1 50 49 47 379 45 45 gf180mcu_fd_io__fill1
* cell instance $110 r0 *1 1416.16,0
X$110 1 50 49 47 379 45 45 gf180mcu_fd_io__fill1
* cell instance $111 r0 *1 1417.16,0
X$111 1 50 49 47 379 45 45 1 1 1 gf180mcu_fd_io__fillnc
* cell instance $112 r0 *1 1417.26,0
X$112 1 50 49 47 379 45 45 1 1 1 gf180mcu_fd_io__fillnc
* cell instance $113 r0 *1 1417.36,0
X$113 1 50 49 47 379 45 45 1 1 1 gf180mcu_fd_io__fillnc
* cell instance $114 r0 *1 1417.46,0
X$114 1 50 49 47 379 45 45 1 1 1 gf180mcu_fd_io__fillnc
* cell instance $115 r0 *1 1417.56,0
X$115 1 50 49 47 379 45 45 1 1 1 gf180mcu_fd_io__fillnc
* cell instance $116 r0 *1 1417.66,0
X$116 49 47 50 1 2 353 353 45 45 379 gf180mcu_fd_io__in_s
* cell instance $117 r0 *1 1492.66,0
X$117 379 353 313 1 50 49 47 gf180mcu_fd_io__fill10
* cell instance $118 r0 *1 1502.66,0
X$118 379 313 326 1 50 49 47 gf180mcu_fd_io__fill10
* cell instance $119 r0 *1 1512.66,0
X$119 379 326 325 1 50 49 47 gf180mcu_fd_io__fill10
* cell instance $120 r0 *1 1522.66,0
X$120 379 325 324 1 50 49 47 gf180mcu_fd_io__fill10
* cell instance $121 r0 *1 1532.66,0
X$121 379 324 323 1 50 49 47 gf180mcu_fd_io__fill10
* cell instance $122 r0 *1 1542.66,0
X$122 379 323 322 1 50 49 47 gf180mcu_fd_io__fill10
* cell instance $123 r0 *1 1552.66,0
X$123 379 322 321 1 50 49 47 gf180mcu_fd_io__fill10
* cell instance $124 r0 *1 1562.66,0
X$124 379 321 331 1 50 49 47 gf180mcu_fd_io__fill10
* cell instance $125 r0 *1 1572.66,0
X$125 379 331 319 1 50 49 47 gf180mcu_fd_io__fill10
* cell instance $126 r0 *1 1582.66,0
X$126 379 319 312 1 50 49 47 gf180mcu_fd_io__fill10
* cell instance $127 r0 *1 1592.66,0
X$127 379 312 311 1 50 49 47 gf180mcu_fd_io__fill10
* cell instance $128 r0 *1 1602.66,0
X$128 379 311 332 1 50 49 47 gf180mcu_fd_io__fill10
* cell instance $129 r0 *1 1612.66,0
X$129 379 332 354 1 50 49 47 gf180mcu_fd_io__fill10
* cell instance $130 r0 *1 1622.66,0
X$130 379 354 299 1 50 49 47 gf180mcu_fd_io__fill10
* cell instance $131 r0 *1 1632.66,0
X$131 379 299 41 1 50 49 47 gf180mcu_fd_io__fill10
* cell instance $132 r0 *1 1642.66,0
X$132 1 50 49 47 379 41 41 gf180mcu_fd_io__fill1
* cell instance $133 r0 *1 1643.66,0
X$133 1 50 49 47 379 41 41 gf180mcu_fd_io__fill1
* cell instance $134 r0 *1 1644.66,0
X$134 1 50 49 47 379 41 41 1 1 1 gf180mcu_fd_io__fillnc
* cell instance $135 r0 *1 1644.76,0
X$135 1 50 49 47 379 41 41 1 1 1 gf180mcu_fd_io__fillnc
* cell instance $136 r0 *1 1644.86,0
X$136 1 50 49 47 379 41 41 1 1 1 gf180mcu_fd_io__fillnc
* cell instance $137 r0 *1 1644.96,0
X$137 1 50 49 47 379 41 41 1 1 1 gf180mcu_fd_io__fillnc
* cell instance $138 r0 *1 1645.06,0
X$138 1 50 49 47 379 41 41 1 1 1 gf180mcu_fd_io__fillnc
* cell instance $139 r90 *1 2000.16,0
X$139 49 50 47 1 2 379 gf180mcu_fd_io__cor
* cell instance $140 r270 *1 0,365.16
X$140 38 94 93 1 40 1 39 gf180mcu_fd_io__fill10
* cell instance $141 r270 *1 0,375.16
X$141 38 95 94 1 40 1 39 gf180mcu_fd_io__fill10
* cell instance $142 r270 *1 0,385.16
X$142 38 75 95 1 40 1 39 gf180mcu_fd_io__fill10
* cell instance $143 r270 *1 0,395.16
X$143 38 52 75 1 40 1 39 gf180mcu_fd_io__fill10
* cell instance $144 r270 *1 0,405.16
X$144 38 53 52 1 40 1 39 gf180mcu_fd_io__fill10
* cell instance $145 r270 *1 0,415.16
X$145 38 54 53 1 40 1 39 gf180mcu_fd_io__fill10
* cell instance $146 r270 *1 0,425.16
X$146 38 55 54 1 40 1 39 gf180mcu_fd_io__fill10
* cell instance $147 r270 *1 0,435.16
X$147 38 219 55 1 40 1 39 gf180mcu_fd_io__fill10
* cell instance $148 r270 *1 0,445.16
X$148 38 15 219 1 40 1 39 gf180mcu_fd_io__fill10
* cell instance $149 r270 *1 0,450.16
X$149 38 26 15 1 40 1 39 gf180mcu_fd_io__fill5
* cell instance $150 r270 *1 0,450.26
X$150 1 40 1 39 38 26 26 1 1 1 gf180mcu_fd_io__fillnc
* cell instance $151 r270 *1 0,450.36
X$151 1 40 1 39 38 26 26 1 1 1 gf180mcu_fd_io__fillnc
* cell instance $152 r270 *1 0,535.86
X$152 38 60 56 1 40 1 39 gf180mcu_fd_io__fill10
* cell instance $153 r270 *1 0,525.86
X$153 1 40 39 2 26 26 56 56 38 gf180mcu_fd_io__dvss
* cell instance $154 r270 *1 0,545.86
X$154 38 99 60 1 40 1 39 gf180mcu_fd_io__fill10
* cell instance $155 r270 *1 0,555.86
X$155 38 96 99 1 40 1 39 gf180mcu_fd_io__fill10
* cell instance $156 r270 *1 0,565.86
X$156 38 97 96 1 40 1 39 gf180mcu_fd_io__fill10
* cell instance $157 r270 *1 0,575.86
X$157 38 83 97 1 40 1 39 gf180mcu_fd_io__fill10
* cell instance $158 r270 *1 0,585.86
X$158 38 87 83 1 40 1 39 gf180mcu_fd_io__fill10
* cell instance $159 r270 *1 0,595.86
X$159 38 230 87 1 40 1 39 gf180mcu_fd_io__fill10
* cell instance $160 r270 *1 0,605.86
X$160 38 90 230 1 40 1 39 gf180mcu_fd_io__fill10
* cell instance $161 r270 *1 0,450.86
X$161 1 40 1 39 38 26 26 1 1 1 gf180mcu_fd_io__fillnc
* cell instance $162 r270 *1 0,615.86
X$162 38 231 90 1 40 1 39 gf180mcu_fd_io__fill10
* cell instance $163 r270 *1 0,620.86
X$163 38 23 231 1 40 1 39 gf180mcu_fd_io__fill5
* cell instance $164 r270 *1 0,620.96
X$164 1 40 1 39 38 23 23 1 1 1 gf180mcu_fd_io__fillnc
* cell instance $165 r270 *1 0,621.06
X$165 1 40 1 39 38 23 23 1 1 1 gf180mcu_fd_io__fillnc
* cell instance $166 r270 *1 0,621.16
X$166 1 40 1 39 38 23 23 1 1 1 gf180mcu_fd_io__fillnc
* cell instance $167 r270 *1 0,621.26
X$167 1 40 1 39 38 23 23 1 1 1 gf180mcu_fd_io__fillnc
* cell instance $168 r270 *1 0,696.56
X$168 1 39 40 1 2 23 23 92 92 38 gf180mcu_fd_io__in_s
* cell instance $169 r270 *1 0,621.36
X$169 1 40 1 39 38 23 23 1 1 1 gf180mcu_fd_io__fillnc
* cell instance $170 r270 *1 0,621.46
X$170 1 40 1 39 38 23 23 1 1 1 gf180mcu_fd_io__fillnc
* cell instance $171 r270 *1 0,450.46
X$171 1 40 1 39 38 26 26 1 1 1 gf180mcu_fd_io__fillnc
* cell instance $172 r270 *1 0,450.56
X$172 1 40 1 39 38 26 26 1 1 1 gf180mcu_fd_io__fillnc
* cell instance $173 r270 *1 0,450.66
X$173 1 40 1 39 38 26 26 1 1 1 gf180mcu_fd_io__fillnc
* cell instance $174 r270 *1 0,450.76
X$174 1 40 1 39 38 26 26 1 1 1 gf180mcu_fd_io__fillnc
* cell instance $175 r270 *1 0,706.56
X$175 38 240 92 1 40 1 39 gf180mcu_fd_io__fill10
* cell instance $176 r270 *1 0,792.06
X$176 1 40 1 39 38 24 24 1 1 1 gf180mcu_fd_io__fillnc
* cell instance $177 r270 *1 0,867.16
X$177 1 39 40 1 2 24 24 66 66 38 gf180mcu_fd_io__in_s
* cell instance $178 r270 *1 0,792.16
X$178 1 40 1 39 38 24 24 1 1 1 gf180mcu_fd_io__fillnc
* cell instance $179 r270 *1 0,877.16
X$179 38 67 66 1 40 1 39 gf180mcu_fd_io__fill10
* cell instance $180 r270 *1 0,887.16
X$180 38 68 67 1 40 1 39 gf180mcu_fd_io__fill10
* cell instance $181 r270 *1 0,897.16
X$181 38 76 68 1 40 1 39 gf180mcu_fd_io__fill10
* cell instance $182 r270 *1 0,907.16
X$182 38 69 76 1 40 1 39 gf180mcu_fd_io__fill10
* cell instance $183 r270 *1 0,917.16
X$183 38 228 69 1 40 1 39 gf180mcu_fd_io__fill10
* cell instance $184 r270 *1 0,927.16
X$184 38 70 228 1 40 1 39 gf180mcu_fd_io__fill10
* cell instance $185 r270 *1 0,791.96
X$185 1 40 1 39 38 24 24 1 1 1 gf180mcu_fd_io__fillnc
* cell instance $186 r270 *1 0,937.16
X$186 38 71 70 1 40 1 39 gf180mcu_fd_io__fill10
* cell instance $187 r270 *1 0,947.16
X$187 38 72 71 1 40 1 39 gf180mcu_fd_io__fill10
* cell instance $188 r270 *1 0,957.16
X$188 38 16 72 1 40 1 39 gf180mcu_fd_io__fill10
* cell instance $189 r270 *1 0,962.16
X$189 38 25 16 1 40 1 39 gf180mcu_fd_io__fill5
* cell instance $190 r270 *1 0,962.26
X$190 1 40 1 39 38 25 25 1 1 1 gf180mcu_fd_io__fillnc
* cell instance $191 r270 *1 0,962.66
X$191 1 40 1 39 38 25 25 1 1 1 gf180mcu_fd_io__fillnc
* cell instance $192 r270 *1 0,1037.76
X$192 1 39 40 1 2 25 25 62 62 38 gf180mcu_fd_io__in_s
* cell instance $193 r270 *1 0,962.36
X$193 1 40 1 39 38 25 25 1 1 1 gf180mcu_fd_io__fillnc
* cell instance $194 r270 *1 0,962.46
X$194 1 40 1 39 38 25 25 1 1 1 gf180mcu_fd_io__fillnc
* cell instance $195 r270 *1 0,962.56
X$195 1 40 1 39 38 25 25 1 1 1 gf180mcu_fd_io__fillnc
* cell instance $196 r270 *1 0,791.86
X$196 1 40 1 39 38 24 24 1 1 1 gf180mcu_fd_io__fillnc
* cell instance $197 r270 *1 0,791.76
X$197 1 40 1 39 38 24 24 1 1 1 gf180mcu_fd_io__fillnc
* cell instance $198 r270 *1 0,791.66
X$198 1 40 1 39 38 24 24 1 1 1 gf180mcu_fd_io__fillnc
* cell instance $199 r270 *1 0,791.56
X$199 38 24 233 1 40 1 39 gf180mcu_fd_io__fill5
* cell instance $200 r270 *1 0,786.56
X$200 38 233 232 1 40 1 39 gf180mcu_fd_io__fill10
* cell instance $201 r270 *1 0,776.56
X$201 38 232 234 1 40 1 39 gf180mcu_fd_io__fill10
* cell instance $202 r270 *1 0,766.56
X$202 38 234 235 1 40 1 39 gf180mcu_fd_io__fill10
* cell instance $203 r270 *1 0,756.56
X$203 38 235 236 1 40 1 39 gf180mcu_fd_io__fill10
* cell instance $204 r270 *1 0,746.56
X$204 38 236 237 1 40 1 39 gf180mcu_fd_io__fill10
* cell instance $205 r270 *1 0,736.56
X$205 38 237 238 1 40 1 39 gf180mcu_fd_io__fill10
* cell instance $206 r270 *1 0,726.56
X$206 38 238 239 1 40 1 39 gf180mcu_fd_io__fill10
* cell instance $207 r270 *1 0,716.56
X$207 38 239 240 1 40 1 39 gf180mcu_fd_io__fill10
* cell instance $208 r270 *1 0,962.76
X$208 1 40 1 39 38 25 25 1 1 1 gf180mcu_fd_io__fillnc
* cell instance $209 r270 *1 0,621.56
X$209 1 40 1 39 38 23 23 1 1 1 gf180mcu_fd_io__fillnc
* cell instance $210 r90 *1 2000,355.16
X$210 378 277 280 1 46 48 46 gf180mcu_fd_io__fill10
* cell instance $211 r90 *1 2000,450.16
X$211 1 46 48 46 378 32 32 1 1 1 gf180mcu_fd_io__fillnc
* cell instance $212 r90 *1 2000,445.16
X$212 378 210 32 1 46 48 46 gf180mcu_fd_io__fill5
* cell instance $213 r90 *1 2000,450.26
X$213 1 46 48 46 378 32 32 1 1 1 gf180mcu_fd_io__fillnc
* cell instance $214 r90 *1 2000,435.16
X$214 378 287 210 1 46 48 46 gf180mcu_fd_io__fill10
* cell instance $215 r90 *1 2000,415.16
X$215 378 286 209 1 46 48 46 gf180mcu_fd_io__fill10
* cell instance $216 r90 *1 2000,425.16
X$216 378 209 287 1 46 48 46 gf180mcu_fd_io__fill10
* cell instance $217 r90 *1 2000,405.16
X$217 378 198 286 1 46 48 46 gf180mcu_fd_io__fill10
* cell instance $218 r90 *1 2000,395.16
X$218 378 197 198 1 46 48 46 gf180mcu_fd_io__fill10
* cell instance $219 r90 *1 2000,385.16
X$219 378 261 197 1 46 48 46 gf180mcu_fd_io__fill10
* cell instance $220 r90 *1 2000,375.16
X$220 378 208 261 1 46 48 46 gf180mcu_fd_io__fill10
* cell instance $221 r90 *1 2000,365.16
X$221 378 280 208 1 46 48 46 gf180mcu_fd_io__fill10
* cell instance $222 r90 *1 2000,450.36
X$222 1 46 48 46 378 32 32 1 1 1 gf180mcu_fd_io__fillnc
* cell instance $223 r90 *1 2000,696.56
X$223 378 273 203 1 46 48 46 gf180mcu_fd_io__fill10
* cell instance $224 r90 *1 2000,621.56
X$224 48 46 46 1 2 273 273 33 33 378 gf180mcu_fd_io__in_s
* cell instance $225 r90 *1 2000,706.56
X$225 378 203 260 1 46 48 46 gf180mcu_fd_io__fill10
* cell instance $226 r90 *1 2000,621.46
X$226 1 46 48 46 378 33 33 1 1 1 gf180mcu_fd_io__fillnc
* cell instance $227 r90 *1 2000,621.36
X$227 1 46 48 46 378 33 33 1 1 1 gf180mcu_fd_io__fillnc
* cell instance $228 r90 *1 2000,621.26
X$228 1 46 48 46 378 33 33 1 1 1 gf180mcu_fd_io__fillnc
* cell instance $229 r90 *1 2000,620.86
X$229 1 46 48 46 378 33 33 1 1 1 gf180mcu_fd_io__fillnc
* cell instance $230 r90 *1 2000,621.16
X$230 1 46 48 46 378 33 33 1 1 1 gf180mcu_fd_io__fillnc
* cell instance $231 r90 *1 2000,621.06
X$231 1 46 48 46 378 33 33 1 1 1 gf180mcu_fd_io__fillnc
* cell instance $232 r90 *1 2000,620.96
X$232 1 46 48 46 378 33 33 1 1 1 gf180mcu_fd_io__fillnc
* cell instance $233 r90 *1 2000,615.86
X$233 378 217 33 1 46 48 46 gf180mcu_fd_io__fill5
* cell instance $234 r90 *1 2000,605.86
X$234 378 216 217 1 46 48 46 gf180mcu_fd_io__fill10
* cell instance $235 r90 *1 2000,595.86
X$235 378 215 216 1 46 48 46 gf180mcu_fd_io__fill10
* cell instance $236 r90 *1 2000,585.86
X$236 378 214 215 1 46 48 46 gf180mcu_fd_io__fill10
* cell instance $237 r90 *1 2000,575.86
X$237 378 213 214 1 46 48 46 gf180mcu_fd_io__fill10
* cell instance $238 r90 *1 2000,565.86
X$238 378 212 213 1 46 48 46 gf180mcu_fd_io__fill10
* cell instance $239 r90 *1 2000,555.86
X$239 378 211 212 1 46 48 46 gf180mcu_fd_io__fill10
* cell instance $240 r90 *1 2000,525.86
X$240 378 278 204 1 46 48 46 gf180mcu_fd_io__fill10
* cell instance $241 r90 *1 2000,450.86
X$241 46 48 1 2 32 32 278 278 378 gf180mcu_fd_io__dvdd
* cell instance $242 r90 *1 2000,535.86
X$242 378 204 288 1 46 48 46 gf180mcu_fd_io__fill10
* cell instance $243 r90 *1 2000,545.86
X$243 378 288 211 1 46 48 46 gf180mcu_fd_io__fill10
* cell instance $244 r90 *1 2000,450.46
X$244 1 46 48 46 378 32 32 1 1 1 gf180mcu_fd_io__fillnc
* cell instance $245 r90 *1 2000,450.56
X$245 1 46 48 46 378 32 32 1 1 1 gf180mcu_fd_io__fillnc
* cell instance $246 r90 *1 2000,450.66
X$246 1 46 48 46 378 32 32 1 1 1 gf180mcu_fd_io__fillnc
* cell instance $247 r90 *1 2000,450.76
X$247 1 46 48 46 378 32 32 1 1 1 gf180mcu_fd_io__fillnc
* cell instance $248 r90 *1 2000,716.56
X$248 378 260 196 1 46 48 46 gf180mcu_fd_io__fill10
* cell instance $249 r90 *1 2000,962.66
X$249 1 46 48 46 378 37 37 1 1 1 gf180mcu_fd_io__fillnc
* cell instance $250 r90 *1 2000,962.76
X$250 48 46 46 1 2 254 254 37 37 378 gf180mcu_fd_io__in_s
* cell instance $251 r90 *1 2000,962.36
X$251 1 46 48 46 378 37 37 1 1 1 gf180mcu_fd_io__fillnc
* cell instance $252 r90 *1 2000,962.16
X$252 1 46 48 46 378 37 37 1 1 1 gf180mcu_fd_io__fillnc
* cell instance $253 r90 *1 2000,957.16
X$253 378 205 37 1 46 48 46 gf180mcu_fd_io__fill5
* cell instance $254 r90 *1 2000,962.46
X$254 1 46 48 46 378 37 37 1 1 1 gf180mcu_fd_io__fillnc
* cell instance $255 r90 *1 2000,947.16
X$255 378 206 205 1 46 48 46 gf180mcu_fd_io__fill10
* cell instance $256 r90 *1 2000,937.16
X$256 378 207 206 1 46 48 46 gf180mcu_fd_io__fill10
* cell instance $257 r90 *1 2000,927.16
X$257 378 279 207 1 46 48 46 gf180mcu_fd_io__fill10
* cell instance $258 r90 *1 2000,917.16
X$258 378 185 279 1 46 48 46 gf180mcu_fd_io__fill10
* cell instance $259 r90 *1 2000,962.26
X$259 1 46 48 46 378 37 37 1 1 1 gf180mcu_fd_io__fillnc
* cell instance $260 r90 *1 2000,962.56
X$260 1 46 48 46 378 37 37 1 1 1 gf180mcu_fd_io__fillnc
* cell instance $261 r90 *1 2000,867.16
X$261 378 253 252 1 46 48 46 gf180mcu_fd_io__fill10
* cell instance $262 r90 *1 2000,792.16
X$262 48 46 46 1 2 253 253 30 30 378 gf180mcu_fd_io__in_s
* cell instance $263 r90 *1 2000,877.16
X$263 378 252 187 1 46 48 46 gf180mcu_fd_io__fill10
* cell instance $264 r90 *1 2000,887.16
X$264 378 187 186 1 46 48 46 gf180mcu_fd_io__fill10
* cell instance $265 r90 *1 2000,897.16
X$265 378 186 251 1 46 48 46 gf180mcu_fd_io__fill10
* cell instance $266 r90 *1 2000,792.06
X$266 1 46 48 46 378 30 30 1 1 1 gf180mcu_fd_io__fillnc
* cell instance $267 r90 *1 2000,907.16
X$267 378 251 185 1 46 48 46 gf180mcu_fd_io__fill10
* cell instance $268 r90 *1 2000,791.86
X$268 1 46 48 46 378 30 30 1 1 1 gf180mcu_fd_io__fillnc
* cell instance $269 r90 *1 2000,791.76
X$269 1 46 48 46 378 30 30 1 1 1 gf180mcu_fd_io__fillnc
* cell instance $270 r90 *1 2000,791.66
X$270 1 46 48 46 378 30 30 1 1 1 gf180mcu_fd_io__fillnc
* cell instance $271 r90 *1 2000,791.56
X$271 1 46 48 46 378 30 30 1 1 1 gf180mcu_fd_io__fillnc
* cell instance $272 r90 *1 2000,786.56
X$272 378 9 30 1 46 48 46 gf180mcu_fd_io__fill5
* cell instance $273 r90 *1 2000,776.56
X$273 378 191 9 1 46 48 46 gf180mcu_fd_io__fill10
* cell instance $274 r90 *1 2000,791.96
X$274 1 46 48 46 378 30 30 1 1 1 gf180mcu_fd_io__fillnc
* cell instance $275 r90 *1 2000,766.56
X$275 378 192 191 1 46 48 46 gf180mcu_fd_io__fill10
* cell instance $276 r90 *1 2000,756.56
X$276 378 193 192 1 46 48 46 gf180mcu_fd_io__fill10
* cell instance $277 r90 *1 2000,746.56
X$277 378 194 193 1 46 48 46 gf180mcu_fd_io__fill10
* cell instance $278 r90 *1 2000,736.56
X$278 378 195 194 1 46 48 46 gf180mcu_fd_io__fill10
* cell instance $279 r90 *1 2000,726.56
X$279 378 196 195 1 46 48 46 gf180mcu_fd_io__fill10
* cell instance $280 r270 *1 0,1047.76
X$280 38 63 62 1 40 1 39 gf180mcu_fd_io__fill10
* cell instance $281 r270 *1 0,1057.76
X$281 38 64 63 1 40 1 39 gf180mcu_fd_io__fill10
* cell instance $282 r270 *1 0,1077.76
X$282 38 221 225 1 40 1 39 gf180mcu_fd_io__fill10
* cell instance $283 r270 *1 0,1087.76
X$283 38 79 221 1 40 1 39 gf180mcu_fd_io__fill10
* cell instance $284 r270 *1 0,1067.76
X$284 38 225 64 1 40 1 39 gf180mcu_fd_io__fill10
* cell instance $285 r90 *1 2000,1037.76
X$285 378 254 255 1 46 48 46 gf180mcu_fd_io__fill10
* cell instance $286 r90 *1 2000,1047.76
X$286 378 255 188 1 46 48 46 gf180mcu_fd_io__fill10
* cell instance $287 r90 *1 2000,1067.76
X$287 378 189 190 1 46 48 46 gf180mcu_fd_io__fill10
* cell instance $288 r90 *1 2000,1077.76
X$288 378 190 256 1 46 48 46 gf180mcu_fd_io__fill10
* cell instance $289 r90 *1 2000,1057.76
X$289 378 188 189 1 46 48 46 gf180mcu_fd_io__fill10
* cell instance $290 r270 *1 0,1097.76
X$290 38 80 79 1 40 1 39 gf180mcu_fd_io__fill10
* cell instance $291 r270 *1 0,1107.76
X$291 38 81 80 1 40 1 39 gf180mcu_fd_io__fill10
* cell instance $292 r90 *1 2000,1087.76
X$292 378 256 257 1 46 48 46 gf180mcu_fd_io__fill10
* cell instance $293 r90 *1 2000,1097.76
X$293 378 257 258 1 46 48 46 gf180mcu_fd_io__fill10
* cell instance $294 r270 *1 0,1117.76
X$294 38 82 81 1 40 1 39 gf180mcu_fd_io__fill10
* cell instance $295 r270 *1 0,1127.76
X$295 38 14 82 1 40 1 39 gf180mcu_fd_io__fill10
* cell instance $296 r90 *1 2000,1107.76
X$296 378 258 259 1 46 48 46 gf180mcu_fd_io__fill10
* cell instance $297 r90 *1 2000,1117.76
X$297 378 259 8 1 46 48 46 gf180mcu_fd_io__fill10
* cell instance $298 r270 *1 0,1132.76
X$298 38 22 14 1 40 1 39 gf180mcu_fd_io__fill5
* cell instance $299 r270 *1 0,1132.86
X$299 1 40 1 39 38 22 22 1 1 1 gf180mcu_fd_io__fillnc
* cell instance $300 r90 *1 2000,1127.76
X$300 378 8 31 1 46 48 46 gf180mcu_fd_io__fill5
* cell instance $301 r90 *1 2000,1132.76
X$301 1 46 48 46 378 31 31 1 1 1 gf180mcu_fd_io__fillnc
* cell instance $302 r270 *1 0,1132.96
X$302 1 40 1 39 38 22 22 1 1 1 gf180mcu_fd_io__fillnc
* cell instance $303 r270 *1 0,1133.06
X$303 1 40 1 39 38 22 22 1 1 1 gf180mcu_fd_io__fillnc
* cell instance $304 r90 *1 2000,1132.86
X$304 1 46 48 46 378 31 31 1 1 1 gf180mcu_fd_io__fillnc
* cell instance $305 r90 *1 2000,1132.96
X$305 1 46 48 46 378 31 31 1 1 1 gf180mcu_fd_io__fillnc
* cell instance $306 r270 *1 0,1208.36
X$306 1 39 40 1 2 22 22 100 100 38 gf180mcu_fd_io__in_s
* cell instance $307 r270 *1 0,1133.16
X$307 1 40 1 39 38 22 22 1 1 1 gf180mcu_fd_io__fillnc
* cell instance $308 r270 *1 0,1133.26
X$308 1 40 1 39 38 22 22 1 1 1 gf180mcu_fd_io__fillnc
* cell instance $309 r270 *1 0,1133.36
X$309 1 40 1 39 38 22 22 1 1 1 gf180mcu_fd_io__fillnc
* cell instance $310 r90 *1 2000,1133.36
X$310 48 46 46 1 2 272 272 31 31 378 gf180mcu_fd_io__in_s
* cell instance $311 r90 *1 2000,1133.06
X$311 1 46 48 46 378 31 31 1 1 1 gf180mcu_fd_io__fillnc
* cell instance $312 r90 *1 2000,1133.16
X$312 1 46 48 46 378 31 31 1 1 1 gf180mcu_fd_io__fillnc
* cell instance $313 r90 *1 2000,1133.26
X$313 1 46 48 46 378 31 31 1 1 1 gf180mcu_fd_io__fillnc
* cell instance $314 r270 *1 0,1218.36
X$314 38 98 100 1 40 1 39 gf180mcu_fd_io__fill10
* cell instance $315 r270 *1 0,1228.36
X$315 38 243 98 1 40 1 39 gf180mcu_fd_io__fill10
* cell instance $316 r270 *1 0,1248.36
X$316 38 241 242 1 40 1 39 gf180mcu_fd_io__fill10
* cell instance $317 r270 *1 0,1258.36
X$317 38 65 241 1 40 1 39 gf180mcu_fd_io__fill10
* cell instance $318 r270 *1 0,1238.36
X$318 38 242 243 1 40 1 39 gf180mcu_fd_io__fill10
* cell instance $319 r90 *1 2000,1208.36
X$319 378 272 199 1 46 48 46 gf180mcu_fd_io__fill10
* cell instance $320 r90 *1 2000,1238.36
X$320 378 201 202 1 46 48 46 gf180mcu_fd_io__fill10
* cell instance $321 r90 *1 2000,1248.36
X$321 378 202 285 1 46 48 46 gf180mcu_fd_io__fill10
* cell instance $322 r90 *1 2000,1228.36
X$322 378 200 201 1 46 48 46 gf180mcu_fd_io__fill10
* cell instance $323 r90 *1 2000,1218.36
X$323 378 199 200 1 46 48 46 gf180mcu_fd_io__fill10
* cell instance $324 r270 *1 0,1268.36
X$324 38 89 65 1 40 1 39 gf180mcu_fd_io__fill10
* cell instance $325 r270 *1 0,1278.36
X$325 38 88 89 1 40 1 39 gf180mcu_fd_io__fill10
* cell instance $326 r90 *1 2000,1258.36
X$326 378 285 274 1 46 48 46 gf180mcu_fd_io__fill10
* cell instance $327 r90 *1 2000,1268.36
X$327 378 274 275 1 46 48 46 gf180mcu_fd_io__fill10
* cell instance $328 r270 *1 0,1288.36
X$328 38 91 88 1 40 1 39 gf180mcu_fd_io__fill10
* cell instance $329 r270 *1 0,1298.36
X$329 38 13 91 1 40 1 39 gf180mcu_fd_io__fill10
* cell instance $330 r90 *1 2000,1278.36
X$330 378 275 276 1 46 48 46 gf180mcu_fd_io__fill10
* cell instance $331 r90 *1 2000,1288.36
X$331 378 276 7 1 46 48 46 gf180mcu_fd_io__fill10
* cell instance $332 r270 *1 0,1303.36
X$332 38 29 13 1 40 1 39 gf180mcu_fd_io__fill5
* cell instance $333 r270 *1 0,1303.46
X$333 1 40 1 39 38 29 29 1 1 1 gf180mcu_fd_io__fillnc
* cell instance $334 r90 *1 2000,1298.36
X$334 378 7 35 1 46 48 46 gf180mcu_fd_io__fill5
* cell instance $335 r90 *1 2000,1303.36
X$335 1 46 48 46 378 35 35 1 1 1 gf180mcu_fd_io__fillnc
* cell instance $336 r270 *1 0,1303.56
X$336 1 40 1 39 38 29 29 1 1 1 gf180mcu_fd_io__fillnc
* cell instance $337 r270 *1 0,1303.66
X$337 1 40 1 39 38 29 29 1 1 1 gf180mcu_fd_io__fillnc
* cell instance $338 r90 *1 2000,1303.46
X$338 1 46 48 46 378 35 35 1 1 1 gf180mcu_fd_io__fillnc
* cell instance $339 r90 *1 2000,1303.56
X$339 1 46 48 46 378 35 35 1 1 1 gf180mcu_fd_io__fillnc
* cell instance $340 r270 *1 0,1378.96
X$340 1 39 40 1 2 29 29 73 73 38 gf180mcu_fd_io__in_s
* cell instance $341 r270 *1 0,1303.76
X$341 1 40 1 39 38 29 29 1 1 1 gf180mcu_fd_io__fillnc
* cell instance $342 r270 *1 0,1303.86
X$342 1 40 1 39 38 29 29 1 1 1 gf180mcu_fd_io__fillnc
* cell instance $343 r270 *1 0,1303.96
X$343 1 40 1 39 38 29 29 1 1 1 gf180mcu_fd_io__fillnc
* cell instance $344 r90 *1 2000,1303.96
X$344 48 46 46 1 2 281 281 35 35 378 gf180mcu_fd_io__in_s
* cell instance $345 r90 *1 2000,1303.66
X$345 1 46 48 46 378 35 35 1 1 1 gf180mcu_fd_io__fillnc
* cell instance $346 r90 *1 2000,1303.76
X$346 1 46 48 46 378 35 35 1 1 1 gf180mcu_fd_io__fillnc
* cell instance $347 r90 *1 2000,1303.86
X$347 1 46 48 46 378 35 35 1 1 1 gf180mcu_fd_io__fillnc
* cell instance $348 r270 *1 0,1388.96
X$348 38 74 73 1 40 1 39 gf180mcu_fd_io__fill10
* cell instance $349 r270 *1 0,1398.96
X$349 38 229 74 1 40 1 39 gf180mcu_fd_io__fill10
* cell instance $350 r270 *1 0,1418.96
X$350 38 220 227 1 40 1 39 gf180mcu_fd_io__fill10
* cell instance $351 r270 *1 0,1428.96
X$351 38 57 220 1 40 1 39 gf180mcu_fd_io__fill10
* cell instance $352 r270 *1 0,1408.96
X$352 38 227 229 1 40 1 39 gf180mcu_fd_io__fill10
* cell instance $353 r90 *1 2000,1378.96
X$353 378 281 282 1 46 48 46 gf180mcu_fd_io__fill10
* cell instance $354 r90 *1 2000,1388.96
X$354 378 282 283 1 46 48 46 gf180mcu_fd_io__fill10
* cell instance $355 r90 *1 2000,1398.96
X$355 378 283 284 1 46 48 46 gf180mcu_fd_io__fill10
* cell instance $356 r90 *1 2000,1408.96
X$356 378 284 247 1 46 48 46 gf180mcu_fd_io__fill10
* cell instance $357 r90 *1 2000,1418.96
X$357 378 247 262 1 46 48 46 gf180mcu_fd_io__fill10
* cell instance $358 r270 *1 0,1438.96
X$358 38 58 57 1 40 1 39 gf180mcu_fd_io__fill10
* cell instance $359 r270 *1 0,1448.96
X$359 38 59 58 1 40 1 39 gf180mcu_fd_io__fill10
* cell instance $360 r90 *1 2000,1428.96
X$360 378 262 248 1 46 48 46 gf180mcu_fd_io__fill10
* cell instance $361 r90 *1 2000,1438.96
X$361 378 248 249 1 46 48 46 gf180mcu_fd_io__fill10
* cell instance $362 r270 *1 0,1458.96
X$362 38 86 59 1 40 1 39 gf180mcu_fd_io__fill10
* cell instance $363 r270 *1 0,1468.96
X$363 38 12 86 1 40 1 39 gf180mcu_fd_io__fill10
* cell instance $364 r90 *1 2000,1448.96
X$364 378 249 250 1 46 48 46 gf180mcu_fd_io__fill10
* cell instance $365 r90 *1 2000,1458.96
X$365 378 250 10 1 46 48 46 gf180mcu_fd_io__fill10
* cell instance $366 r270 *1 0,1473.96
X$366 38 28 12 1 40 1 39 gf180mcu_fd_io__fill5
* cell instance $367 r270 *1 0,1474.06
X$367 1 40 1 39 38 28 28 1 1 1 gf180mcu_fd_io__fillnc
* cell instance $368 r90 *1 2000,1468.96
X$368 378 10 36 1 46 48 46 gf180mcu_fd_io__fill5
* cell instance $369 r90 *1 2000,1473.96
X$369 1 46 48 46 378 36 36 1 1 1 gf180mcu_fd_io__fillnc
* cell instance $370 r270 *1 0,1474.16
X$370 1 40 1 39 38 28 28 1 1 1 gf180mcu_fd_io__fillnc
* cell instance $371 r270 *1 0,1474.26
X$371 1 40 1 39 38 28 28 1 1 1 gf180mcu_fd_io__fillnc
* cell instance $372 r90 *1 2000,1474.06
X$372 1 46 48 46 378 36 36 1 1 1 gf180mcu_fd_io__fillnc
* cell instance $373 r90 *1 2000,1474.16
X$373 1 46 48 46 378 36 36 1 1 1 gf180mcu_fd_io__fillnc
* cell instance $374 r270 *1 0,1549.56
X$374 1 39 40 1 2 28 28 61 61 38 gf180mcu_fd_io__in_s
* cell instance $375 r270 *1 0,1474.36
X$375 1 40 1 39 38 28 28 1 1 1 gf180mcu_fd_io__fillnc
* cell instance $376 r270 *1 0,1474.46
X$376 1 40 1 39 38 28 28 1 1 1 gf180mcu_fd_io__fillnc
* cell instance $377 r270 *1 0,1474.56
X$377 1 40 1 39 38 28 28 1 1 1 gf180mcu_fd_io__fillnc
* cell instance $378 r90 *1 2000,1474.56
X$378 48 46 46 1 2 263 263 36 36 378 gf180mcu_fd_io__in_s
* cell instance $379 r90 *1 2000,1474.26
X$379 1 46 48 46 378 36 36 1 1 1 gf180mcu_fd_io__fillnc
* cell instance $380 r90 *1 2000,1474.36
X$380 1 46 48 46 378 36 36 1 1 1 gf180mcu_fd_io__fillnc
* cell instance $381 r90 *1 2000,1474.46
X$381 1 46 48 46 378 36 36 1 1 1 gf180mcu_fd_io__fillnc
* cell instance $382 r270 *1 0,1559.56
X$382 38 224 61 1 40 1 39 gf180mcu_fd_io__fill10
* cell instance $383 r270 *1 0,1589.56
X$383 38 226 222 1 40 1 39 gf180mcu_fd_io__fill10
* cell instance $384 r270 *1 0,1599.56
X$384 38 85 226 1 40 1 39 gf180mcu_fd_io__fill10
* cell instance $385 r270 *1 0,1579.56
X$385 38 222 223 1 40 1 39 gf180mcu_fd_io__fill10
* cell instance $386 r270 *1 0,1569.56
X$386 38 223 224 1 40 1 39 gf180mcu_fd_io__fill10
* cell instance $387 r90 *1 2000,1549.56
X$387 378 263 264 1 46 48 46 gf180mcu_fd_io__fill10
* cell instance $388 r90 *1 2000,1559.56
X$388 378 264 265 1 46 48 46 gf180mcu_fd_io__fill10
* cell instance $389 r90 *1 2000,1569.56
X$389 378 265 266 1 46 48 46 gf180mcu_fd_io__fill10
* cell instance $390 r90 *1 2000,1579.56
X$390 378 266 267 1 46 48 46 gf180mcu_fd_io__fill10
* cell instance $391 r90 *1 2000,1589.56
X$391 378 267 268 1 46 48 46 gf180mcu_fd_io__fill10
* cell instance $392 r270 *1 0,1609.56
X$392 38 78 85 1 40 1 39 gf180mcu_fd_io__fill10
* cell instance $393 r270 *1 0,1619.56
X$393 38 77 78 1 40 1 39 gf180mcu_fd_io__fill10
* cell instance $394 r90 *1 2000,1599.56
X$394 378 268 269 1 46 48 46 gf180mcu_fd_io__fill10
* cell instance $395 r90 *1 2000,1609.56
X$395 378 269 270 1 46 48 46 gf180mcu_fd_io__fill10
* cell instance $396 r270 *1 0,1629.56
X$396 38 84 77 1 40 1 39 gf180mcu_fd_io__fill10
* cell instance $397 r270 *1 0,1639.56
X$397 38 17 84 1 40 1 39 gf180mcu_fd_io__fill10
* cell instance $398 r90 *1 2000,1619.56
X$398 378 270 271 1 46 48 46 gf180mcu_fd_io__fill10
* cell instance $399 r90 *1 2000,1629.56
X$399 378 271 11 1 46 48 46 gf180mcu_fd_io__fill10
* cell instance $400 r270 *1 0,1644.56
X$400 38 27 17 1 40 1 39 gf180mcu_fd_io__fill5
* cell instance $401 r270 *1 0,1644.66
X$401 1 40 1 39 38 27 27 1 1 1 gf180mcu_fd_io__fillnc
* cell instance $402 r90 *1 2000,1639.56
X$402 378 11 34 1 46 48 46 gf180mcu_fd_io__fill5
* cell instance $403 r90 *1 2000,1644.56
X$403 1 46 48 46 378 34 34 1 1 1 gf180mcu_fd_io__fillnc
* cell instance $404 r270 *1 0,1644.76
X$404 1 40 1 39 38 27 27 1 1 1 gf180mcu_fd_io__fillnc
* cell instance $405 r270 *1 0,1644.86
X$405 1 40 1 39 38 27 27 1 1 1 gf180mcu_fd_io__fillnc
* cell instance $406 r90 *1 2000,1644.66
X$406 1 46 48 46 378 34 34 1 1 1 gf180mcu_fd_io__fillnc
* cell instance $407 r90 *1 2000,1644.76
X$407 1 46 48 46 378 34 34 1 1 1 gf180mcu_fd_io__fillnc
* cell instance $408 r270 *1 0,1644.96
X$408 1 40 1 39 38 27 27 1 1 1 gf180mcu_fd_io__fillnc
* cell instance $409 r270 *1 0,1645.06
X$409 1 40 1 39 38 27 27 1 1 1 gf180mcu_fd_io__fillnc
* cell instance $410 r270 *1 0,1645.16
X$410 1 40 1 39 38 27 27 1 1 1 gf180mcu_fd_io__fillnc
* cell instance $411 r270 *1 0,2000.16
X$411 1 40 39 1 2 38 gf180mcu_fd_io__cor
* cell instance $412 r90 *1 2000,1644.86
X$412 1 46 48 46 378 34 34 1 1 1 gf180mcu_fd_io__fillnc
* cell instance $413 r90 *1 2000,1644.96
X$413 1 46 48 46 378 34 34 1 1 1 gf180mcu_fd_io__fillnc
* cell instance $414 r180 *1 2000.16,2000.16
X$414 48 46 46 1 2 378 gf180mcu_fd_io__cor
* cell instance $415 r90 *1 2000,1645.06
X$415 1 46 48 46 378 34 34 1 1 1 gf180mcu_fd_io__fillnc
* cell instance $416 r180 *1 365.16,2000
X$416 378 151 101 1 46 48 46 gf180mcu_fd_io__fill10
* cell instance $417 r180 *1 375.16,2000
X$417 378 162 151 1 46 48 46 gf180mcu_fd_io__fill10
* cell instance $418 r180 *1 385.16,2000
X$418 378 153 162 1 46 48 46 gf180mcu_fd_io__fill10
* cell instance $419 r180 *1 395.16,2000
X$419 378 154 153 1 46 48 46 gf180mcu_fd_io__fill10
* cell instance $420 r180 *1 405.16,2000
X$420 378 155 154 1 46 48 46 gf180mcu_fd_io__fill10
* cell instance $421 r180 *1 415.16,2000
X$421 378 156 155 1 46 48 46 gf180mcu_fd_io__fill10
* cell instance $422 r180 *1 425.16,2000
X$422 378 157 156 1 46 48 46 gf180mcu_fd_io__fill10
* cell instance $423 r180 *1 435.16,2000
X$423 378 158 157 1 46 48 46 gf180mcu_fd_io__fill10
* cell instance $424 r180 *1 445.16,2000
X$424 378 159 158 1 46 48 46 gf180mcu_fd_io__fill10
* cell instance $425 r180 *1 455.16,2000
X$425 378 160 159 1 46 48 46 gf180mcu_fd_io__fill10
* cell instance $426 r180 *1 465.16,2000
X$426 378 161 160 1 46 48 46 gf180mcu_fd_io__fill10
* cell instance $427 r180 *1 475.16,2000
X$427 378 245 161 1 46 48 46 gf180mcu_fd_io__fill10
* cell instance $428 r180 *1 550.16,2000
X$428 48 46 46 1 2 164 164 245 245 378 gf180mcu_fd_io__in_c
* cell instance $429 r180 *1 560.16,2000
X$429 378 165 164 1 46 48 46 gf180mcu_fd_io__fill10
* cell instance $430 r180 *1 570.16,2000
X$430 378 166 165 1 46 48 46 gf180mcu_fd_io__fill10
* cell instance $431 r180 *1 580.16,2000
X$431 378 167 166 1 46 48 46 gf180mcu_fd_io__fill10
* cell instance $432 r180 *1 590.16,2000
X$432 378 168 167 1 46 48 46 gf180mcu_fd_io__fill10
* cell instance $433 r180 *1 600.16,2000
X$433 378 169 168 1 46 48 46 gf180mcu_fd_io__fill10
* cell instance $434 r180 *1 610.16,2000
X$434 378 170 169 1 46 48 46 gf180mcu_fd_io__fill10
* cell instance $435 r180 *1 620.16,2000
X$435 378 171 170 1 46 48 46 gf180mcu_fd_io__fill10
* cell instance $436 r180 *1 630.16,2000
X$436 378 183 171 1 46 48 46 gf180mcu_fd_io__fill10
* cell instance $437 r180 *1 640.16,2000
X$437 378 173 183 1 46 48 46 gf180mcu_fd_io__fill10
* cell instance $438 r180 *1 650.16,2000
X$438 378 174 173 1 46 48 46 gf180mcu_fd_io__fill10
* cell instance $439 r180 *1 660.16,2000
X$439 378 175 174 1 46 48 46 gf180mcu_fd_io__fill10
* cell instance $440 r180 *1 670.16,2000
X$440 378 246 175 1 46 48 46 gf180mcu_fd_io__fill10
* cell instance $441 r180 *1 745.16,2000
X$441 48 46 46 1 2 176 176 246 246 378 gf180mcu_fd_io__bi_t
* cell instance $442 r180 *1 755.16,2000
X$442 378 177 176 1 46 48 46 gf180mcu_fd_io__fill10
* cell instance $443 r180 *1 765.16,2000
X$443 378 178 177 1 46 48 46 gf180mcu_fd_io__fill10
* cell instance $444 r180 *1 775.16,2000
X$444 378 179 178 1 46 48 46 gf180mcu_fd_io__fill10
* cell instance $445 r180 *1 785.16,2000
X$445 378 180 179 1 46 48 46 gf180mcu_fd_io__fill10
* cell instance $446 r180 *1 795.16,2000
X$446 378 181 180 1 46 48 46 gf180mcu_fd_io__fill10
* cell instance $447 r180 *1 805.16,2000
X$447 378 182 181 1 46 48 46 gf180mcu_fd_io__fill10
* cell instance $448 r180 *1 815.16,2000
X$448 378 172 182 1 46 48 46 gf180mcu_fd_io__fill10
* cell instance $449 r180 *1 825.16,2000
X$449 378 111 172 1 46 48 46 gf180mcu_fd_io__fill10
* cell instance $450 r180 *1 835.16,2000
X$450 378 143 111 1 46 48 46 gf180mcu_fd_io__fill10
* cell instance $451 r180 *1 845.16,2000
X$451 378 144 143 1 46 48 46 gf180mcu_fd_io__fill10
* cell instance $452 r180 *1 855.16,2000
X$452 378 145 144 1 46 48 46 gf180mcu_fd_io__fill10
* cell instance $453 r180 *1 865.16,2000
X$453 378 3 145 1 46 48 46 gf180mcu_fd_io__fill10
* cell instance $454 r180 *1 940.16,2000
X$454 48 46 46 1 2 146 146 3 3 378 gf180mcu_fd_io__bi_t
* cell instance $455 r180 *1 950.16,2000
X$455 378 147 146 1 46 48 46 gf180mcu_fd_io__fill10
* cell instance $456 r180 *1 960.16,2000
X$456 378 148 147 1 46 48 46 gf180mcu_fd_io__fill10
* cell instance $457 r180 *1 970.16,2000
X$457 378 149 148 1 46 48 46 gf180mcu_fd_io__fill10
* cell instance $458 r180 *1 980.16,2000
X$458 378 150 149 1 46 48 46 gf180mcu_fd_io__fill10
* cell instance $459 r180 *1 990.16,2000
X$459 378 184 150 1 46 48 46 gf180mcu_fd_io__fill10
* cell instance $460 r180 *1 1000.16,2000
X$460 378 122 184 1 46 48 46 gf180mcu_fd_io__fill10
* cell instance $461 r180 *1 1010.16,2000
X$461 378 106 122 1 46 48 46 gf180mcu_fd_io__fill10
* cell instance $462 r180 *1 1020.16,2000
X$462 378 163 106 1 46 48 46 gf180mcu_fd_io__fill10
* cell instance $463 r180 *1 1030.16,2000
X$463 378 135 163 1 46 48 46 gf180mcu_fd_io__fill10
* cell instance $464 r180 *1 1040.16,2000
X$464 378 136 135 1 46 48 46 gf180mcu_fd_io__fill10
* cell instance $465 r180 *1 1050.16,2000
X$465 378 137 136 1 46 48 46 gf180mcu_fd_io__fill10
* cell instance $466 r180 *1 1060.16,2000
X$466 378 6 137 1 46 48 46 gf180mcu_fd_io__fill10
* cell instance $467 r180 *1 1135.16,2000
X$467 48 46 46 1 2 138 138 6 6 378 gf180mcu_fd_io__bi_t
* cell instance $468 r180 *1 1145.16,2000
X$468 378 139 138 1 46 48 46 gf180mcu_fd_io__fill10
* cell instance $469 r180 *1 1155.16,2000
X$469 378 140 139 1 46 48 46 gf180mcu_fd_io__fill10
* cell instance $470 r180 *1 1165.16,2000
X$470 378 141 140 1 46 48 46 gf180mcu_fd_io__fill10
* cell instance $471 r180 *1 1175.16,2000
X$471 378 131 141 1 46 48 46 gf180mcu_fd_io__fill10
* cell instance $472 r180 *1 1185.16,2000
X$472 378 102 131 1 46 48 46 gf180mcu_fd_io__fill10
* cell instance $473 r180 *1 1195.16,2000
X$473 378 103 102 1 46 48 46 gf180mcu_fd_io__fill10
* cell instance $474 r180 *1 1205.16,2000
X$474 378 104 103 1 46 48 46 gf180mcu_fd_io__fill10
* cell instance $475 r180 *1 1215.16,2000
X$475 378 105 104 1 46 48 46 gf180mcu_fd_io__fill10
* cell instance $476 r180 *1 1225.16,2000
X$476 378 107 105 1 46 48 46 gf180mcu_fd_io__fill10
* cell instance $477 r180 *1 1235.16,2000
X$477 378 108 107 1 46 48 46 gf180mcu_fd_io__fill10
* cell instance $478 r180 *1 1245.16,2000
X$478 378 109 108 1 46 48 46 gf180mcu_fd_io__fill10
* cell instance $479 r180 *1 1255.16,2000
X$479 378 5 109 1 46 48 46 gf180mcu_fd_io__fill10
* cell instance $480 r180 *1 1330.16,2000
X$480 48 46 46 1 2 110 110 5 5 378 gf180mcu_fd_io__bi_t
* cell instance $481 r180 *1 1340.16,2000
X$481 378 121 110 1 46 48 46 gf180mcu_fd_io__fill10
* cell instance $482 r180 *1 1350.16,2000
X$482 378 112 121 1 46 48 46 gf180mcu_fd_io__fill10
* cell instance $483 r180 *1 1360.16,2000
X$483 378 113 112 1 46 48 46 gf180mcu_fd_io__fill10
* cell instance $484 r180 *1 1370.16,2000
X$484 378 114 113 1 46 48 46 gf180mcu_fd_io__fill10
* cell instance $485 r180 *1 1380.16,2000
X$485 378 115 114 1 46 48 46 gf180mcu_fd_io__fill10
* cell instance $486 r180 *1 1390.16,2000
X$486 378 116 115 1 46 48 46 gf180mcu_fd_io__fill10
* cell instance $487 r180 *1 1400.16,2000
X$487 378 117 116 1 46 48 46 gf180mcu_fd_io__fill10
* cell instance $488 r180 *1 1410.16,2000
X$488 378 118 117 1 46 48 46 gf180mcu_fd_io__fill10
* cell instance $489 r180 *1 1420.16,2000
X$489 378 119 118 1 46 48 46 gf180mcu_fd_io__fill10
* cell instance $490 r180 *1 1430.16,2000
X$490 378 120 119 1 46 48 46 gf180mcu_fd_io__fill10
* cell instance $491 r180 *1 1440.16,2000
X$491 378 152 120 1 46 48 46 gf180mcu_fd_io__fill10
* cell instance $492 r180 *1 1450.16,2000
X$492 378 4 152 1 46 48 46 gf180mcu_fd_io__fill10
* cell instance $493 r180 *1 1525.16,2000
X$493 48 46 46 1 2 134 134 4 4 378 gf180mcu_fd_io__bi_t
* cell instance $494 r180 *1 1535.16,2000
X$494 378 123 134 1 46 48 46 gf180mcu_fd_io__fill10
* cell instance $495 r180 *1 1545.16,2000
X$495 378 124 123 1 46 48 46 gf180mcu_fd_io__fill10
* cell instance $496 r180 *1 1555.16,2000
X$496 378 125 124 1 46 48 46 gf180mcu_fd_io__fill10
* cell instance $497 r180 *1 1565.16,2000
X$497 378 126 125 1 46 48 46 gf180mcu_fd_io__fill10
* cell instance $498 r180 *1 1575.16,2000
X$498 378 127 126 1 46 48 46 gf180mcu_fd_io__fill10
* cell instance $499 r180 *1 1585.16,2000
X$499 378 128 127 1 46 48 46 gf180mcu_fd_io__fill10
* cell instance $500 r180 *1 1595.16,2000
X$500 378 129 128 1 46 48 46 gf180mcu_fd_io__fill10
* cell instance $501 r180 *1 1605.16,2000
X$501 378 130 129 1 46 48 46 gf180mcu_fd_io__fill10
* cell instance $502 r180 *1 1615.16,2000
X$502 378 142 130 1 46 48 46 gf180mcu_fd_io__fill10
* cell instance $503 r180 *1 1625.16,2000
X$503 378 132 142 1 46 48 46 gf180mcu_fd_io__fill10
* cell instance $504 r180 *1 1635.16,2000
X$504 378 133 132 1 46 48 46 gf180mcu_fd_io__fill10
* cell instance $505 r180 *1 1645.16,2000
X$505 378 244 133 1 46 48 46 gf180mcu_fd_io__fill10
.ENDS PAD_RING_TOP

* cell gf180mcu_fd_io__dvdd
* pin DVDD
* pin DVSS
* pin VSS
* pin gf180mcu_gnd
* pin
* pin
* pin
* pin
* pin
.SUBCKT gf180mcu_fd_io__dvdd 1 2 3 4 5 6 7 8 9
* net 1 DVDD
* net 2 DVSS
* net 3 VSS
* net 4 gf180mcu_gnd
* cell instance $1 r0 *1 0,0
X$1 9 1 10 3 3 1 1 2 3LM_METAL_RAIL_PAD_60
* cell instance $2 r0 *1 0.055,62
X$2 3 3 1 10 2 10 10 10 10 10 6 8 2 3 3 5 3 7 4 GF_NI_DVDD_BASE
.ENDS gf180mcu_fd_io__dvdd

* cell gf180mcu_fd_io__fill1
* pin VSS
* pin VDD
* pin DVSS
* pin DVDD
* pin
* pin
* pin
.SUBCKT gf180mcu_fd_io__fill1 1 2 3 4 5 6 7
* net 1 VSS
* net 2 VDD
* net 3 DVSS
* net 4 DVDD
* cell instance $1 r0 *1 0.5,207.57
X$1 1 5 M1_PSUB_CDNS_40661956134167
* cell instance $2 r0 *1 0.505,321.5
X$2 1 6 M2_M1_CDNS_40661956134169
* cell instance $3 r0 *1 0.51,249.47
X$3 1 7 M2_M1_CDNS_40661956134168
* cell instance $4 r0 *1 0.505,321.5
X$4 1 6 M3_M2_CDNS_40661956134171
* cell instance $5 r0 *1 0.51,249.47
X$5 1 7 M3_M2_CDNS_40661956134170
.ENDS gf180mcu_fd_io__fill1

* cell gf180mcu_fd_io__dvss
* pin DVSS
* pin VDD
* pin DVDD
* pin gf180mcu_gnd
* pin
* pin
* pin
* pin
* pin
.SUBCKT gf180mcu_fd_io__dvss 1 2 3 4 5 6 7 8 9
* net 1 DVSS
* net 2 VDD
* net 3 DVDD
* net 4 gf180mcu_gnd
* cell instance $1 r0 *1 0,0
X$1 9 1 10 1 1 3 2 1 3LM_METAL_RAIL_PAD_60
* cell instance $2 r0 *1 0.055,62
X$2 1 1 10 1 10 10 10 10 10 3 8 6 2 1 1 1 1 2 3 1 7 1 5 1 1 4 GF_NI_DVSS_BASE
.ENDS gf180mcu_fd_io__dvss

* cell gf180mcu_fd_io__in_c
* pin DVSS
* pin DVDD
* pin VDD
* pin VSS
* pin gf180mcu_gnd
* pin
* pin
* pin
* pin
* pin
.SUBCKT gf180mcu_fd_io__in_c 4 5 6 7 9 10 11 12 13 14
* net 1 Y
* net 2 PU
* net 3 PD
* net 4 DVSS
* net 5 DVDD
* net 6 VDD
* net 7 VSS
* net 8 PAD
* net 9 gf180mcu_gnd
* cell instance $1 r0 *1 -0.16,62
X$1 7 4 5 8 4 6 11 13 6 7 5 6 7 7 5 4 5 15 7 6 10 12 2 5 3 4 5 5 4 1 4 9 6 7 4
+ 4 4 4 5 5 5 5 5 5 5 5 4 5 4 5 GF_NI_IN_C_BASE
* cell instance $2 r0 *1 0,0
X$2 14 8 15 7 7 5 6 4 3LM_METAL_RAIL_PAD_60
.ENDS gf180mcu_fd_io__in_c

* cell gf180mcu_fd_io__fillnc
* pin VSS
* pin VDD
* pin DVSS
* pin DVDD
* pin
* pin
* pin
* pin
* pin
* pin
.SUBCKT gf180mcu_fd_io__fillnc 1 2 3 4 5 6 7 8 9 10
* net 1 VSS
* net 2 VDD
* net 3 DVSS
* net 4 DVDD
.ENDS gf180mcu_fd_io__fillnc

* cell gf180mcu_fd_io__fill5
* pin
* pin
* pin
* pin VSS
* pin VDD
* pin DVSS
* pin DVDD
.SUBCKT gf180mcu_fd_io__fill5 1 2 3 4 5 6 7
* net 4 VSS
* net 5 VDD
* net 6 DVSS
* net 7 DVDD
* cell instance $1 r0 *1 2.5,349.365
X$1 4 1 M1_PSUB_CDNS_40661956134174
* cell instance $2 m0 *1 2.5,65.96
X$2 4 1 M1_PSUB_CDNS_40661956134174
* cell instance $3 m90 *1 0.24,207.62
X$3 4 1 M1_PSUB_CDNS_40661956134176
* cell instance $4 r0 *1 4.76,207.62
X$4 4 1 M1_PSUB_CDNS_40661956134176
* cell instance $5 r0 *1 0.425,249.5
X$5 4 2 M3_M2_CDNS_40661956134177
* cell instance $6 r0 *1 0.425,249.5
X$6 4 2 M2_M1_CDNS_40661956134173
* cell instance $7 r0 *1 0.425,321.5
X$7 4 2 M3_M2_CDNS_40661956134177
* cell instance $8 r0 *1 0.425,321.5
X$8 4 2 M2_M1_CDNS_40661956134173
* cell instance $9 r0 *1 4.385,249.5
X$9 4 3 M3_M2_CDNS_40661956134177
* cell instance $10 r0 *1 4.385,249.5
X$10 4 3 M2_M1_CDNS_40661956134173
* cell instance $11 r0 *1 4.385,321.5
X$11 4 3 M3_M2_CDNS_40661956134177
* cell instance $12 r0 *1 4.385,321.5
X$12 4 3 M2_M1_CDNS_40661956134173
* cell instance $13 r0 *1 -4.03,69.095
X$13 5 4 10 POLY_SUB_FILL
* cell instance $14 r0 *1 -4.03,77.095
X$14 5 4 10 POLY_SUB_FILL
* cell instance $15 r0 *1 -4.03,85.095
X$15 5 4 10 POLY_SUB_FILL
* cell instance $16 r0 *1 -4.03,93.095
X$16 5 4 10 POLY_SUB_FILL
* cell instance $17 r0 *1 -4.03,101.095
X$17 5 4 10 POLY_SUB_FILL
* cell instance $18 r0 *1 -4.03,109.095
X$18 5 4 10 POLY_SUB_FILL
* cell instance $19 r0 *1 -4.03,117.095
X$19 5 4 10 POLY_SUB_FILL
* cell instance $20 r0 *1 -4.03,125.095
X$20 5 4 10 POLY_SUB_FILL
* cell instance $21 r0 *1 -4.03,133.095
X$21 5 4 10 POLY_SUB_FILL
* cell instance $22 r0 *1 -4.03,141.095
X$22 5 4 10 POLY_SUB_FILL
* cell instance $23 r0 *1 -4.03,149.095
X$23 5 4 10 POLY_SUB_FILL
* cell instance $24 r0 *1 -4.03,157.095
X$24 5 4 10 POLY_SUB_FILL
* cell instance $25 r0 *1 -4.03,165.095
X$25 5 4 10 POLY_SUB_FILL
* cell instance $26 r0 *1 -4.03,173.095
X$26 5 4 10 POLY_SUB_FILL
* cell instance $27 r0 *1 -4.03,181.095
X$27 5 4 10 POLY_SUB_FILL
* cell instance $28 r0 *1 -4.03,189.095
X$28 5 4 10 POLY_SUB_FILL
* cell instance $29 r0 *1 -4.03,197.095
X$29 5 4 10 POLY_SUB_FILL
* cell instance $30 r0 *1 -4.03,205.095
X$30 5 4 10 POLY_SUB_FILL
* cell instance $31 r0 *1 -4.03,213.095
X$31 5 4 10 POLY_SUB_FILL
* cell instance $32 r0 *1 -4.03,221.095
X$32 5 4 10 POLY_SUB_FILL
* cell instance $33 r0 *1 -4.03,229.095
X$33 5 4 10 POLY_SUB_FILL
* cell instance $34 r0 *1 -4.03,237.095
X$34 5 4 10 POLY_SUB_FILL
* cell instance $35 r0 *1 -4.03,245.095
X$35 5 4 10 POLY_SUB_FILL
* cell instance $36 r0 *1 -4.03,253.095
X$36 5 4 10 POLY_SUB_FILL
* cell instance $37 r0 *1 -4.03,261.095
X$37 5 4 10 POLY_SUB_FILL
* cell instance $38 r0 *1 -4.03,269.095
X$38 5 4 10 POLY_SUB_FILL
* cell instance $39 r0 *1 -4.03,277.095
X$39 5 4 10 POLY_SUB_FILL
* cell instance $40 r0 *1 -4.03,285.095
X$40 5 4 10 POLY_SUB_FILL
* cell instance $41 r0 *1 -4.03,293.095
X$41 5 4 10 POLY_SUB_FILL
* cell instance $42 r0 *1 -4.03,301.095
X$42 5 4 10 POLY_SUB_FILL
* cell instance $43 r0 *1 -4.03,309.095
X$43 5 4 10 POLY_SUB_FILL
* cell instance $44 r0 *1 -4.03,317.095
X$44 5 4 10 POLY_SUB_FILL
* cell instance $45 r0 *1 -4.03,325.095
X$45 5 4 10 POLY_SUB_FILL
* cell instance $46 r0 *1 -4.03,333.095
X$46 5 4 10 POLY_SUB_FILL
* cell instance $47 r0 *1 -4.03,341.095
X$47 5 4 10 POLY_SUB_FILL
* cell instance $48 r0 *1 2.55,257.52
X$48 5 10 M3_M2_CDNS_40661956134172
* cell instance $49 r0 *1 2.55,313.485
X$49 5 10 M3_M2_CDNS_40661956134172
* cell instance $50 r0 *1 3.47,93.48
X$50 6 8 M3_M2_CDNS_40661956134175
* cell instance $51 r0 *1 3.47,77.48
X$51 6 8 M3_M2_CDNS_40661956134175
* cell instance $52 r0 *1 3.47,109.54
X$52 6 8 M3_M2_CDNS_40661956134175
* cell instance $53 r0 *1 3.47,237.64
X$53 6 8 M3_M2_CDNS_40661956134175
* cell instance $54 r0 *1 3.47,345.115
X$54 6 8 M3_M2_CDNS_40661956134172
* cell instance $55 r0 *1 3.47,329.55
X$55 6 8 M3_M2_CDNS_40661956134172
* cell instance $56 r0 *1 3.47,129.645
X$56 6 8 M3_M2_CDNS_40661956134172
* cell instance $57 r0 *1 3.47,201.635
X$57 6 8 M3_M2_CDNS_40661956134172
* cell instance $58 r0 *1 3.47,289.485
X$58 6 8 M3_M2_CDNS_40661956134172
* cell instance $59 r0 *1 3.47,305.54
X$59 6 8 M3_M2_CDNS_40661956134172
* cell instance $60 r0 *1 1.59,141.715
X$60 7 9 M3_M2_CDNS_40661956134175
* cell instance $61 r0 *1 1.59,157.565
X$61 7 9 M3_M2_CDNS_40661956134175
* cell instance $62 r0 *1 1.59,173.59
X$62 7 9 M3_M2_CDNS_40661956134175
* cell instance $63 r0 *1 1.59,189.44
X$63 7 9 M3_M2_CDNS_40661956134175
* cell instance $64 r0 *1 1.59,221.555
X$64 7 9 M3_M2_CDNS_40661956134175
* cell instance $65 r0 *1 1.59,121.49
X$65 7 9 M3_M2_CDNS_40661956134172
* cell instance $66 r0 *1 1.59,209.475
X$66 7 9 M3_M2_CDNS_40661956134172
* cell instance $67 r0 *1 1.59,265.565
X$67 7 9 M3_M2_CDNS_40661956134172
* cell instance $68 r0 *1 1.59,273.52
X$68 7 9 M3_M2_CDNS_40661956134172
* cell instance $69 r0 *1 1.59,281.615
X$69 7 9 M3_M2_CDNS_40661956134172
* cell instance $70 r0 *1 1.59,297.525
X$70 7 9 M3_M2_CDNS_40661956134172
* cell instance $71 r0 *1 1.59,337.47
X$71 7 9 M3_M2_CDNS_40661956134172
.ENDS gf180mcu_fd_io__fill5

* cell gf180mcu_fd_io__cor
* pin DVSS
* pin VDD
* pin DVDD
* pin VSS
* pin gf180mcu_gnd
* pin
.SUBCKT gf180mcu_fd_io__cor 1 2 3 4 5 6
* net 1 DVSS
* net 2 VDD
* net 3 DVDD
* net 4 VSS
* net 5 gf180mcu_gnd
* cell instance $1 r0 *1 0,0
X$1 6 4 1 3 4 2 POWER_RAIL_COR
* cell instance $2 r0 *1 0,0
X$2 1 3 1 1 2 1 5 1 4 3 3 1 4 4 4 4 1 3 3 3 3 3 3 3 GF_NI_COR_BASE
.ENDS gf180mcu_fd_io__cor

* cell gf180mcu_fd_io__bi_t
* pin DVSS
* pin DVDD
* pin VDD
* pin VSS
* pin gf180mcu_gnd
* pin
* pin
* pin
* pin
* pin
.SUBCKT gf180mcu_fd_io__bi_t 11 12 13 14 16 17 18 19 20 21
* net 1 PU
* net 2 PD
* net 3 IE
* net 4 SL
* net 5 CS
* net 6 Y
* net 7 A
* net 8 OE
* net 9 PDRV0
* net 10 PDRV1
* net 11 DVSS
* net 12 DVDD
* net 13 VDD
* net 14 VSS
* net 15 PAD
* net 16 gf180mcu_gnd
* cell instance $1 r0 *1 -0.16,62.15
X$1 14 11 12 15 11 9 13 7 20 18 13 14 12 14 13 14 12 8 4 11 12 10 22 14 13 19
+ 17 1 12 2 11 11 5 3 6 12 12 12 16 13 14 11 11 11 11 12 12 12 12 12 12 12 12
+ 11 12 11 12 GF_NI_BI_T_BASE
* cell instance $2 r0 *1 0,0
X$2 21 15 22 14 14 12 13 11 3LM_METAL_RAIL_PAD_60
.ENDS gf180mcu_fd_io__bi_t

* cell gf180mcu_fd_io__fill10
* pin
* pin
* pin
* pin VSS
* pin VDD
* pin DVSS
* pin DVDD
.SUBCKT gf180mcu_fd_io__fill10 1 2 3 4 5 6 7
* net 4 VSS
* net 5 VDD
* net 6 DVSS
* net 7 DVDD
* cell instance $1 r0 *1 5.005,349.365
X$1 4 1 M1_PSUB_CDNS_40661956134182
* cell instance $2 m0 *1 5.005,65.96
X$2 4 1 M1_PSUB_CDNS_40661956134182
* cell instance $3 m90 *1 0.24,207.62
X$3 4 1 M1_PSUB_CDNS_40661956134176
* cell instance $4 r0 *1 9.76,207.62
X$4 4 1 M1_PSUB_CDNS_40661956134176
* cell instance $5 r0 *1 0.91,321.5
X$5 4 2 M3_M2_CDNS_40661956134180
* cell instance $6 r0 *1 0.91,321.5
X$6 4 2 M2_M1_CDNS_40661956134179
* cell instance $7 r0 *1 0.91,249.505
X$7 4 2 M3_M2_CDNS_40661956134180
* cell instance $8 r0 *1 0.91,249.505
X$8 4 2 M2_M1_CDNS_40661956134179
* cell instance $9 r0 *1 9.09,321.5
X$9 4 3 M3_M2_CDNS_40661956134180
* cell instance $10 r0 *1 9.09,321.5
X$10 4 3 M2_M1_CDNS_40661956134179
* cell instance $11 r0 *1 9.09,249.505
X$11 4 3 M3_M2_CDNS_40661956134180
* cell instance $12 r0 *1 9.09,249.505
X$12 4 3 M2_M1_CDNS_40661956134179
* cell instance $13 m90 *1 11.435,71.96
X$13 4 5 10 POLY_SUB_FILL_1
* cell instance $14 m90 *1 11.435,89.02
X$14 4 5 10 POLY_SUB_FILL_1
* cell instance $15 m90 *1 11.435,106.08
X$15 4 5 10 POLY_SUB_FILL_1
* cell instance $16 m90 *1 11.435,123.14
X$16 4 5 10 POLY_SUB_FILL_1
* cell instance $17 m90 *1 11.435,140.2
X$17 4 5 10 POLY_SUB_FILL_1
* cell instance $18 m90 *1 11.435,157.26
X$18 4 5 10 POLY_SUB_FILL_1
* cell instance $19 m90 *1 11.435,174.32
X$19 4 5 10 POLY_SUB_FILL_1
* cell instance $20 m90 *1 11.435,191.38
X$20 4 5 10 POLY_SUB_FILL_1
* cell instance $21 m90 *1 11.435,208.44
X$21 4 5 10 POLY_SUB_FILL_1
* cell instance $22 m90 *1 11.435,225.5
X$22 4 5 10 POLY_SUB_FILL_1
* cell instance $23 m90 *1 11.435,242.56
X$23 4 5 10 POLY_SUB_FILL_1
* cell instance $24 m90 *1 11.435,259.62
X$24 4 5 10 POLY_SUB_FILL_1
* cell instance $25 m90 *1 11.435,276.68
X$25 4 5 10 POLY_SUB_FILL_1
* cell instance $26 m90 *1 11.435,293.74
X$26 4 5 10 POLY_SUB_FILL_1
* cell instance $27 m90 *1 11.435,310.8
X$27 4 5 10 POLY_SUB_FILL_1
* cell instance $28 m90 *1 11.435,327.86
X$28 4 5 10 POLY_SUB_FILL_1
* cell instance $29 r0 *1 5.125,257.585
X$29 5 10 M3_M2_CDNS_40661956134181
* cell instance $30 r0 *1 5.13,313.495
X$30 5 10 M3_M2_CDNS_40661956134181
* cell instance $31 r0 *1 7.375,77.66
X$31 6 9 M3_M2_CDNS_40661956134175
* cell instance $32 r0 *1 7.375,93.61
X$32 6 9 M3_M2_CDNS_40661956134175
* cell instance $33 r0 *1 7.375,109.345
X$33 6 9 M3_M2_CDNS_40661956134175
* cell instance $34 r0 *1 7.375,237.415
X$34 6 9 M3_M2_CDNS_40661956134175
* cell instance $35 r0 *1 7.375,329.585
X$35 6 9 M3_M2_CDNS_40661956134172
* cell instance $36 r0 *1 7.375,129.67
X$36 6 9 M3_M2_CDNS_40661956134172
* cell instance $37 r0 *1 7.375,201.64
X$37 6 9 M3_M2_CDNS_40661956134172
* cell instance $38 r0 *1 7.375,289.415
X$38 6 9 M3_M2_CDNS_40661956134172
* cell instance $39 r0 *1 7.375,305.605
X$39 6 9 M3_M2_CDNS_40661956134172
* cell instance $40 r0 *1 7.375,345.27
X$40 6 9 M3_M2_CDNS_40661956134172
* cell instance $41 r0 *1 2.76,221.295
X$41 7 8 M3_M2_CDNS_40661956134175
* cell instance $42 r0 *1 2.76,141.75
X$42 7 8 M3_M2_CDNS_40661956134175
* cell instance $43 r0 *1 2.76,157.46
X$43 7 8 M3_M2_CDNS_40661956134175
* cell instance $44 r0 *1 2.76,173.585
X$44 7 8 M3_M2_CDNS_40661956134175
* cell instance $45 r0 *1 2.76,189.69
X$45 7 8 M3_M2_CDNS_40661956134175
* cell instance $46 r0 *1 2.76,209.5
X$46 7 8 M3_M2_CDNS_40661956134172
* cell instance $47 r0 *1 2.76,265.455
X$47 7 8 M3_M2_CDNS_40661956134172
* cell instance $48 r0 *1 2.76,273.525
X$48 7 8 M3_M2_CDNS_40661956134172
* cell instance $49 r0 *1 2.76,281.64
X$49 7 8 M3_M2_CDNS_40661956134172
* cell instance $50 r0 *1 2.76,297.4
X$50 7 8 M3_M2_CDNS_40661956134172
* cell instance $51 r0 *1 2.76,337.285
X$51 7 8 M3_M2_CDNS_40661956134172
* cell instance $52 r0 *1 2.76,121.505
X$52 7 8 M3_M2_CDNS_40661956134172
.ENDS gf180mcu_fd_io__fill10

* cell gf180mcu_fd_io__in_s
* pin DVSS
* pin DVDD
* pin VDD
* pin VSS
* pin gf180mcu_gnd
* pin
* pin
* pin
* pin
* pin
.SUBCKT gf180mcu_fd_io__in_s 4 5 6 7 9 10 11 12 13 14
* net 1 PU
* net 2 PD
* net 3 Y
* net 4 DVSS
* net 5 DVDD
* net 6 VDD
* net 7 VSS
* net 8 PAD
* net 9 gf180mcu_gnd
* cell instance $1 r0 *1 -0.16,62
X$1 7 4 5 8 4 6 13 11 6 7 5 6 7 7 5 4 5 15 7 6 12 10 1 5 2 4 5 5 4 3 4 9 6 7 4
+ 4 4 4 5 5 5 5 5 5 5 5 4 5 4 5 GF_NI_IN_S_BASE
* cell instance $2 r0 *1 0,0
X$2 14 8 15 7 7 5 6 4 3LM_METAL_RAIL_PAD_60
.ENDS gf180mcu_fd_io__in_s

* cell GF_NI_DVDD_BASE
* pin
* pin
* pin DVDD
* pin
* pin DVSS
* pin
* pin
* pin
* pin
* pin
* pin
* pin
* pin
* pin
* pin
* pin
* pin
* pin
* pin gf180mcu_gnd
.SUBCKT GF_NI_DVDD_BASE 1 2 3 4 5 6 7 8 9 10 11 12 14 15 16 18 22 27 28
* net 3 DVDD
* net 5 DVSS
* net 28 gf180mcu_gnd
* cell instance $1 r0 *1 67.48,174.62
X$1 1 M1_PSUB_CDNS_40661956134228
* cell instance $2 r0 *1 72.435,109.62
X$2 1 M1_PSUB_CDNS_40661956134229
* cell instance $3 r0 *1 74.65,187.5
X$3 1 12 M3_M2_CDNS_40661956134114
* cell instance $4 r0 *1 74.65,187.5
X$4 1 12 M2_M1_CDNS_40661956134115
* cell instance $5 r0 *1 2.455,109.62
X$5 2 M1_PSUB_CDNS_40661956134229
* cell instance $6 r0 *1 0.24,187.5
X$6 2 11 M2_M1_CDNS_40661956134115
* cell instance $7 r0 *1 0.24,187.5
X$7 2 11 M3_M2_CDNS_40661956134114
* cell instance $8 r0 *1 41.415,275.775
X$8 3 8 M2_M1_CDNS_40661956134208
* cell instance $9 r0 *1 38.535,268.275
X$9 14 3 nmoscap_6p0_CDNS_406619561348
* cell instance $10 r0 *1 44.21,275.5
X$10 3 8 M3_M2_CDNS_40661956134221
* cell instance $11 r0 *1 52.13,275.775
X$11 3 9 M2_M1_CDNS_40661956134213
* cell instance $12 r0 *1 56.06,275.5
X$12 3 9 M3_M2_CDNS_40661956134221
* cell instance $13 m90 *1 58.425,275.775
X$13 3 9 M2_M1_CDNS_40661956134214
* cell instance $14 r0 *1 55.715,268.275
X$14 14 3 nmoscap_6p0_CDNS_406619561348
* cell instance $15 m90 *1 68.005,275.775
X$15 3 10 M2_M1_CDNS_40661956134214
* cell instance $16 r0 *1 68.835,275.5
X$16 3 10 M3_M2_CDNS_40661956134119
* cell instance $17 r0 *1 20.715,243.685
X$17 3 6 M2_M1_CDNS_40661956134211
* cell instance $18 r0 *1 17.445,243.185
X$18 3 np_6p0_CDNS_406619561349
* cell instance $19 r0 *1 30.68,243.685
X$19 3 7 M2_M1_CDNS_40661956134212
* cell instance $20 m90 *1 44.21,243.685
X$20 3 8 M2_M1_CDNS_40661956134212
* cell instance $21 m90 *1 54.175,243.685
X$21 3 9 M2_M1_CDNS_40661956134211
* cell instance $22 r0 *1 20.715,248.355
X$22 3 6 M2_M1_CDNS_40661956134211
* cell instance $23 r0 *1 18.83,251.5
X$23 3 6 M3_M2_CDNS_40661956134221
* cell instance $24 r0 *1 17.445,247.855
X$24 3 np_6p0_CDNS_406619561349
* cell instance $25 r0 *1 30.68,248.355
X$25 3 7 M2_M1_CDNS_40661956134212
* cell instance $26 r0 *1 30.68,251.5
X$26 3 7 M3_M2_CDNS_40661956134221
* cell instance $27 m90 *1 44.21,248.355
X$27 3 8 M2_M1_CDNS_40661956134212
* cell instance $28 r0 *1 44.21,251.5
X$28 3 8 M3_M2_CDNS_40661956134221
* cell instance $29 m90 *1 54.175,248.355
X$29 3 9 M2_M1_CDNS_40661956134211
* cell instance $30 r0 *1 56.06,251.5
X$30 3 9 M3_M2_CDNS_40661956134221
* cell instance $31 r0 *1 20.715,253.025
X$31 3 6 M2_M1_CDNS_40661956134211
* cell instance $32 r0 *1 17.445,252.525
X$32 3 np_6p0_CDNS_406619561349
* cell instance $33 r0 *1 30.68,253.025
X$33 3 7 M2_M1_CDNS_40661956134212
* cell instance $34 m90 *1 44.21,253.025
X$34 3 8 M2_M1_CDNS_40661956134212
* cell instance $35 m90 *1 54.175,253.025
X$35 3 9 M2_M1_CDNS_40661956134211
* cell instance $36 r0 *1 20.715,257.695
X$36 3 6 M2_M1_CDNS_40661956134211
* cell instance $37 r0 *1 17.445,257.195
X$37 3 np_6p0_CDNS_406619561349
* cell instance $38 r0 *1 30.68,257.695
X$38 3 7 M2_M1_CDNS_40661956134212
* cell instance $39 m90 *1 44.21,257.695
X$39 3 8 M2_M1_CDNS_40661956134212
* cell instance $40 m90 *1 54.175,257.695
X$40 3 9 M2_M1_CDNS_40661956134211
* cell instance $41 r0 *1 37.445,239.19
X$41 3 29 3 17 M1_NWELL_CDNS_40661956134205
* cell instance $42 r0 *1 13.675,250.69
X$42 3 17 3 29 M1_NWELL_CDNS_40661956134204
* cell instance $43 r0 *1 61.215,250.69
X$43 3 17 3 29 M1_NWELL_CDNS_40661956134204
* cell instance $44 r0 *1 37.445,262.19
X$44 3 29 3 17 M1_NWELL_CDNS_40661956134205
* cell instance $45 r0 *1 6.055,275.5
X$45 3 4 M3_M2_CDNS_40661956134119
* cell instance $46 r0 *1 6.885,275.775
X$46 3 4 M2_M1_CDNS_40661956134214
* cell instance $47 r0 *1 4.175,268.275
X$47 14 3 nmoscap_6p0_CDNS_406619561348
* cell instance $48 r0 *1 16.465,275.775
X$48 3 6 M2_M1_CDNS_40661956134214
* cell instance $49 r0 *1 18.83,275.5
X$49 3 6 M3_M2_CDNS_40661956134221
* cell instance $50 r0 *1 22.76,275.775
X$50 3 6 M2_M1_CDNS_40661956134213
* cell instance $51 r0 *1 21.355,268.275
X$51 14 3 nmoscap_6p0_CDNS_406619561348
* cell instance $52 r0 *1 33.475,275.775
X$52 3 7 M2_M1_CDNS_40661956134208
* cell instance $53 r0 *1 30.68,275.5
X$53 3 7 M3_M2_CDNS_40661956134221
* cell instance $54 r0 *1 6.055,251.5
X$54 3 4 M3_M2_CDNS_40661956134119
* cell instance $55 r0 *1 6.055,59.5
X$55 3 4 M3_M2_CDNS_40661956134119
* cell instance $56 r0 *1 5.04,5.735
X$56 14 3 4 20 23 6 7 24 8 25 9 26 10 28 comp018green_esd_clamp_v5p0_DVDD
* cell instance $57 r0 *1 18.83,59.5
X$57 3 6 M3_M2_CDNS_40661956134221
* cell instance $58 r0 *1 30.68,59.5
X$58 3 7 M3_M2_CDNS_40661956134221
* cell instance $59 r0 *1 44.21,59.5
X$59 3 8 M3_M2_CDNS_40661956134221
* cell instance $60 r0 *1 56.06,59.5
X$60 3 9 M3_M2_CDNS_40661956134221
* cell instance $61 r0 *1 68.835,59.5
X$61 3 10 M3_M2_CDNS_40661956134119
* cell instance $62 r0 *1 6.055,95.5
X$62 3 4 M3_M2_CDNS_40661956134156
* cell instance $63 r0 *1 6.055,79.5
X$63 3 4 M3_M2_CDNS_40661956134156
* cell instance $64 r0 *1 18.83,95.5
X$64 3 6 M3_M2_CDNS_40661956134222
* cell instance $65 r0 *1 18.83,79.5
X$65 3 6 M3_M2_CDNS_40661956134222
* cell instance $66 r0 *1 30.68,79.5
X$66 3 7 M3_M2_CDNS_40661956134222
* cell instance $67 r0 *1 30.68,95.5
X$67 3 7 M3_M2_CDNS_40661956134222
* cell instance $68 r0 *1 44.21,79.5
X$68 3 8 M3_M2_CDNS_40661956134222
* cell instance $69 r0 *1 44.21,95.5
X$69 3 8 M3_M2_CDNS_40661956134222
* cell instance $70 r0 *1 56.06,79.5
X$70 3 9 M3_M2_CDNS_40661956134222
* cell instance $71 r0 *1 56.06,95.5
X$71 3 9 M3_M2_CDNS_40661956134222
* cell instance $72 r0 *1 68.835,79.5
X$72 3 10 M3_M2_CDNS_40661956134156
* cell instance $73 r0 *1 68.835,95.5
X$73 3 10 M3_M2_CDNS_40661956134156
* cell instance $74 r0 *1 6.055,127.5
X$74 3 4 M3_M2_CDNS_40661956134156
* cell instance $75 r0 *1 6.055,111.5
X$75 3 4 M3_M2_CDNS_40661956134156
* cell instance $76 r0 *1 18.83,127.5
X$76 3 6 M3_M2_CDNS_40661956134222
* cell instance $77 r0 *1 18.83,111.5
X$77 3 6 M3_M2_CDNS_40661956134222
* cell instance $78 r0 *1 30.68,127.5
X$78 3 7 M3_M2_CDNS_40661956134222
* cell instance $79 r0 *1 30.68,111.5
X$79 3 7 M3_M2_CDNS_40661956134222
* cell instance $80 r0 *1 44.21,127.5
X$80 3 8 M3_M2_CDNS_40661956134222
* cell instance $81 r0 *1 44.21,111.5
X$81 3 8 M3_M2_CDNS_40661956134222
* cell instance $82 r0 *1 56.06,111.5
X$82 3 9 M3_M2_CDNS_40661956134222
* cell instance $83 r0 *1 56.06,127.5
X$83 3 9 M3_M2_CDNS_40661956134222
* cell instance $84 r0 *1 68.835,127.5
X$84 3 10 M3_M2_CDNS_40661956134156
* cell instance $85 r0 *1 68.835,111.5
X$85 3 10 M3_M2_CDNS_40661956134156
* cell instance $86 r0 *1 6.055,147.5
X$86 3 4 M3_M2_CDNS_40661956134119
* cell instance $87 r0 *1 18.83,147.5
X$87 3 6 M3_M2_CDNS_40661956134221
* cell instance $88 r0 *1 30.68,147.5
X$88 3 7 M3_M2_CDNS_40661956134221
* cell instance $89 r0 *1 44.21,147.5
X$89 3 8 M3_M2_CDNS_40661956134221
* cell instance $90 r0 *1 56.06,147.5
X$90 3 9 M3_M2_CDNS_40661956134221
* cell instance $91 r0 *1 68.835,147.5
X$91 3 10 M3_M2_CDNS_40661956134119
* cell instance $92 r0 *1 6.055,159.5
X$92 3 4 M3_M2_CDNS_40661956134156
* cell instance $93 r0 *1 18.83,159.5
X$93 3 6 M3_M2_CDNS_40661956134222
* cell instance $94 r0 *1 30.68,159.5
X$94 3 7 M3_M2_CDNS_40661956134222
* cell instance $95 r0 *1 44.21,159.5
X$95 3 8 M3_M2_CDNS_40661956134222
* cell instance $96 r0 *1 56.06,159.5
X$96 3 9 M3_M2_CDNS_40661956134222
* cell instance $97 r0 *1 68.835,159.5
X$97 3 10 M3_M2_CDNS_40661956134156
* cell instance $98 r0 *1 6.055,195.5
X$98 3 4 M3_M2_CDNS_40661956134119
* cell instance $99 r0 *1 18.83,195.5
X$99 3 6 M3_M2_CDNS_40661956134221
* cell instance $100 r0 *1 30.68,195.5
X$100 3 7 M3_M2_CDNS_40661956134221
* cell instance $101 r0 *1 44.21,195.5
X$101 3 8 M3_M2_CDNS_40661956134221
* cell instance $102 r0 *1 56.06,195.5
X$102 3 9 M3_M2_CDNS_40661956134221
* cell instance $103 r0 *1 68.835,195.5
X$103 3 10 M3_M2_CDNS_40661956134119
* cell instance $104 r0 *1 6.055,211.5
X$104 3 4 M3_M2_CDNS_40661956134119
* cell instance $105 r0 *1 6.055,203.5
X$105 3 4 M3_M2_CDNS_40661956134119
* cell instance $106 r0 *1 18.83,211.5
X$106 3 6 M3_M2_CDNS_40661956134221
* cell instance $107 r0 *1 18.83,203.5
X$107 3 6 M3_M2_CDNS_40661956134221
* cell instance $108 r0 *1 30.68,211.5
X$108 3 7 M3_M2_CDNS_40661956134221
* cell instance $109 r0 *1 30.68,203.5
X$109 3 7 M3_M2_CDNS_40661956134221
* cell instance $110 r0 *1 44.21,211.5
X$110 3 8 M3_M2_CDNS_40661956134221
* cell instance $111 r0 *1 44.21,203.5
X$111 3 8 M3_M2_CDNS_40661956134221
* cell instance $112 r0 *1 56.06,203.5
X$112 3 9 M3_M2_CDNS_40661956134221
* cell instance $113 r0 *1 56.06,211.5
X$113 3 9 M3_M2_CDNS_40661956134221
* cell instance $114 r0 *1 68.835,203.5
X$114 3 10 M3_M2_CDNS_40661956134119
* cell instance $115 r0 *1 68.835,211.5
X$115 3 10 M3_M2_CDNS_40661956134119
* cell instance $116 r0 *1 6.055,219.5
X$116 3 4 M3_M2_CDNS_40661956134119
* cell instance $117 r0 *1 18.83,219.5
X$117 3 6 M3_M2_CDNS_40661956134221
* cell instance $118 r0 *1 30.68,219.5
X$118 3 7 M3_M2_CDNS_40661956134221
* cell instance $119 r0 *1 44.21,219.5
X$119 3 8 M3_M2_CDNS_40661956134221
* cell instance $120 r0 *1 56.06,219.5
X$120 3 9 M3_M2_CDNS_40661956134221
* cell instance $121 r0 *1 68.835,219.5
X$121 3 10 M3_M2_CDNS_40661956134119
* cell instance $122 r0 *1 6.055,235.5
X$122 3 4 M3_M2_CDNS_40661956134119
* cell instance $123 r0 *1 18.83,235.5
X$123 3 6 M3_M2_CDNS_40661956134221
* cell instance $124 r0 *1 30.68,235.5
X$124 3 7 M3_M2_CDNS_40661956134221
* cell instance $125 r0 *1 44.21,235.5
X$125 3 8 M3_M2_CDNS_40661956134221
* cell instance $126 r0 *1 56.06,235.5
X$126 3 9 M3_M2_CDNS_40661956134221
* cell instance $127 r0 *1 68.835,235.5
X$127 3 10 M3_M2_CDNS_40661956134119
* cell instance $128 r0 *1 18.83,239.19
X$128 3 6 M2_M1_CDNS_40661956134210
* cell instance $129 r0 *1 30.68,239.19
X$129 3 7 M2_M1_CDNS_40661956134210
* cell instance $130 m90 *1 44.21,239.19
X$130 3 8 M2_M1_CDNS_40661956134210
* cell instance $131 m90 *1 56.06,239.19
X$131 3 9 M2_M1_CDNS_40661956134210
* cell instance $132 r0 *1 18.83,262.19
X$132 3 6 M2_M1_CDNS_40661956134210
* cell instance $133 r0 *1 30.68,262.19
X$133 3 7 M2_M1_CDNS_40661956134210
* cell instance $134 m90 *1 44.21,262.19
X$134 3 8 M2_M1_CDNS_40661956134210
* cell instance $135 m90 *1 56.06,262.19
X$135 3 9 M2_M1_CDNS_40661956134210
* cell instance $136 r0 *1 68.835,251.5
X$136 3 10 M3_M2_CDNS_40661956134119
* cell instance $137 r0 *1 15.695,250.69
X$137 14 13 M1_PSUB_CDNS_40661956134203
* cell instance $138 r0 *1 37.445,241.35
X$138 14 13 M1_PSUB_CDNS_40661956134202
* cell instance $139 r0 *1 37.445,242.12
X$139 14 13 M1_PSUB_CDNS_40661956134200
* cell instance $140 r0 *1 37.445,250.69
X$140 14 13 M1_PSUB_CDNS_40661956134201
* cell instance $141 r0 *1 37.445,255.36
X$141 14 13 M1_PSUB_CDNS_40661956134201
* cell instance $142 r0 *1 37.445,246.02
X$142 14 13 M1_PSUB_CDNS_40661956134201
* cell instance $143 m0 *1 37.445,259.26
X$143 14 13 M1_PSUB_CDNS_40661956134200
* cell instance $144 r0 *1 37.445,249.92
X$144 14 13 M1_PSUB_CDNS_40661956134200
* cell instance $145 r0 *1 37.445,245.25
X$145 14 13 M1_PSUB_CDNS_40661956134200
* cell instance $146 r0 *1 37.445,246.79
X$146 14 13 M1_PSUB_CDNS_40661956134200
* cell instance $147 r0 *1 37.445,254.59
X$147 14 13 M1_PSUB_CDNS_40661956134200
* cell instance $148 r0 *1 37.445,256.13
X$148 14 13 M1_PSUB_CDNS_40661956134200
* cell instance $149 r0 *1 37.445,251.46
X$149 14 13 M1_PSUB_CDNS_40661956134200
* cell instance $150 m0 *1 37.445,260.03
X$150 14 13 M1_PSUB_CDNS_40661956134202
* cell instance $151 m90 *1 59.195,250.69
X$151 14 13 M1_PSUB_CDNS_40661956134203
* cell instance $152 m90 *1 58.425,248.355
X$152 14 13 M1_PSUB_CDNS_40661956134199
* cell instance $153 m90 *1 58.425,243.685
X$153 14 13 M1_PSUB_CDNS_40661956134199
* cell instance $154 m90 *1 58.425,257.695
X$154 14 13 M1_PSUB_CDNS_40661956134199
* cell instance $155 m90 *1 58.425,253.025
X$155 14 13 M1_PSUB_CDNS_40661956134199
* cell instance $156 r0 *1 16.465,257.695
X$156 14 13 M1_PSUB_CDNS_40661956134199
* cell instance $157 r0 *1 16.465,253.025
X$157 14 13 M1_PSUB_CDNS_40661956134199
* cell instance $158 r0 *1 16.465,243.685
X$158 14 13 M1_PSUB_CDNS_40661956134199
* cell instance $159 r0 *1 16.465,248.355
X$159 14 13 M1_PSUB_CDNS_40661956134199
* cell instance $160 r0 *1 1.895,275.775
X$160 14 19 M1_PSUB_CDNS_40661956134197
* cell instance $161 r0 *1 72.995,275.775
X$161 14 19 M1_PSUB_CDNS_40661956134197
* cell instance $162 r0 *1 24.755,255.36
X$162 14 23 M2_M1_CDNS_40661956134216
* cell instance $163 m90 *1 37.445,255.36
X$163 14 24 M2_M1_CDNS_40661956134220
* cell instance $164 m90 *1 50.135,255.36
X$164 14 25 M2_M1_CDNS_40661956134216
* cell instance $165 r0 *1 24.755,250.69
X$165 14 23 M2_M1_CDNS_40661956134216
* cell instance $166 m90 *1 37.445,250.69
X$166 14 24 M2_M1_CDNS_40661956134220
* cell instance $167 m90 *1 50.135,250.69
X$167 14 25 M2_M1_CDNS_40661956134216
* cell instance $168 r0 *1 24.755,241.735
X$168 14 23 M2_M1_CDNS_40661956134209
* cell instance $169 r0 *1 24.755,243.5
X$169 14 23 M3_M2_CDNS_40661956134223
* cell instance $170 m90 *1 37.445,241.735
X$170 14 24 M2_M1_CDNS_40661956134215
* cell instance $171 r0 *1 37.445,243.5
X$171 14 24 M3_M2_CDNS_40661956134225
* cell instance $172 m90 *1 50.135,241.735
X$172 14 25 M2_M1_CDNS_40661956134209
* cell instance $173 r0 *1 50.135,243.5
X$173 14 25 M3_M2_CDNS_40661956134223
* cell instance $174 r0 *1 24.755,246.02
X$174 14 23 M2_M1_CDNS_40661956134216
* cell instance $175 m90 *1 37.445,246.02
X$175 14 24 M2_M1_CDNS_40661956134220
* cell instance $176 m90 *1 50.135,246.02
X$176 14 25 M2_M1_CDNS_40661956134216
* cell instance $177 r0 *1 24.755,259.645
X$177 14 23 M2_M1_CDNS_40661956134209
* cell instance $178 m90 *1 37.445,259.645
X$178 14 24 M2_M1_CDNS_40661956134215
* cell instance $179 m90 *1 50.135,259.645
X$179 14 25 M2_M1_CDNS_40661956134209
* cell instance $180 r0 *1 61.985,243.5
X$180 14 26 M3_M2_CDNS_40661956134223
* cell instance $181 r0 *1 12.905,243.5
X$181 14 20 M3_M2_CDNS_40661956134223
* cell instance $182 r0 *1 12.905,15.5
X$182 14 20 M3_M2_CDNS_40661956134226
* cell instance $183 r0 *1 24.755,15.5
X$183 14 23 M3_M2_CDNS_40661956134226
* cell instance $184 r0 *1 37.445,15.5
X$184 14 24 M3_M2_CDNS_40661956134227
* cell instance $185 r0 *1 50.135,15.5
X$185 14 25 M3_M2_CDNS_40661956134226
* cell instance $186 r0 *1 61.985,15.5
X$186 14 26 M3_M2_CDNS_40661956134226
* cell instance $187 r0 *1 12.905,47.5
X$187 14 20 M3_M2_CDNS_40661956134226
* cell instance $188 r0 *1 12.905,31.5
X$188 14 20 M3_M2_CDNS_40661956134226
* cell instance $189 r0 *1 24.755,47.5
X$189 14 23 M3_M2_CDNS_40661956134226
* cell instance $190 r0 *1 24.755,31.5
X$190 14 23 M3_M2_CDNS_40661956134226
* cell instance $191 r0 *1 37.445,31.5
X$191 14 24 M3_M2_CDNS_40661956134227
* cell instance $192 r0 *1 37.445,47.5
X$192 14 24 M3_M2_CDNS_40661956134227
* cell instance $193 r0 *1 50.135,31.5
X$193 14 25 M3_M2_CDNS_40661956134226
* cell instance $194 r0 *1 50.135,47.5
X$194 14 25 M3_M2_CDNS_40661956134226
* cell instance $195 r0 *1 61.985,31.5
X$195 14 26 M3_M2_CDNS_40661956134226
* cell instance $196 r0 *1 61.985,47.5
X$196 14 26 M3_M2_CDNS_40661956134226
* cell instance $197 r0 *1 12.905,67.5
X$197 14 20 M3_M2_CDNS_40661956134223
* cell instance $198 r0 *1 24.755,67.5
X$198 14 23 M3_M2_CDNS_40661956134223
* cell instance $199 r0 *1 37.445,67.5
X$199 14 24 M3_M2_CDNS_40661956134225
* cell instance $200 r0 *1 50.135,67.5
X$200 14 25 M3_M2_CDNS_40661956134223
* cell instance $201 r0 *1 61.985,67.5
X$201 14 26 M3_M2_CDNS_40661956134223
* cell instance $202 r0 *1 12.905,139.5
X$202 14 20 M3_M2_CDNS_40661956134223
* cell instance $203 r0 *1 24.755,139.5
X$203 14 23 M3_M2_CDNS_40661956134223
* cell instance $204 r0 *1 37.445,139.5
X$204 14 24 M3_M2_CDNS_40661956134225
* cell instance $205 r0 *1 50.135,139.5
X$205 14 25 M3_M2_CDNS_40661956134223
* cell instance $206 r0 *1 61.985,139.5
X$206 14 26 M3_M2_CDNS_40661956134223
* cell instance $207 r0 *1 12.905,175.5
X$207 14 20 M3_M2_CDNS_40661956134226
* cell instance $208 r0 *1 24.755,175.5
X$208 14 23 M3_M2_CDNS_40661956134226
* cell instance $209 r0 *1 37.445,175.5
X$209 14 24 M3_M2_CDNS_40661956134227
* cell instance $210 r0 *1 50.135,175.5
X$210 14 25 M3_M2_CDNS_40661956134226
* cell instance $211 r0 *1 61.985,175.5
X$211 14 26 M3_M2_CDNS_40661956134226
* cell instance $212 r0 *1 12.905,227.5
X$212 14 20 M3_M2_CDNS_40661956134223
* cell instance $213 r0 *1 24.755,227.5
X$213 14 23 M3_M2_CDNS_40661956134223
* cell instance $214 r0 *1 37.445,227.5
X$214 14 24 M3_M2_CDNS_40661956134225
* cell instance $215 r0 *1 50.135,227.5
X$215 14 25 M3_M2_CDNS_40661956134223
* cell instance $216 r0 *1 61.985,227.5
X$216 14 26 M3_M2_CDNS_40661956134223
* cell instance $217 r0 *1 12.905,285.41
X$217 14 20 M2_M1_CDNS_40661956134218
* cell instance $218 r0 *1 37.445,285.41
X$218 14 19 M1_PSUB_CDNS_40661956134198
* cell instance $219 r0 *1 12.905,283.195
X$219 14 20 M3_M2_CDNS_40661956134180
* cell instance $220 r0 *1 24.755,285.41
X$220 14 23 M2_M1_CDNS_40661956134218
* cell instance $221 r0 *1 24.755,283.195
X$221 14 23 M3_M2_CDNS_40661956134180
* cell instance $222 r0 *1 37.445,285.41
X$222 14 24 M2_M1_CDNS_40661956134217
* cell instance $223 r0 *1 37.445,283.195
X$223 14 24 M3_M2_CDNS_40661956134224
* cell instance $224 r0 *1 50.135,285.41
X$224 14 25 M2_M1_CDNS_40661956134218
* cell instance $225 r0 *1 50.135,283.195
X$225 14 25 M3_M2_CDNS_40661956134180
* cell instance $226 r0 *1 61.985,285.41
X$226 14 26 M2_M1_CDNS_40661956134218
* cell instance $227 r0 *1 61.985,283.195
X$227 14 26 M3_M2_CDNS_40661956134180
* cell instance $228 r0 *1 12.905,266.75
X$228 14 20 M2_M1_CDNS_40661956134206
* cell instance $229 r0 *1 37.445,266.14
X$229 14 19 M1_PSUB_CDNS_40661956134198
* cell instance $230 r0 *1 12.905,267.5
X$230 14 20 M3_M2_CDNS_40661956134223
* cell instance $231 r0 *1 24.755,266.75
X$231 14 23 M2_M1_CDNS_40661956134206
* cell instance $232 r0 *1 24.755,267.5
X$232 14 23 M3_M2_CDNS_40661956134223
* cell instance $233 r0 *1 37.445,266.75
X$233 14 24 M2_M1_CDNS_40661956134207
* cell instance $234 r0 *1 37.445,267.5
X$234 14 24 M3_M2_CDNS_40661956134225
* cell instance $235 r0 *1 50.135,266.75
X$235 14 25 M2_M1_CDNS_40661956134206
* cell instance $236 r0 *1 50.135,267.5
X$236 14 25 M3_M2_CDNS_40661956134223
* cell instance $237 r0 *1 61.985,266.75
X$237 14 26 M2_M1_CDNS_40661956134206
* cell instance $238 r0 *1 61.985,267.5
X$238 14 26 M3_M2_CDNS_40661956134223
* cell instance $239 r0 *1 68.685,250.69
X$239 15 M1_PSUB_CDNS_40661956134230
* cell instance $240 r0 *1 74.65,259.5
X$240 15 27 M3_M2_CDNS_40661956134114
* cell instance $241 r0 *1 74.65,259.5
X$241 15 27 M2_M1_CDNS_40661956134115
* cell instance $242 r0 *1 6.205,250.69
X$242 16 M1_PSUB_CDNS_40661956134230
* cell instance $243 r0 *1 0.24,259.5
X$243 16 18 M2_M1_CDNS_40661956134115
* cell instance $244 r0 *1 0.24,259.5
X$244 16 18 M3_M2_CDNS_40661956134114
* cell instance $245 r0 *1 11.585,187.565
X$245 22 21 M3_M2_CDNS_40661956134219
* cell instance $246 r0 *1 11.585,259.495
X$246 22 21 M3_M2_CDNS_40661956134219
.ENDS GF_NI_DVDD_BASE

* cell M2_M1_CDNS_40661956134168
* pin
* pin
.SUBCKT M2_M1_CDNS_40661956134168 1 2
.ENDS M2_M1_CDNS_40661956134168

* cell M2_M1_CDNS_40661956134169
* pin
* pin
.SUBCKT M2_M1_CDNS_40661956134169 1 2
.ENDS M2_M1_CDNS_40661956134169

* cell M3_M2_CDNS_40661956134170
* pin
* pin
.SUBCKT M3_M2_CDNS_40661956134170 1 2
.ENDS M3_M2_CDNS_40661956134170

* cell M3_M2_CDNS_40661956134171
* pin
* pin
.SUBCKT M3_M2_CDNS_40661956134171 1 2
.ENDS M3_M2_CDNS_40661956134171

* cell M1_PSUB_CDNS_40661956134167
* pin
* pin
.SUBCKT M1_PSUB_CDNS_40661956134167 1 2
.ENDS M1_PSUB_CDNS_40661956134167

* cell GF_NI_DVSS_BASE
* pin
* pin
* pin
* pin DVSS
* pin
* pin
* pin
* pin
* pin
* pin DVDD
* pin
* pin
* pin VDD
* pin
* pin
* pin
* pin
* pin
* pin
* pin
* pin
* pin
* pin
* pin
* pin
* pin gf180mcu_gnd
.SUBCKT GF_NI_DVSS_BASE 1 3 4 5 6 7 8 9 10 16 23 24 25 26 29 31 34 36 38 40 41
+ 42 50 51 52 55
* net 5 DVSS
* net 16 DVDD
* net 25 VDD
* net 55 gf180mcu_gnd
* cell instance $1 r0 *1 0.24,15.5
X$1 1 2 M3_M2_CDNS_40661956134259
* cell instance $2 r0 *1 0.24,15.5
X$2 1 2 M2_M1_CDNS_40661956134258
* cell instance $3 r0 *1 0.24,175.5
X$3 1 21 M2_M1_CDNS_40661956134258
* cell instance $4 r0 *1 0.24,175.5
X$4 1 21 M3_M2_CDNS_40661956134259
* cell instance $5 r0 *1 0.24,47.5
X$5 1 14 M2_M1_CDNS_40661956134258
* cell instance $6 r0 *1 0.24,47.5
X$6 1 14 M3_M2_CDNS_40661956134259
* cell instance $7 r0 *1 0.24,31.5
X$7 1 12 M3_M2_CDNS_40661956134259
* cell instance $8 r0 *1 0.24,31.5
X$8 1 12 M2_M1_CDNS_40661956134258
* cell instance $9 r0 *1 2.455,109.62
X$9 1 M1_PSUB_CDNS_40661956134229
* cell instance $10 r0 *1 0.24,67.5
X$10 1 17 M2_M1_CDNS_40661956134115
* cell instance $11 r0 *1 0.24,67.5
X$11 1 17 M3_M2_CDNS_40661956134114
* cell instance $12 r0 *1 0.24,187.5
X$12 1 23 M3_M2_CDNS_40661956134114
* cell instance $13 r0 *1 0.24,187.5
X$13 1 23 M2_M1_CDNS_40661956134115
* cell instance $14 r0 *1 0.24,139.5
X$14 1 19 M3_M2_CDNS_40661956134114
* cell instance $15 r0 *1 0.24,139.5
X$15 1 19 M2_M1_CDNS_40661956134115
* cell instance $16 r0 *1 74.65,47.5
X$16 3 15 M2_M1_CDNS_40661956134258
* cell instance $17 r0 *1 74.65,47.5
X$17 3 15 M3_M2_CDNS_40661956134259
* cell instance $18 r0 *1 74.65,31.5
X$18 3 13 M2_M1_CDNS_40661956134258
* cell instance $19 r0 *1 74.65,31.5
X$19 3 13 M3_M2_CDNS_40661956134259
* cell instance $20 r0 *1 74.65,175.5
X$20 3 22 M3_M2_CDNS_40661956134259
* cell instance $21 r0 *1 74.65,175.5
X$21 3 22 M2_M1_CDNS_40661956134258
* cell instance $22 r0 *1 74.65,15.5
X$22 3 11 M3_M2_CDNS_40661956134259
* cell instance $23 r0 *1 74.65,15.5
X$23 3 11 M2_M1_CDNS_40661956134258
* cell instance $24 m90 *1 67.48,174.62
X$24 3 M1_PSUB_CDNS_40661956134228
* cell instance $25 m90 *1 72.435,109.62
X$25 3 M1_PSUB_CDNS_40661956134229
* cell instance $26 r0 *1 74.65,67.5
X$26 3 18 M2_M1_CDNS_40661956134115
* cell instance $27 r0 *1 74.65,67.5
X$27 3 18 M3_M2_CDNS_40661956134114
* cell instance $28 r0 *1 74.65,139.5
X$28 3 20 M2_M1_CDNS_40661956134115
* cell instance $29 r0 *1 74.65,139.5
X$29 3 20 M3_M2_CDNS_40661956134114
* cell instance $30 r0 *1 74.65,187.5
X$30 3 24 M2_M1_CDNS_40661956134115
* cell instance $31 r0 *1 74.65,187.5
X$31 3 24 M3_M2_CDNS_40661956134114
* cell instance $32 r0 *1 6.055,15.5
X$32 5 4 M3_M2_CDNS_40661956134156
* cell instance $33 r0 *1 5.04,5.45
X$33 5 38 4 45 46 6 7 48 8 47 9 49 10 55 comp018green_esd_clamp_v5p0_DVSS
* cell instance $34 r0 *1 6.055,31.5
X$34 5 4 M3_M2_CDNS_40661956134156
* cell instance $35 r0 *1 6.055,47.5
X$35 5 4 M3_M2_CDNS_40661956134156
* cell instance $36 r0 *1 6.055,67.5
X$36 5 4 M3_M2_CDNS_40661956134119
* cell instance $37 r0 *1 6.055,139.5
X$37 5 4 M3_M2_CDNS_40661956134119
* cell instance $38 r0 *1 6.055,175.5
X$38 5 4 M3_M2_CDNS_40661956134156
* cell instance $39 r0 *1 6.055,187.5
X$39 5 4 M3_M2_CDNS_40661956134119
* cell instance $40 r0 *1 6.055,227.5
X$40 5 4 M3_M2_CDNS_40661956134119
* cell instance $41 r0 *1 6.055,267.5
X$41 5 4 M3_M2_CDNS_40661956134119
* cell instance $42 r0 *1 7.445,266.745
X$42 5 4 M2_M1_CDNS_40661956134253
* cell instance $43 r0 *1 2.905,274.715
X$43 5 4 M2_M1_CDNS_40661956134264
* cell instance $44 r0 *1 6.055,283.195
X$44 5 4 M3_M2_CDNS_40661956134257
* cell instance $45 r0 *1 6.055,285.39
X$45 5 4 M2_M1_CDNS_40661956134252
* cell instance $46 r0 *1 6.055,243.5
X$46 5 4 M3_M2_CDNS_40661956134119
* cell instance $47 r0 *1 6.055,259.5
X$47 5 4 M3_M2_CDNS_40661956134119
* cell instance $48 r0 *1 6.055,287.365
X$48 5 4 M2_M1_CDNS_40661956134140
* cell instance $49 r0 *1 6.055,3.96
X$49 5 4 M2_M1_CDNS_40661956134140
* cell instance $50 r0 *1 18.83,243.5
X$50 5 6 M3_M2_CDNS_40661956134221
* cell instance $51 r0 *1 19.715,246.02
X$51 5 6 M2_M1_CDNS_40661956134251
* cell instance $52 r0 *1 15.695,250.69
X$52 5 30 M1_PSUB_CDNS_40661956134203
* cell instance $53 r0 *1 19.715,241.735
X$53 5 6 M2_M1_CDNS_40661956134152
* cell instance $54 r0 *1 37.445,241.35
X$54 5 30 M1_PSUB_CDNS_40661956134202
* cell instance $55 r0 *1 16.465,243.685
X$55 5 30 M1_PSUB_CDNS_40661956134199
* cell instance $56 r0 *1 37.445,245.25
X$56 5 30 M1_PSUB_CDNS_40661956134200
* cell instance $57 r0 *1 37.445,242.12
X$57 5 30 M1_PSUB_CDNS_40661956134200
* cell instance $58 r0 *1 30.68,246.02
X$58 5 7 M2_M1_CDNS_40661956134247
* cell instance $59 r0 *1 30.68,241.735
X$59 5 7 M2_M1_CDNS_40661956134255
* cell instance $60 r0 *1 30.68,243.5
X$60 5 7 M3_M2_CDNS_40661956134221
* cell instance $61 r0 *1 44.21,241.735
X$61 5 8 M2_M1_CDNS_40661956134255
* cell instance $62 r0 *1 44.21,246.02
X$62 5 8 M2_M1_CDNS_40661956134247
* cell instance $63 m90 *1 44.21,243.5
X$63 5 8 M3_M2_CDNS_40661956134221
* cell instance $64 m90 *1 55.175,241.735
X$64 5 9 M2_M1_CDNS_40661956134152
* cell instance $65 m90 *1 55.175,246.02
X$65 5 9 M2_M1_CDNS_40661956134251
* cell instance $66 m90 *1 56.06,243.5
X$66 5 9 M3_M2_CDNS_40661956134221
* cell instance $67 m90 *1 58.425,243.685
X$67 5 30 M1_PSUB_CDNS_40661956134199
* cell instance $68 m90 *1 59.195,250.69
X$68 5 30 M1_PSUB_CDNS_40661956134203
* cell instance $69 r0 *1 19.715,255.36
X$69 5 6 M2_M1_CDNS_40661956134251
* cell instance $70 r0 *1 19.715,250.69
X$70 5 6 M2_M1_CDNS_40661956134251
* cell instance $71 r0 *1 37.445,250.69
X$71 5 30 M1_PSUB_CDNS_40661956134201
* cell instance $72 r0 *1 37.445,246.02
X$72 5 30 M1_PSUB_CDNS_40661956134201
* cell instance $73 r0 *1 37.445,251.46
X$73 5 30 M1_PSUB_CDNS_40661956134200
* cell instance $74 r0 *1 37.445,249.92
X$74 5 30 M1_PSUB_CDNS_40661956134200
* cell instance $75 r0 *1 37.445,254.59
X$75 5 30 M1_PSUB_CDNS_40661956134200
* cell instance $76 r0 *1 37.445,246.79
X$76 5 30 M1_PSUB_CDNS_40661956134200
* cell instance $77 r0 *1 30.68,250.69
X$77 5 7 M2_M1_CDNS_40661956134247
* cell instance $78 r0 *1 30.68,255.36
X$78 5 7 M2_M1_CDNS_40661956134247
* cell instance $79 r0 *1 44.21,255.36
X$79 5 8 M2_M1_CDNS_40661956134247
* cell instance $80 r0 *1 44.21,250.69
X$80 5 8 M2_M1_CDNS_40661956134247
* cell instance $81 m90 *1 55.175,255.36
X$81 5 9 M2_M1_CDNS_40661956134251
* cell instance $82 m90 *1 55.175,250.69
X$82 5 9 M2_M1_CDNS_40661956134251
* cell instance $83 r0 *1 37.445,255.36
X$83 5 30 M1_PSUB_CDNS_40661956134201
* cell instance $84 r0 *1 37.445,256.13
X$84 5 30 M1_PSUB_CDNS_40661956134200
* cell instance $85 r0 *1 19.715,259.645
X$85 5 6 M2_M1_CDNS_40661956134152
* cell instance $86 r0 *1 18.83,259.5
X$86 5 6 M3_M2_CDNS_40661956134221
* cell instance $87 m0 *1 37.445,260.03
X$87 5 30 M1_PSUB_CDNS_40661956134202
* cell instance $88 r0 *1 16.465,257.695
X$88 5 30 M1_PSUB_CDNS_40661956134199
* cell instance $89 m0 *1 37.445,259.26
X$89 5 30 M1_PSUB_CDNS_40661956134200
* cell instance $90 r0 *1 30.68,259.645
X$90 5 7 M2_M1_CDNS_40661956134255
* cell instance $91 r0 *1 30.68,259.5
X$91 5 7 M3_M2_CDNS_40661956134221
* cell instance $92 r0 *1 44.21,259.645
X$92 5 8 M2_M1_CDNS_40661956134255
* cell instance $93 m90 *1 44.21,259.5
X$93 5 8 M3_M2_CDNS_40661956134221
* cell instance $94 m90 *1 55.175,259.645
X$94 5 9 M2_M1_CDNS_40661956134152
* cell instance $95 m90 *1 56.06,259.5
X$95 5 9 M3_M2_CDNS_40661956134221
* cell instance $96 m90 *1 58.425,257.695
X$96 5 30 M1_PSUB_CDNS_40661956134199
* cell instance $97 m90 *1 58.425,248.355
X$97 5 30 M1_PSUB_CDNS_40661956134199
* cell instance $98 m90 *1 58.425,253.025
X$98 5 30 M1_PSUB_CDNS_40661956134199
* cell instance $99 r0 *1 16.465,253.025
X$99 5 30 M1_PSUB_CDNS_40661956134199
* cell instance $100 r0 *1 16.465,248.355
X$100 5 30 M1_PSUB_CDNS_40661956134199
* cell instance $101 r0 *1 18.83,15.5
X$101 5 6 M3_M2_CDNS_40661956134222
* cell instance $102 r0 *1 30.68,15.5
X$102 5 7 M3_M2_CDNS_40661956134222
* cell instance $103 m90 *1 44.21,15.5
X$103 5 8 M3_M2_CDNS_40661956134222
* cell instance $104 m90 *1 56.06,15.5
X$104 5 9 M3_M2_CDNS_40661956134222
* cell instance $105 m90 *1 68.835,15.5
X$105 5 10 M3_M2_CDNS_40661956134156
* cell instance $106 r0 *1 18.83,31.5
X$106 5 6 M3_M2_CDNS_40661956134222
* cell instance $107 r0 *1 30.68,31.5
X$107 5 7 M3_M2_CDNS_40661956134222
* cell instance $108 m90 *1 44.21,31.5
X$108 5 8 M3_M2_CDNS_40661956134222
* cell instance $109 m90 *1 56.06,31.5
X$109 5 9 M3_M2_CDNS_40661956134222
* cell instance $110 m90 *1 68.835,31.5
X$110 5 10 M3_M2_CDNS_40661956134156
* cell instance $111 r0 *1 18.83,47.5
X$111 5 6 M3_M2_CDNS_40661956134222
* cell instance $112 r0 *1 30.68,47.5
X$112 5 7 M3_M2_CDNS_40661956134222
* cell instance $113 m90 *1 44.21,47.5
X$113 5 8 M3_M2_CDNS_40661956134222
* cell instance $114 m90 *1 56.06,47.5
X$114 5 9 M3_M2_CDNS_40661956134222
* cell instance $115 m90 *1 68.835,47.5
X$115 5 10 M3_M2_CDNS_40661956134156
* cell instance $116 r0 *1 18.83,67.5
X$116 5 6 M3_M2_CDNS_40661956134221
* cell instance $117 r0 *1 30.68,67.5
X$117 5 7 M3_M2_CDNS_40661956134221
* cell instance $118 m90 *1 44.21,67.5
X$118 5 8 M3_M2_CDNS_40661956134221
* cell instance $119 m90 *1 56.06,67.5
X$119 5 9 M3_M2_CDNS_40661956134221
* cell instance $120 m90 *1 68.835,67.5
X$120 5 10 M3_M2_CDNS_40661956134119
* cell instance $121 r0 *1 18.83,139.5
X$121 5 6 M3_M2_CDNS_40661956134221
* cell instance $122 r0 *1 30.68,139.5
X$122 5 7 M3_M2_CDNS_40661956134221
* cell instance $123 m90 *1 44.21,139.5
X$123 5 8 M3_M2_CDNS_40661956134221
* cell instance $124 m90 *1 56.06,139.5
X$124 5 9 M3_M2_CDNS_40661956134221
* cell instance $125 m90 *1 68.835,139.5
X$125 5 10 M3_M2_CDNS_40661956134119
* cell instance $126 r0 *1 18.83,175.5
X$126 5 6 M3_M2_CDNS_40661956134222
* cell instance $127 r0 *1 30.68,175.5
X$127 5 7 M3_M2_CDNS_40661956134222
* cell instance $128 m90 *1 44.21,175.5
X$128 5 8 M3_M2_CDNS_40661956134222
* cell instance $129 m90 *1 56.06,175.5
X$129 5 9 M3_M2_CDNS_40661956134222
* cell instance $130 m90 *1 68.835,175.5
X$130 5 10 M3_M2_CDNS_40661956134156
* cell instance $131 r0 *1 18.83,187.5
X$131 5 6 M3_M2_CDNS_40661956134221
* cell instance $132 r0 *1 30.68,187.5
X$132 5 7 M3_M2_CDNS_40661956134221
* cell instance $133 m90 *1 44.21,187.5
X$133 5 8 M3_M2_CDNS_40661956134221
* cell instance $134 m90 *1 56.06,187.5
X$134 5 9 M3_M2_CDNS_40661956134221
* cell instance $135 m90 *1 68.835,187.5
X$135 5 10 M3_M2_CDNS_40661956134119
* cell instance $136 r0 *1 18.83,227.5
X$136 5 6 M3_M2_CDNS_40661956134221
* cell instance $137 r0 *1 30.68,227.5
X$137 5 7 M3_M2_CDNS_40661956134221
* cell instance $138 m90 *1 44.21,227.5
X$138 5 8 M3_M2_CDNS_40661956134221
* cell instance $139 m90 *1 56.06,227.5
X$139 5 9 M3_M2_CDNS_40661956134221
* cell instance $140 m90 *1 68.835,227.5
X$140 5 10 M3_M2_CDNS_40661956134119
* cell instance $141 m90 *1 68.835,243.5
X$141 5 10 M3_M2_CDNS_40661956134119
* cell instance $142 m90 *1 68.835,259.5
X$142 5 10 M3_M2_CDNS_40661956134119
* cell instance $143 r0 *1 37.445,266.14
X$143 5 44 M1_PSUB_CDNS_40661956134198
* cell instance $144 r0 *1 16.375,266.745
X$144 5 6 M2_M1_CDNS_40661956134145
* cell instance $145 r0 *1 18.83,267.5
X$145 5 6 M3_M2_CDNS_40661956134221
* cell instance $146 m90 *1 30.68,266.745
X$146 5 7 M2_M1_CDNS_40661956134247
* cell instance $147 r0 *1 30.68,267.5
X$147 5 7 M3_M2_CDNS_40661956134221
* cell instance $148 m90 *1 44.21,266.745
X$148 5 8 M2_M1_CDNS_40661956134247
* cell instance $149 m90 *1 44.21,267.5
X$149 5 8 M3_M2_CDNS_40661956134221
* cell instance $150 m90 *1 58.515,266.745
X$150 5 9 M2_M1_CDNS_40661956134145
* cell instance $151 m90 *1 56.06,267.5
X$151 5 9 M3_M2_CDNS_40661956134221
* cell instance $152 m90 *1 67.445,266.745
X$152 5 10 M2_M1_CDNS_40661956134253
* cell instance $153 m90 *1 68.835,267.5
X$153 5 10 M3_M2_CDNS_40661956134119
* cell instance $154 r0 *1 1.895,275.775
X$154 5 44 M1_PSUB_CDNS_40661956134197
* cell instance $155 r0 *1 4.175,268.275
X$155 5 38 nmoscap_6p0_CDNS_406619561348
* cell instance $156 r0 *1 20.265,274.715
X$156 5 6 M2_M1_CDNS_40661956134263
* cell instance $157 r0 *1 21.355,268.275
X$157 5 38 nmoscap_6p0_CDNS_406619561348
* cell instance $158 r0 *1 38.535,268.275
X$158 5 38 nmoscap_6p0_CDNS_406619561348
* cell instance $159 m90 *1 54.625,274.715
X$159 5 9 M2_M1_CDNS_40661956134263
* cell instance $160 r0 *1 55.715,268.275
X$160 5 38 nmoscap_6p0_CDNS_406619561348
* cell instance $161 m90 *1 71.985,274.715
X$161 5 10 M2_M1_CDNS_40661956134264
* cell instance $162 r0 *1 72.995,275.775
X$162 5 44 M1_PSUB_CDNS_40661956134197
* cell instance $163 r0 *1 37.445,285.41
X$163 5 44 M1_PSUB_CDNS_40661956134198
* cell instance $164 r0 *1 18.83,285.39
X$164 5 6 M2_M1_CDNS_40661956134249
* cell instance $165 r0 *1 18.83,283.195
X$165 5 6 M3_M2_CDNS_40661956134262
* cell instance $166 m90 *1 30.68,285.39
X$166 5 7 M2_M1_CDNS_40661956134249
* cell instance $167 r0 *1 30.68,283.195
X$167 5 7 M3_M2_CDNS_40661956134262
* cell instance $168 m90 *1 44.21,285.39
X$168 5 8 M2_M1_CDNS_40661956134249
* cell instance $169 m90 *1 44.21,283.195
X$169 5 8 M3_M2_CDNS_40661956134262
* cell instance $170 m90 *1 56.06,285.39
X$170 5 9 M2_M1_CDNS_40661956134249
* cell instance $171 m90 *1 56.06,283.195
X$171 5 9 M3_M2_CDNS_40661956134262
* cell instance $172 m90 *1 68.835,285.39
X$172 5 10 M2_M1_CDNS_40661956134252
* cell instance $173 m90 *1 68.835,283.195
X$173 5 10 M3_M2_CDNS_40661956134257
* cell instance $174 r0 *1 68.835,287.365
X$174 5 10 M2_M1_CDNS_40661956134140
* cell instance $175 r0 *1 18.83,287.365
X$175 5 6 M2_M1_CDNS_40661956134140
* cell instance $176 r0 *1 44.21,3.96
X$176 5 8 M2_M1_CDNS_40661956134140
* cell instance $177 r0 *1 68.835,3.96
X$177 5 10 M2_M1_CDNS_40661956134140
* cell instance $178 r0 *1 56.06,3.96
X$178 5 9 M2_M1_CDNS_40661956134140
* cell instance $179 r0 *1 18.83,3.96
X$179 5 6 M2_M1_CDNS_40661956134140
* cell instance $180 r0 *1 30.68,287.365
X$180 5 7 M2_M1_CDNS_40661956134140
* cell instance $181 r0 *1 56.06,287.365
X$181 5 9 M2_M1_CDNS_40661956134140
* cell instance $182 r0 *1 30.68,3.96
X$182 5 7 M2_M1_CDNS_40661956134140
* cell instance $183 r0 *1 44.21,287.365
X$183 5 8 M2_M1_CDNS_40661956134140
* cell instance $184 r0 *1 0.24,227.5
X$184 26 27 M2_M1_CDNS_40661956134115
* cell instance $185 r0 *1 0.24,227.5
X$185 26 27 M3_M2_CDNS_40661956134114
* cell instance $186 r0 *1 74.65,227.5
X$186 29 28 M3_M2_CDNS_40661956134114
* cell instance $187 r0 *1 74.65,227.5
X$187 29 28 M2_M1_CDNS_40661956134115
* cell instance $188 r0 *1 6.205,250.69
X$188 31 M1_PSUB_CDNS_40661956134230
* cell instance $189 r0 *1 0.24,243.5
X$189 31 32 M2_M1_CDNS_40661956134115
* cell instance $190 r0 *1 0.24,243.5
X$190 31 32 M3_M2_CDNS_40661956134114
* cell instance $191 r0 *1 0.24,259.5
X$191 31 41 M2_M1_CDNS_40661956134115
* cell instance $192 r0 *1 0.24,259.5
X$192 31 41 M3_M2_CDNS_40661956134114
* cell instance $193 r0 *1 74.65,243.5
X$193 34 33 M2_M1_CDNS_40661956134115
* cell instance $194 r0 *1 74.65,243.5
X$194 34 33 M3_M2_CDNS_40661956134114
* cell instance $195 m90 *1 68.685,250.69
X$195 34 M1_PSUB_CDNS_40661956134230
* cell instance $196 r0 *1 74.65,259.5
X$196 34 50 M2_M1_CDNS_40661956134115
* cell instance $197 r0 *1 74.65,259.5
X$197 34 50 M3_M2_CDNS_40661956134114
* cell instance $198 r0 *1 37.445,239.19
X$198 38 56 38 35 M1_NWELL_CDNS_40661956134205
* cell instance $199 r0 *1 37.445,262.19
X$199 38 56 38 35 M1_NWELL_CDNS_40661956134205
* cell instance $200 r0 *1 13.675,250.69
X$200 38 35 38 56 M1_NWELL_CDNS_40661956134204
* cell instance $201 r0 *1 61.215,250.69
X$201 38 35 38 56 M1_NWELL_CDNS_40661956134204
* cell instance $202 r0 *1 11.65,195.525
X$202 36 37 M3_M2_CDNS_40661956134219
* cell instance $203 r0 *1 11.65,251.52
X$203 36 37 M3_M2_CDNS_40661956134219
* cell instance $204 r0 *1 50.135,275.775
X$204 38 47 M2_M1_CDNS_40661956134254
* cell instance $205 m90 *1 50.135,275.5
X$205 38 47 M3_M2_CDNS_40661956134223
* cell instance $206 r0 *1 24.755,275.775
X$206 38 46 M2_M1_CDNS_40661956134254
* cell instance $207 r0 *1 24.755,275.5
X$207 38 46 M3_M2_CDNS_40661956134223
* cell instance $208 r0 *1 37.445,275.5
X$208 38 48 M3_M2_CDNS_40661956134225
* cell instance $209 m90 *1 61.985,275.5
X$209 38 49 M3_M2_CDNS_40661956134223
* cell instance $210 r0 *1 12.905,59.5
X$210 38 45 M3_M2_CDNS_40661956134223
* cell instance $211 r0 *1 24.755,59.5
X$211 38 46 M3_M2_CDNS_40661956134223
* cell instance $212 r0 *1 37.445,59.5
X$212 38 48 M3_M2_CDNS_40661956134225
* cell instance $213 m90 *1 50.135,59.5
X$213 38 47 M3_M2_CDNS_40661956134223
* cell instance $214 m90 *1 61.985,59.5
X$214 38 49 M3_M2_CDNS_40661956134223
* cell instance $215 r0 *1 12.905,111.5
X$215 38 45 M3_M2_CDNS_40661956134226
* cell instance $216 r0 *1 12.905,95.5
X$216 38 45 M3_M2_CDNS_40661956134226
* cell instance $217 r0 *1 12.905,79.5
X$217 38 45 M3_M2_CDNS_40661956134226
* cell instance $218 r0 *1 24.755,111.5
X$218 38 46 M3_M2_CDNS_40661956134226
* cell instance $219 r0 *1 24.755,95.5
X$219 38 46 M3_M2_CDNS_40661956134226
* cell instance $220 r0 *1 24.755,79.5
X$220 38 46 M3_M2_CDNS_40661956134226
* cell instance $221 r0 *1 37.445,79.5
X$221 38 48 M3_M2_CDNS_40661956134227
* cell instance $222 r0 *1 37.445,111.5
X$222 38 48 M3_M2_CDNS_40661956134227
* cell instance $223 r0 *1 37.445,95.5
X$223 38 48 M3_M2_CDNS_40661956134227
* cell instance $224 m90 *1 50.135,79.5
X$224 38 47 M3_M2_CDNS_40661956134226
* cell instance $225 m90 *1 50.135,95.5
X$225 38 47 M3_M2_CDNS_40661956134226
* cell instance $226 m90 *1 50.135,111.5
X$226 38 47 M3_M2_CDNS_40661956134226
* cell instance $227 m90 *1 61.985,79.5
X$227 38 49 M3_M2_CDNS_40661956134226
* cell instance $228 m90 *1 61.985,95.5
X$228 38 49 M3_M2_CDNS_40661956134226
* cell instance $229 m90 *1 61.985,111.5
X$229 38 49 M3_M2_CDNS_40661956134226
* cell instance $230 r0 *1 12.905,127.5
X$230 38 45 M3_M2_CDNS_40661956134226
* cell instance $231 r0 *1 24.755,127.5
X$231 38 46 M3_M2_CDNS_40661956134226
* cell instance $232 r0 *1 37.445,127.5
X$232 38 48 M3_M2_CDNS_40661956134227
* cell instance $233 m90 *1 50.135,127.5
X$233 38 47 M3_M2_CDNS_40661956134226
* cell instance $234 m90 *1 61.985,127.5
X$234 38 49 M3_M2_CDNS_40661956134226
* cell instance $235 r0 *1 12.905,147.5
X$235 38 45 M3_M2_CDNS_40661956134223
* cell instance $236 r0 *1 24.755,147.5
X$236 38 46 M3_M2_CDNS_40661956134223
* cell instance $237 r0 *1 37.445,147.5
X$237 38 48 M3_M2_CDNS_40661956134225
* cell instance $238 m90 *1 50.135,147.5
X$238 38 47 M3_M2_CDNS_40661956134223
* cell instance $239 m90 *1 61.985,147.5
X$239 38 49 M3_M2_CDNS_40661956134223
* cell instance $240 r0 *1 12.905,159.5
X$240 38 45 M3_M2_CDNS_40661956134226
* cell instance $241 r0 *1 24.755,159.5
X$241 38 46 M3_M2_CDNS_40661956134226
* cell instance $242 r0 *1 37.445,159.5
X$242 38 48 M3_M2_CDNS_40661956134227
* cell instance $243 m90 *1 50.135,159.5
X$243 38 47 M3_M2_CDNS_40661956134226
* cell instance $244 m90 *1 61.985,159.5
X$244 38 49 M3_M2_CDNS_40661956134226
* cell instance $245 r0 *1 12.905,203.5
X$245 38 45 M3_M2_CDNS_40661956134223
* cell instance $246 r0 *1 24.755,203.5
X$246 38 46 M3_M2_CDNS_40661956134223
* cell instance $247 r0 *1 37.445,203.5
X$247 38 48 M3_M2_CDNS_40661956134225
* cell instance $248 m90 *1 50.135,203.5
X$248 38 47 M3_M2_CDNS_40661956134223
* cell instance $249 m90 *1 61.985,203.5
X$249 38 49 M3_M2_CDNS_40661956134223
* cell instance $250 r0 *1 12.905,219.5
X$250 38 45 M3_M2_CDNS_40661956134223
* cell instance $251 r0 *1 12.905,211.5
X$251 38 45 M3_M2_CDNS_40661956134223
* cell instance $252 r0 *1 24.755,219.5
X$252 38 46 M3_M2_CDNS_40661956134223
* cell instance $253 r0 *1 24.755,211.5
X$253 38 46 M3_M2_CDNS_40661956134223
* cell instance $254 r0 *1 37.445,219.5
X$254 38 48 M3_M2_CDNS_40661956134225
* cell instance $255 r0 *1 37.445,211.5
X$255 38 48 M3_M2_CDNS_40661956134225
* cell instance $256 m90 *1 50.135,211.5
X$256 38 47 M3_M2_CDNS_40661956134223
* cell instance $257 m90 *1 50.135,219.5
X$257 38 47 M3_M2_CDNS_40661956134223
* cell instance $258 m90 *1 61.985,211.5
X$258 38 49 M3_M2_CDNS_40661956134223
* cell instance $259 m90 *1 61.985,219.5
X$259 38 49 M3_M2_CDNS_40661956134223
* cell instance $260 r0 *1 12.905,235.5
X$260 38 45 M3_M2_CDNS_40661956134223
* cell instance $261 r0 *1 13.08,250.69
X$261 38 45 M2_M1_CDNS_40661956134256
* cell instance $262 r0 *1 24.755,235.5
X$262 38 46 M3_M2_CDNS_40661956134223
* cell instance $263 r0 *1 37.445,235.5
X$263 38 48 M3_M2_CDNS_40661956134225
* cell instance $264 m90 *1 50.135,235.5
X$264 38 47 M3_M2_CDNS_40661956134223
* cell instance $265 m90 *1 61.985,235.5
X$265 38 49 M3_M2_CDNS_40661956134223
* cell instance $266 r0 *1 61.81,250.69
X$266 38 49 M2_M1_CDNS_40661956134256
* cell instance $267 r0 *1 24.755,239.19
X$267 38 46 M2_M1_CDNS_40661956134206
* cell instance $268 r0 *1 37.445,239.19
X$268 38 48 M2_M1_CDNS_40661956134207
* cell instance $269 r0 *1 50.135,239.19
X$269 38 47 M2_M1_CDNS_40661956134206
* cell instance $270 r0 *1 12.905,275.5
X$270 38 45 M3_M2_CDNS_40661956134223
* cell instance $271 r0 *1 24.755,253.025
X$271 38 46 M2_M1_CDNS_40661956134126
* cell instance $272 r0 *1 17.445,252.525
X$272 38 np_6p0_CDNS_406619561349
* cell instance $273 r0 *1 37.445,253.025
X$273 38 48 M2_M1_CDNS_40661956134250
* cell instance $274 r0 *1 50.135,253.025
X$274 38 47 M2_M1_CDNS_40661956134126
* cell instance $275 r0 *1 24.755,248.355
X$275 38 46 M2_M1_CDNS_40661956134126
* cell instance $276 r0 *1 17.445,247.855
X$276 38 np_6p0_CDNS_406619561349
* cell instance $277 r0 *1 37.445,248.355
X$277 38 48 M2_M1_CDNS_40661956134250
* cell instance $278 r0 *1 50.135,248.355
X$278 38 47 M2_M1_CDNS_40661956134126
* cell instance $279 r0 *1 24.755,257.695
X$279 38 46 M2_M1_CDNS_40661956134126
* cell instance $280 r0 *1 17.445,257.195
X$280 38 np_6p0_CDNS_406619561349
* cell instance $281 r0 *1 37.445,257.695
X$281 38 48 M2_M1_CDNS_40661956134250
* cell instance $282 r0 *1 50.135,257.695
X$282 38 47 M2_M1_CDNS_40661956134126
* cell instance $283 r0 *1 24.755,243.685
X$283 38 46 M2_M1_CDNS_40661956134126
* cell instance $284 r0 *1 17.445,243.185
X$284 38 np_6p0_CDNS_406619561349
* cell instance $285 r0 *1 37.445,243.685
X$285 38 48 M2_M1_CDNS_40661956134250
* cell instance $286 r0 *1 50.135,243.685
X$286 38 47 M2_M1_CDNS_40661956134126
* cell instance $287 r0 *1 61.985,267.975
X$287 38 49 M2_M1_CDNS_40661956134218
* cell instance $288 r0 *1 61.985,283.575
X$288 38 49 M2_M1_CDNS_40661956134218
* cell instance $289 r0 *1 12.905,267.975
X$289 38 45 M2_M1_CDNS_40661956134218
* cell instance $290 r0 *1 12.905,283.575
X$290 38 45 M2_M1_CDNS_40661956134218
* cell instance $291 r0 *1 24.755,262.19
X$291 38 46 M2_M1_CDNS_40661956134206
* cell instance $292 r0 *1 37.445,262.19
X$292 38 48 M2_M1_CDNS_40661956134207
* cell instance $293 r0 *1 50.135,262.19
X$293 38 47 M2_M1_CDNS_40661956134206
* cell instance $294 r0 *1 0.24,267.5
X$294 40 39 M3_M2_CDNS_40661956134114
* cell instance $295 r0 *1 0.24,267.5
X$295 40 39 M2_M1_CDNS_40661956134115
* cell instance $296 r0 *1 0.24,283.195
X$296 42 43 M2_M1_CDNS_40661956134261
* cell instance $297 r0 *1 0.24,283.195
X$297 42 43 M3_M2_CDNS_40661956134260
* cell instance $298 r0 *1 74.65,283.195
X$298 51 54 M3_M2_CDNS_40661956134260
* cell instance $299 r0 *1 74.65,283.195
X$299 51 54 M2_M1_CDNS_40661956134261
* cell instance $300 r0 *1 74.65,267.5
X$300 52 53 M3_M2_CDNS_40661956134114
* cell instance $301 r0 *1 74.65,267.5
X$301 52 53 M2_M1_CDNS_40661956134115
.ENDS GF_NI_DVSS_BASE

* cell GF_NI_IN_C_BASE
* pin
* pin
* pin
* pin PAD
* pin
* pin
* pin
* pin
* pin
* pin
* pin
* pin
* pin
* pin
* pin
* pin
* pin
* pin
* pin
* pin
* pin
* pin
* pin PU
* pin
* pin PD
* pin
* pin
* pin
* pin
* pin Y
* pin
* pin gf180mcu_gnd
* pin
* pin
* pin
* pin
* pin
* pin
* pin
* pin
* pin
* pin
* pin
* pin
* pin
* pin
* pin
* pin
* pin
* pin
.SUBCKT GF_NI_IN_C_BASE 1 3 4 14 44 76 79 80 81 83 86 87 88 89 94 98 100 106
+ 109 111 115 116 117 121 126 130 136 138 141 142 146 151 152 153 154 155 156
+ 157 158 159 160 161 162 163 164 165 204 210 227 278
* net 6 ndrive_x_<0>
* net 7 ndrive_y_<0>
* net 8 ndrive_x_<1>
* net 9 ndrive_Y_<1>
* net 10 pdrive_x_<0>
* net 11 pdrive_y_<0>
* net 12 pdrive_y_<1>
* net 13 pdrive_x_<1>
* net 14 PAD
* net 15 pdrive_x_<2>
* net 16 pdrive_y_<2>
* net 17 pdrive_y_<3>
* net 18 pdrive_x_<3>
* net 19 ndrive_x_<2>
* net 20 ndrive_y_<2>
* net 21 ndrive_x_<3>
* net 22 ndrive_Y_<3>
* net 117 PU
* net 126 PD
* net 142 Y
* net 151 gf180mcu_gnd
* cell instance $1 m90 *1 1.17,30.87
X$1 1 M1_PSUB_CDNS_40661956134442
* cell instance $2 r0 *1 37.51,5.605
X$2 1 M1_PSUB_CDNS_40661956134441
* cell instance $3 r0 *1 73.84,30.87
X$3 1 M1_PSUB_CDNS_40661956134442
* cell instance $4 r0 *1 74.9,259.465
X$4 1 116 M2_M1_CDNS_40661956134242
* cell instance $5 r0 *1 74.9,259.465
X$5 1 116 M3_M2_CDNS_40661956134314
* cell instance $6 r0 *1 74.9,187.465
X$6 1 80 M2_M1_CDNS_40661956134240
* cell instance $7 r0 *1 74.9,187.465
X$7 1 80 M3_M2_CDNS_40661956134284
* cell instance $8 r0 *1 0.42,187.465
X$8 1 79 M2_M1_CDNS_40661956134240
* cell instance $9 r0 *1 0.42,187.5
X$9 1 79 M3_M2_CDNS_40661956134284
* cell instance $10 r0 *1 0.42,259.465
X$10 1 115 M2_M1_CDNS_40661956134240
* cell instance $11 r0 *1 0.42,259.5
X$11 1 115 M3_M2_CDNS_40661956134284
* cell instance $12 r0 *1 3.97,7.325
X$12 33 30 24 23 36 32 29 31 106 4 9 8 7 6 19 20 21 22 14 157 151 163 162 161
+ 160 159 158 156 155 154 18 18 17 16 15 15 13 13 12 11 10 10 3 2 2 5
+ comp018green_out_paddrv_16T
* cell instance $13 r0 *1 1.37,139.5
X$13 3 2 M3_M2_CDNS_40661956134313
* cell instance $14 r0 *1 1.37,15.5
X$14 3 2 M3_M2_CDNS_40661956134312
* cell instance $15 r0 *1 1.37,31.5
X$15 3 2 M3_M2_CDNS_40661956134312
* cell instance $16 r0 *1 1.37,47.5
X$16 3 2 M3_M2_CDNS_40661956134312
* cell instance $17 r0 *1 1.37,175.5
X$17 3 2 M3_M2_CDNS_40661956134312
* cell instance $18 r0 *1 72.36,240.47
X$18 4 5 M2_M1_CDNS_40661956134436
* cell instance $19 r0 *1 72.36,245.31
X$19 4 5 M2_M1_CDNS_40661956134436
* cell instance $20 r0 *1 72.9,127.5
X$20 4 5 M3_M2_CDNS_40661956134311
* cell instance $21 r0 *1 72.9,95.5
X$21 4 5 M3_M2_CDNS_40661956134311
* cell instance $22 r0 *1 72.9,111.5
X$22 4 5 M3_M2_CDNS_40661956134311
* cell instance $23 r0 *1 72.9,79.5
X$23 4 5 M3_M2_CDNS_40661956134311
* cell instance $24 m0 *1 2.395,179.845
X$24 44 10 271 54 57 55 44 11 59 6 7 251 4 269 53 268 4 267 151 62 52
+ comp018green_out_predrv
* cell instance $25 r180 *1 37.885,179.845
X$25 44 13 271 63 66 55 44 12 59 8 9 250 4 269 53 268 4 267 151 68 72
+ comp018green_out_predrv
* cell instance $26 m0 *1 37.435,179.845
X$26 44 15 271 63 66 55 44 16 59 19 20 252 4 270 53 268 4 267 151 60 70
+ comp018green_out_predrv
* cell instance $27 r180 *1 72.925,179.845
X$27 44 18 271 47 49 55 44 17 59 21 22 253 4 270 53 268 4 267 151 61 78
+ comp018green_out_predrv
* cell instance $28 r0 *1 2.62,159.765
X$28 4 280 M2_M1_CDNS_40661956134236
* cell instance $29 r0 *1 13.31,150.405
X$29 4 272 M2_M1_CDNS_40661956134309
* cell instance $30 r0 *1 13.31,150.405
X$30 4 272 M3_M2_CDNS_40661956134310
* cell instance $31 r0 *1 62.995,150.405
X$31 4 273 M2_M1_CDNS_40661956134309
* cell instance $32 r0 *1 62.995,150.405
X$32 4 273 M3_M2_CDNS_40661956134310
* cell instance $33 r0 *1 72.7,159.765
X$33 4 5 M2_M1_CDNS_40661956134236
* cell instance $34 r0 *1 72.9,147.5
X$34 4 5 M3_M2_CDNS_40661956134285
* cell instance $35 r0 *1 2.62,159.5
X$35 4 280 M3_M2_CDNS_40661956134304
* cell instance $36 r0 *1 5.03,157.86
X$36 4 275 M2_M1_CDNS_40661956134305
* cell instance $37 r0 *1 5.03,157.995
X$37 4 275 M3_M2_CDNS_40661956134306
* cell instance $38 r0 *1 11.99,157.86
X$38 4 262 M2_M1_CDNS_40661956134305
* cell instance $39 r0 *1 11.99,157.995
X$39 4 262 M3_M2_CDNS_40661956134306
* cell instance $40 r0 *1 14.07,157.86
X$40 4 263 M2_M1_CDNS_40661956134305
* cell instance $41 r0 *1 14.07,157.995
X$41 4 263 M3_M2_CDNS_40661956134306
* cell instance $42 r0 *1 35.25,157.86
X$42 4 276 M2_M1_CDNS_40661956134305
* cell instance $43 r0 *1 35.25,157.995
X$43 4 276 M3_M2_CDNS_40661956134306
* cell instance $44 r0 *1 40.07,157.86
X$44 4 274 M2_M1_CDNS_40661956134305
* cell instance $45 r0 *1 40.07,157.995
X$45 4 274 M3_M2_CDNS_40661956134306
* cell instance $46 r0 *1 61.25,157.86
X$46 4 265 M2_M1_CDNS_40661956134305
* cell instance $47 r0 *1 61.25,157.995
X$47 4 265 M3_M2_CDNS_40661956134306
* cell instance $48 r0 *1 63.33,157.86
X$48 4 266 M2_M1_CDNS_40661956134305
* cell instance $49 r0 *1 63.33,157.995
X$49 4 266 M3_M2_CDNS_40661956134306
* cell instance $50 r0 *1 70.29,157.86
X$50 4 264 M2_M1_CDNS_40661956134305
* cell instance $51 r0 *1 70.29,157.995
X$51 4 264 M3_M2_CDNS_40661956134306
* cell instance $52 r0 *1 72.9,159.5
X$52 4 5 M3_M2_CDNS_40661956134311
* cell instance $53 r0 *1 16.51,159.42
X$53 4 247 M2_M1_CDNS_40661956134307
* cell instance $54 r0 *1 16.51,159.42
X$54 4 247 M3_M2_CDNS_40661956134308
* cell instance $55 r0 *1 18.95,159.17
X$55 4 251 M2_M1_CDNS_40661956134307
* cell instance $56 r0 *1 18.95,159.165
X$56 4 251 M3_M2_CDNS_40661956134308
* cell instance $57 r0 *1 20.14,159.575
X$57 4 261 M2_M1_CDNS_40661956134293
* cell instance $58 r0 *1 20.14,159.77
X$58 4 261 M3_M2_CDNS_40661956134300
* cell instance $59 r0 *1 21.33,159.17
X$59 4 250 M2_M1_CDNS_40661956134307
* cell instance $60 r0 *1 21.33,159.165
X$60 4 250 M3_M2_CDNS_40661956134308
* cell instance $61 r0 *1 23.77,159.42
X$61 4 258 M2_M1_CDNS_40661956134307
* cell instance $62 r0 *1 23.77,159.42
X$62 4 258 M3_M2_CDNS_40661956134308
* cell instance $63 r0 *1 26.21,159.42
X$63 4 257 M2_M1_CDNS_40661956134307
* cell instance $64 r0 *1 26.21,159.42
X$64 4 257 M3_M2_CDNS_40661956134308
* cell instance $65 r0 *1 28.29,159.42
X$65 4 256 M2_M1_CDNS_40661956134307
* cell instance $66 r0 *1 28.29,159.42
X$66 4 256 M3_M2_CDNS_40661956134308
* cell instance $67 r0 *1 47.03,159.42
X$67 4 254 M2_M1_CDNS_40661956134307
* cell instance $68 r0 *1 47.03,159.42
X$68 4 254 M3_M2_CDNS_40661956134308
* cell instance $69 r0 *1 49.11,159.42
X$69 4 248 M2_M1_CDNS_40661956134307
* cell instance $70 r0 *1 49.11,159.42
X$70 4 248 M3_M2_CDNS_40661956134308
* cell instance $71 r0 *1 51.55,159.42
X$71 4 249 M2_M1_CDNS_40661956134307
* cell instance $72 r0 *1 51.55,159.42
X$72 4 249 M3_M2_CDNS_40661956134308
* cell instance $73 r0 *1 53.99,159.165
X$73 4 252 M3_M2_CDNS_40661956134308
* cell instance $74 r0 *1 53.99,159.17
X$74 4 252 M2_M1_CDNS_40661956134307
* cell instance $75 r0 *1 55.18,159.575
X$75 4 260 M2_M1_CDNS_40661956134293
* cell instance $76 r0 *1 55.18,159.77
X$76 4 260 M3_M2_CDNS_40661956134300
* cell instance $77 r0 *1 56.37,159.165
X$77 4 253 M3_M2_CDNS_40661956134308
* cell instance $78 r0 *1 56.37,159.17
X$78 4 253 M2_M1_CDNS_40661956134307
* cell instance $79 r0 *1 58.81,159.42
X$79 4 255 M2_M1_CDNS_40661956134307
* cell instance $80 r0 *1 58.81,159.42
X$80 4 255 M3_M2_CDNS_40661956134308
* cell instance $81 r0 *1 72.9,203.465
X$81 4 5 M3_M2_CDNS_40661956134285
* cell instance $82 r0 *1 72.9,235.465
X$82 4 5 M3_M2_CDNS_40661956134285
* cell instance $83 r0 *1 72.9,275.5
X$83 4 5 M3_M2_CDNS_40661956134285
* cell instance $84 r0 *1 51.3,283.185
X$84 4 148 M2_M1_CDNS_40661956134235
* cell instance $85 m45 *1 51.3,282.445
X$85 4 141 166 nmoscap_6p0_CDNS_4066195613423
* cell instance $86 r0 *1 56.3,283.185
X$86 4 148 M2_M1_CDNS_40661956134235
* cell instance $87 r0 *1 43.8,283.185
X$87 4 148 M2_M1_CDNS_40661956134235
* cell instance $88 m45 *1 43.8,282.445
X$88 4 141 173 nmoscap_6p0_CDNS_4066195613423
* cell instance $89 r0 *1 48.8,283.185
X$89 4 148 M2_M1_CDNS_40661956134235
* cell instance $90 r0 *1 58.8,283.185
X$90 4 148 M2_M1_CDNS_40661956134235
* cell instance $91 m45 *1 58.8,282.445
X$91 4 141 169 nmoscap_6p0_CDNS_4066195613423
* cell instance $92 r0 *1 63.8,283.185
X$92 4 148 M2_M1_CDNS_40661956134235
* cell instance $93 r0 *1 36.3,283.185
X$93 4 148 M2_M1_CDNS_40661956134235
* cell instance $94 m45 *1 36.3,282.445
X$94 4 141 172 nmoscap_6p0_CDNS_4066195613423
* cell instance $95 r0 *1 41.3,283.185
X$95 4 148 M2_M1_CDNS_40661956134235
* cell instance $96 r0 *1 28.8,283.185
X$96 4 148 M2_M1_CDNS_40661956134235
* cell instance $97 m45 *1 28.8,282.445
X$97 4 141 171 nmoscap_6p0_CDNS_4066195613423
* cell instance $98 r0 *1 33.8,283.185
X$98 4 148 M2_M1_CDNS_40661956134235
* cell instance $99 r0 *1 72.35,283.185
X$99 4 5 M2_M1_CDNS_40661956134235
* cell instance $100 r0 *1 66.3,283.185
X$100 4 148 M2_M1_CDNS_40661956134235
* cell instance $101 m45 *1 66.3,282.445
X$101 4 141 168 nmoscap_6p0_CDNS_4066195613423
* cell instance $102 r0 *1 13.8,283.185
X$102 4 148 M2_M1_CDNS_40661956134235
* cell instance $103 m45 *1 13.8,282.445
X$103 4 141 167 nmoscap_6p0_CDNS_4066195613423
* cell instance $104 r0 *1 18.8,283.185
X$104 4 148 M2_M1_CDNS_40661956134235
* cell instance $105 r0 *1 21.3,283.185
X$105 4 148 M2_M1_CDNS_40661956134235
* cell instance $106 m45 *1 21.3,282.445
X$106 4 141 170 nmoscap_6p0_CDNS_4066195613423
* cell instance $107 r0 *1 26.3,283.185
X$107 4 148 M2_M1_CDNS_40661956134235
* cell instance $108 r0 *1 7.47,152.48
X$108 6 23 M2_M1_CDNS_40661956134320
* cell instance $109 r0 *1 8.69,152.48
X$109 7 24 M2_M1_CDNS_40661956134320
* cell instance $110 r0 *1 32.81,152.48
X$110 8 39 M2_M1_CDNS_40661956134320
* cell instance $111 r0 *1 32.61,148.955
X$111 8 39 M2_M1_CDNS_40661956134237
* cell instance $112 r0 *1 7.285,148.955
X$112 8 30 M2_M1_CDNS_40661956134237
* cell instance $113 r0 *1 34.03,152.48
X$113 9 37 M2_M1_CDNS_40661956134320
* cell instance $114 r0 *1 33.83,148.055
X$114 9 37 M2_M1_CDNS_40661956134237
* cell instance $115 r0 *1 8.185,148.055
X$115 9 33 M2_M1_CDNS_40661956134237
* cell instance $116 r0 *1 17.73,152.48
X$116 10 34 M2_M1_CDNS_40661956134320
* cell instance $117 r0 *1 17.93,147.02
X$117 10 34 M2_M1_CDNS_40661956134237
* cell instance $118 r0 *1 15.29,153.38
X$118 11 25 M2_M1_CDNS_40661956134320
* cell instance $119 r0 *1 20.965,146.955
X$119 11 25 M2_M1_CDNS_40661956134270
* cell instance $120 r0 *1 24.99,152.48
X$120 12 35 M2_M1_CDNS_40661956134320
* cell instance $121 m90 *1 24.99,146.955
X$121 12 35 M2_M1_CDNS_40661956134270
* cell instance $122 r0 *1 22.55,153.38
X$122 13 26 M2_M1_CDNS_40661956134320
* cell instance $123 m90 *1 29.76,146.955
X$123 13 26 M2_M1_CDNS_40661956134270
* cell instance $124 m0 *1 22.915,247.295
X$124 121 98 114 165 112 113 98 123 207 164 114 14 106 151 comp018green_esd_cdm
* cell instance $125 m90 *1 52.77,153.38
X$125 15 27 M2_M1_CDNS_40661956134320
* cell instance $126 r0 *1 45.57,146.955
X$126 15 27 M2_M1_CDNS_40661956134270
* cell instance $127 m90 *1 50.33,152.48
X$127 16 42 M2_M1_CDNS_40661956134320
* cell instance $128 r0 *1 50.34,146.955
X$128 16 42 M2_M1_CDNS_40661956134270
* cell instance $129 m90 *1 60.03,153.38
X$129 17 28 M2_M1_CDNS_40661956134320
* cell instance $130 m90 *1 54.365,146.955
X$130 17 28 M2_M1_CDNS_40661956134270
* cell instance $131 m90 *1 57.59,152.48
X$131 18 38 M2_M1_CDNS_40661956134320
* cell instance $132 m90 *1 57.4,147.02
X$132 18 38 M2_M1_CDNS_40661956134237
* cell instance $133 r0 *1 42.51,152.48
X$133 19 41 M2_M1_CDNS_40661956134320
* cell instance $134 m90 *1 67.145,148.055
X$134 19 36 M2_M1_CDNS_40661956134237
* cell instance $135 r0 *1 42.71,148.055
X$135 19 41 M2_M1_CDNS_40661956134237
* cell instance $136 r0 *1 43.73,152.48
X$136 20 40 M2_M1_CDNS_40661956134320
* cell instance $137 m90 *1 68.045,148.955
X$137 20 32 M2_M1_CDNS_40661956134237
* cell instance $138 r0 *1 43.93,148.955
X$138 20 40 M2_M1_CDNS_40661956134237
* cell instance $139 m90 *1 67.85,152.48
X$139 21 29 M2_M1_CDNS_40661956134320
* cell instance $140 m90 *1 69.07,152.48
X$140 22 31 M2_M1_CDNS_40661956134320
* cell instance $141 r0 *1 17.325,190.09
X$141 44 43 M2_M1_CDNS_40661956134281
* cell instance $142 r0 *1 15.65,176.22
X$142 44 43 M2_M1_CDNS_40661956134299
* cell instance $143 r0 *1 15.65,176.22
X$143 44 43 M3_M2_CDNS_40661956134301
* cell instance $144 r0 *1 55.96,187.505
X$144 53 88 59 278 230 229 228 44 74 87 87 151 comp018green_sigbuf_1
* cell instance $145 r0 *1 54.63,227.37
X$145 44 108 M3_M2_CDNS_40661956134433
* cell instance $146 r0 *1 55.275,227.37
X$146 44 108 M3_M2_CDNS_40661956134433
* cell instance $147 r0 *1 3.99,187.505
X$147 103 54 57 74 242 240 237 235 233 238 73 74 81 83 86 44 81 86 151
+ comp018green_out_sigbuf_oe
* cell instance $148 m90 *1 30.66,187.505
X$148 102 63 66 74 242 240 236 234 232 238 104 74 76 89 86 44 76 86 151
+ comp018green_out_sigbuf_oe
* cell instance $149 r0 *1 30.21,187.505
X$149 105 47 49 74 243 241 236 234 232 239 174 76 76 89 94 44 76 94 151
+ comp018green_out_sigbuf_oe
* cell instance $150 m90 *1 56.41,187.505
X$150 88 55 87 230 243 241 229 239 228 74 44 94 74 94 87 151
+ comp018green_out_sigbuf_a
* cell instance $151 r0 *1 43.545,190.09
X$151 44 92 M2_M1_CDNS_40661956134281
* cell instance $152 r0 *1 2.62,175.18
X$152 44 259 M2_M1_CDNS_40661956134293
* cell instance $153 r0 *1 2.62,175.18
X$153 44 259 M3_M2_CDNS_40661956134300
* cell instance $154 r0 *1 20.14,173.1
X$154 44 269 M2_M1_CDNS_40661956134302
* cell instance $155 r0 *1 20.14,174.255
X$155 44 269 M3_M2_CDNS_40661956134303
* cell instance $156 r0 *1 55.18,173.1
X$156 44 270 M2_M1_CDNS_40661956134302
* cell instance $157 r0 *1 55.18,174.255
X$157 44 270 M3_M2_CDNS_40661956134303
* cell instance $158 r0 *1 3.81,176.22
X$158 44 244 M2_M1_CDNS_40661956134299
* cell instance $159 r0 *1 3.81,176.22
X$159 44 244 M3_M2_CDNS_40661956134301
* cell instance $160 r0 *1 24.63,176.22
X$160 44 245 M2_M1_CDNS_40661956134299
* cell instance $161 r0 *1 24.63,176.22
X$161 44 245 M3_M2_CDNS_40661956134301
* cell instance $162 r0 *1 43.285,179.6
X$162 44 92 M2_M1_CDNS_40661956134237
* cell instance $163 r0 *1 43.545,176.22
X$163 44 92 M3_M2_CDNS_40661956134301
* cell instance $164 r0 *1 50.69,176.22
X$164 44 246 M2_M1_CDNS_40661956134299
* cell instance $165 r0 *1 50.69,176.22
X$165 44 246 M3_M2_CDNS_40661956134301
* cell instance $166 r0 *1 59.67,176.22
X$166 44 45 M2_M1_CDNS_40661956134299
* cell instance $167 r0 *1 59.67,176.22
X$167 44 45 M3_M2_CDNS_40661956134301
* cell instance $168 r0 *1 52.57,240.04
X$168 44 108 M3_M2_CDNS_40661956134417
* cell instance $169 r0 *1 58.96,204.285
X$169 44 45 M2_M1_CDNS_40661956134237
* cell instance $170 r0 *1 55.275,204.47
X$170 44 108 M2_M1_CDNS_40661956134270
* cell instance $171 r0 *1 65.76,184.36
X$171 47 46 M2_M1_CDNS_40661956134237
* cell instance $172 m90 *1 66.02,171.785
X$172 47 46 M2_M1_CDNS_40661956134270
* cell instance $173 r90 *1 42.385,184.62
X$173 47 93 M2_M1_CDNS_40661956134237
* cell instance $174 m90 *1 42.385,189.305
X$174 47 93 M2_M1_CDNS_40661956134270
* cell instance $175 r0 *1 65.06,183.68
X$175 49 48 M2_M1_CDNS_40661956134237
* cell instance $176 m90 *1 64.8,171.785
X$176 49 48 M2_M1_CDNS_40661956134270
* cell instance $177 r0 *1 41.915,183.68
X$177 49 91 M2_M1_CDNS_40661956134237
* cell instance $178 m90 *1 41.655,193.05
X$178 49 91 M2_M1_CDNS_40661956134270
* cell instance $179 r0 *1 9.56,182.32
X$179 54 50 M2_M1_CDNS_40661956134237
* cell instance $180 r0 *1 9.3,171.785
X$180 54 50 M2_M1_CDNS_40661956134270
* cell instance $181 m90 *1 62.98,181.64
X$181 55 51 M2_M1_CDNS_40661956134237
* cell instance $182 m90 *1 62.72,171.785
X$182 55 51 M2_M1_CDNS_40661956134270
* cell instance $183 r0 *1 7,180.96
X$183 53 52 M2_M1_CDNS_40661956134237
* cell instance $184 m90 *1 68.32,180.96
X$184 53 78 M2_M1_CDNS_40661956134237
* cell instance $185 m90 *1 33.28,180.96
X$185 53 72 M2_M1_CDNS_40661956134237
* cell instance $186 r0 *1 42.04,180.96
X$186 53 70 M2_M1_CDNS_40661956134237
* cell instance $187 r0 *1 66.705,192.985
X$187 53 78 M2_M1_CDNS_40661956134270
* cell instance $188 r0 *1 15.905,182.32
X$188 54 85 M2_M1_CDNS_40661956134237
* cell instance $189 r0 *1 16.165,189.305
X$189 54 85 M2_M1_CDNS_40661956134270
* cell instance $190 m90 *1 27.42,181.64
X$190 55 67 M2_M1_CDNS_40661956134237
* cell instance $191 r0 *1 12.86,181.64
X$191 55 58 M2_M1_CDNS_40661956134237
* cell instance $192 r0 *1 47.9,181.64
X$192 55 77 M2_M1_CDNS_40661956134237
* cell instance $193 m90 *1 27.68,171.785
X$193 55 67 M2_M1_CDNS_40661956134270
* cell instance $194 r0 *1 44.665,189.305
X$194 55 77 M2_M1_CDNS_40661956134270
* cell instance $195 r0 *1 47.64,171.785
X$195 55 77 M2_M1_CDNS_40661956134270
* cell instance $196 r0 *1 12.6,171.785
X$196 55 58 M2_M1_CDNS_40661956134270
* cell instance $197 r0 *1 11.35,183
X$197 57 56 M2_M1_CDNS_40661956134286
* cell instance $198 r0 *1 13.725,189.305
X$198 57 56 M2_M1_CDNS_40661956134270
* cell instance $199 r0 *1 10.52,171.785
X$199 57 56 M2_M1_CDNS_40661956134270
* cell instance $200 m90 *1 57.94,180.28
X$200 59 61 M2_M1_CDNS_40661956134237
* cell instance $201 m90 *1 22.9,180.28
X$201 59 68 M2_M1_CDNS_40661956134237
* cell instance $202 r0 *1 67.125,180.28
X$202 59 82 M2_M1_CDNS_40661956134237
* cell instance $203 r0 *1 52.42,180.28
X$203 59 60 M2_M1_CDNS_40661956134237
* cell instance $204 r0 *1 17.38,180.28
X$204 59 62 M2_M1_CDNS_40661956134237
* cell instance $205 r0 *1 67.385,189.725
X$205 59 82 M2_M1_CDNS_40661956134270
* cell instance $206 m90 *1 30.72,182.32
X$206 63 64 M2_M1_CDNS_40661956134237
* cell instance $207 m90 *1 18.745,182.32
X$207 63 84 M2_M1_CDNS_40661956134237
* cell instance $208 r0 *1 44.6,182.32
X$208 63 69 M2_M1_CDNS_40661956134237
* cell instance $209 m90 *1 44.34,171.785
X$209 63 69 M2_M1_CDNS_40661956134270
* cell instance $210 m90 *1 18.485,189.305
X$210 63 84 M2_M1_CDNS_40661956134270
* cell instance $211 r0 *1 30.98,171.785
X$211 63 64 M2_M1_CDNS_40661956134270
* cell instance $212 m90 *1 29.5,183
X$212 66 65 M2_M1_CDNS_40661956134237
* cell instance $213 r0 *1 29.76,171.785
X$213 66 65 M2_M1_CDNS_40661956134270
* cell instance $214 m90 *1 22.755,183
X$214 66 75 M2_M1_CDNS_40661956134237
* cell instance $215 m90 *1 45.3,183
X$215 66 71 M2_M1_CDNS_40661956134237
* cell instance $216 m90 *1 20.925,189.305
X$216 66 75 M2_M1_CDNS_40661956134270
* cell instance $217 r0 *1 45.56,171.785
X$217 66 71 M2_M1_CDNS_40661956134270
* cell instance $218 r0 *1 7.82,286.505
X$218 74 73 M2_M1_CDNS_40661956134237
* cell instance $219 r0 *1 8.43,202.71
X$219 74 73 M2_M1_CDNS_40661956134237
* cell instance $220 r90 *1 6.095,277.005
X$220 74 83 151 ppolyf_u_CDNS_4066195613451
* cell instance $221 m0 *1 4.24,279.26
X$221 117 74 144 81 136 81 138 81 134 140 125 126 83 83 130 83 204 113 112 143
+ 152 142 130 121 153 118 151 111 122 121 227 111 113 109 124 124 124 124 210
+ 207 121 150 comp018green_inpath_cms_smt
* cell instance $222 r0 *1 57.29,208.135
X$222 206 74 87 205 87 pn_6p0_CDNS_4066195613428
* cell instance $223 r0 *1 58.045,208.685
X$223 74 96 M2_M1_CDNS_40661956134270
* cell instance $224 r0 *1 57.29,205.815
X$224 206 74 87 205 87 pn_6p0_CDNS_4066195613428
* cell instance $225 r0 *1 58.045,206.315
X$225 74 97 M2_M1_CDNS_40661956134270
* cell instance $226 r0 *1 69.76,286.505
X$226 74 149 M2_M1_CDNS_40661956134245
* cell instance $227 m90 *1 35.715,203.54
X$227 74 105 M2_M1_CDNS_40661956134237
* cell instance $228 m90 *1 24.635,203.54
X$228 74 102 M2_M1_CDNS_40661956134237
* cell instance $229 r90 *1 57.79,193.035
X$229 74 96 M2_M1_CDNS_40661956134237
* cell instance $230 r90 *1 70.48,203.8
X$230 74 149 M2_M1_CDNS_40661956134237
* cell instance $231 r0 *1 28.28,202.71
X$231 74 104 M2_M1_CDNS_40661956134237
* cell instance $232 r0 *1 10.015,203.54
X$232 74 103 M2_M1_CDNS_40661956134237
* cell instance $233 r0 *1 57.53,202.86
X$233 74 96 M2_M1_CDNS_40661956134237
* cell instance $234 r0 *1 60.37,202.18
X$234 74 97 M2_M1_CDNS_40661956134237
* cell instance $235 r0 *1 54.89,203.54
X$235 74 107 M2_M1_CDNS_40661956134237
* cell instance $236 r0 *1 69.49,202.18
X$236 74 149 M2_M1_CDNS_40661956134237
* cell instance $237 r0 *1 68.76,202.86
X$237 74 149 M2_M1_CDNS_40661956134237
* cell instance $238 r0 *1 53.67,202.18
X$238 74 90 M2_M1_CDNS_40661956134237
* cell instance $239 r0 *1 3.71,286.245
X$239 74 144 M2_M1_CDNS_40661956134270
* cell instance $240 r0 *1 54.63,194.84
X$240 74 107 M2_M1_CDNS_40661956134270
* cell instance $241 r0 *1 53.41,194.84
X$241 74 90 M2_M1_CDNS_40661956134270
* cell instance $242 r0 *1 30.435,196.32
X$242 76 223 M2_M1_CDNS_40661956134281
* cell instance $243 r0 *1 30.435,196.145
X$243 76 223 M3_M2_CDNS_40661956134290
* cell instance $244 r0 *1 25.605,197.36
X$244 76 221 M2_M1_CDNS_40661956134279
* cell instance $245 r0 *1 25.605,197.24
X$245 76 221 M3_M2_CDNS_40661956134294
* cell instance $246 r0 *1 35.265,197.36
X$246 76 220 M2_M1_CDNS_40661956134279
* cell instance $247 r0 *1 35.265,197.24
X$247 76 220 M3_M2_CDNS_40661956134294
* cell instance $248 r0 *1 2.41,279.5
X$248 81 139 124 81 M1_NWELL_CDNS_40661956134480
* cell instance $249 r90 *1 4.695,277.005
X$249 134 81 151 ppolyf_u_CDNS_4066195613451
* cell instance $250 r0 *1 1.92,270.18
X$250 81 137 M2_M1_CDNS_40661956134283
* cell instance $251 r0 *1 66.56,276.435
X$251 81 135 M2_M1_CDNS_40661956134277
* cell instance $252 r0 *1 4.995,275.675
X$252 81 139 124 81 M1_NWELL_CDNS_40661956134425
* cell instance $253 r0 *1 1.92,274.725
X$253 81 137 M2_M1_CDNS_40661956134283
* cell instance $254 r0 *1 18.99,279.055
X$254 81 135 M2_M1_CDNS_40661956134481
* cell instance $255 r0 *1 40.34,276.675
X$255 81 135 M2_M1_CDNS_40661956134281
* cell instance $256 r0 *1 42.685,276.675
X$256 81 135 M2_M1_CDNS_40661956134281
* cell instance $257 r0 *1 43.76,276.675
X$257 81 135 M2_M1_CDNS_40661956134281
* cell instance $258 r0 *1 44.875,276.675
X$258 81 135 M2_M1_CDNS_40661956134281
* cell instance $259 r0 *1 47.22,276.675
X$259 81 135 M2_M1_CDNS_40661956134281
* cell instance $260 r0 *1 9.045,197.51
X$260 81 212 M2_M1_CDNS_40661956134279
* cell instance $261 r0 *1 9.045,197.24
X$261 81 212 M3_M2_CDNS_40661956134294
* cell instance $262 r0 *1 1.92,201.4
X$262 81 137 M2_M1_CDNS_40661956134286
* cell instance $263 r0 *1 1.92,251.465
X$263 81 137 M3_M2_CDNS_40661956134285
* cell instance $264 r0 *1 1.92,195.465
X$264 81 137 M3_M2_CDNS_40661956134285
* cell instance $265 r0 *1 40.34,268.865
X$265 83 127 M2_M1_CDNS_40661956134275
* cell instance $266 r0 *1 43.78,269.385
X$266 83 127 M2_M1_CDNS_40661956134281
* cell instance $267 r0 *1 66.56,268.865
X$267 83 127 M2_M1_CDNS_40661956134275
* cell instance $268 r0 *1 17.54,269.385
X$268 83 131 M2_M1_CDNS_40661956134281
* cell instance $269 r0 *1 21,268.865
X$269 83 127 M2_M1_CDNS_40661956134275
* cell instance $270 r0 *1 4.215,190.09
X$270 83 128 M2_M1_CDNS_40661956134281
* cell instance $271 r0 *1 4.52,187.465
X$271 83 128 M3_M2_CDNS_40661956134285
* cell instance $272 r0 *1 4.52,264.905
X$272 83 128 M2_M1_CDNS_40661956134286
* cell instance $273 r0 *1 4.52,259.465
X$273 83 128 M3_M2_CDNS_40661956134285
* cell instance $274 r0 *1 13.415,277.185
X$274 83 127 M2_M1_CDNS_40661956134237
* cell instance $275 r0 *1 17.28,264.905
X$275 83 131 M2_M1_CDNS_40661956134237
* cell instance $276 r0 *1 18.865,264.905
X$276 83 127 M2_M1_CDNS_40661956134237
* cell instance $277 r0 *1 17.295,201.44
X$277 86 211 M2_M1_CDNS_40661956134318
* cell instance $278 r0 *1 17.3,201.44
X$278 86 211 M3_M2_CDNS_40661956134435
* cell instance $279 r0 *1 51.825,196.47
X$279 87 224 M2_M1_CDNS_40661956134281
* cell instance $280 r0 *1 51.825,196.175
X$280 87 224 M3_M2_CDNS_40661956134290
* cell instance $281 r0 *1 56.19,196.47
X$281 87 95 M2_M1_CDNS_40661956134281
* cell instance $282 r0 *1 56.19,196.175
X$282 87 95 M3_M2_CDNS_40661956134290
* cell instance $283 r0 *1 56.62,205.425
X$283 87 95 M2_M1_CDNS_40661956134270
* cell instance $284 r0 *1 54.705,187.71
X$284 88 279 M2_M1_CDNS_40661956134234
* cell instance $285 r0 *1 54.8,187.71
X$285 88 279 M3_M2_CDNS_40661956134298
* cell instance $286 r0 *1 30.435,190.09
X$286 89 225 M2_M1_CDNS_40661956134281
* cell instance $287 r0 *1 30.435,187.465
X$287 89 225 M3_M2_CDNS_40661956134284
* cell instance $288 r0 *1 44.05,201.44
X$288 94 208 M2_M1_CDNS_40661956134291
* cell instance $289 r0 *1 44.385,201.44
X$289 94 208 M3_M2_CDNS_40661956134297
* cell instance $290 r0 *1 66.665,217.77
X$290 98 101 M1_PACTIVE_CDNS_40661956134272
* cell instance $291 r0 *1 56.5,215.745
X$291 98 M1_PSUB_CDNS_40661956134319
* cell instance $292 r0 *1 66.665,205.55
X$292 98 101 M1_PACTIVE_CDNS_40661956134272
* cell instance $293 m45 *1 62.41,207.74
X$293 100 98 nmoscap_6p0_CDNS_4066195613422
* cell instance $294 r0 *1 60.49,211.66
X$294 98 101 M1_PACTIVE_CDNS_40661956134271
* cell instance $295 m45 *1 62.41,212.58
X$295 100 98 nmoscap_6p0_CDNS_4066195613422
* cell instance $296 r0 *1 73.075,211.66
X$296 98 101 M1_PACTIVE_CDNS_40661956134271
* cell instance $297 m45 *1 68.11,207.74
X$297 100 98 nmoscap_6p0_CDNS_4066195613422
* cell instance $298 m45 *1 68.11,212.58
X$298 100 98 nmoscap_6p0_CDNS_4066195613422
* cell instance $299 r0 *1 46.745,267.465
X$299 98 114 M3_M2_CDNS_40661956134285
* cell instance $300 r0 *1 66.655,211.9
X$300 100 99 M3_M2_CDNS_40661956134317
* cell instance $301 r0 *1 65.67,213.95
X$301 100 99 M2_M1_CDNS_40661956134270
* cell instance $302 r0 *1 67.85,209.315
X$302 100 99 M2_M1_CDNS_40661956134270
* cell instance $303 r0 *1 67.85,213.95
X$303 100 99 M2_M1_CDNS_40661956134270
* cell instance $304 r0 *1 65.67,209.315
X$304 100 99 M2_M1_CDNS_40661956134270
* cell instance $305 r0 *1 62.575,187.465
X$305 109 110 M3_M2_CDNS_40661956134313
* cell instance $306 r0 *1 62.56,220.135
X$306 109 110 M2_M1_CDNS_40661956134237
* cell instance $307 r0 *1 58.34,248.81
X$307 111 119 M3_M2_CDNS_40661956134280
* cell instance $308 r0 *1 62.3,234.7
X$308 111 M2_M1_CDNS_40661956134434
* cell instance $309 r0 *1 58.28,239.32
X$309 111 119 M2_M1_CDNS_40661956134270
* cell instance $310 r0 *1 16.375,231.35
X$310 113 112 M2_M1_CDNS_40661956134269
* cell instance $311 r0 *1 71.21,229.575
X$311 117 118 M2_M1_CDNS_40661956134270
* cell instance $312 r0 *1 43.08,246.34
X$312 121 120 M2_M1_CDNS_40661956134287
* cell instance $313 r0 *1 43.08,251.215
X$313 121 120 M2_M1_CDNS_40661956134286
* cell instance $314 r0 *1 21.67,251.215
X$314 121 123 M2_M1_CDNS_40661956134432
* cell instance $315 r0 *1 39.57,251.215
X$315 121 122 M2_M1_CDNS_40661956134286
* cell instance $316 r0 *1 23.97,243.27
X$316 121 123 M2_M1_CDNS_40661956134282
* cell instance $317 r0 *1 55.195,237.16
X$317 121 213 M2_M1_CDNS_40661956134279
* cell instance $318 r0 *1 55.195,237.16
X$318 121 213 M3_M2_CDNS_40661956134294
* cell instance $319 r0 *1 28.565,246.34
X$319 121 123 M2_M1_CDNS_40661956134287
* cell instance $320 r0 *1 33.08,246.34
X$320 121 123 M2_M1_CDNS_40661956134287
* cell instance $321 r0 *1 39.57,246.34
X$321 121 122 M2_M1_CDNS_40661956134287
* cell instance $322 r0 *1 36.46,268.58
X$322 130 129 M3_M2_CDNS_40661956134276
* cell instance $323 r0 *1 36.46,268.58
X$323 130 129 M2_M1_CDNS_40661956134279
* cell instance $324 r0 *1 36.72,263.265
X$324 130 129 M2_M1_CDNS_40661956134237
* cell instance $325 r0 *1 23.94,268.865
X$325 130 191 M2_M1_CDNS_40661956134275
* cell instance $326 r0 *1 23.94,268.53
X$326 130 191 M3_M2_CDNS_40661956134278
* cell instance $327 r0 *1 24.88,268.58
X$327 130 132 M2_M1_CDNS_40661956134279
* cell instance $328 r0 *1 24.88,268.58
X$328 130 132 M3_M2_CDNS_40661956134276
* cell instance $329 r0 *1 27.32,268.58
X$329 130 218 M2_M1_CDNS_40661956134279
* cell instance $330 r0 *1 27.32,268.58
X$330 130 218 M3_M2_CDNS_40661956134276
* cell instance $331 r0 *1 29.76,268.58
X$331 130 219 M2_M1_CDNS_40661956134279
* cell instance $332 r0 *1 29.76,268.58
X$332 130 219 M3_M2_CDNS_40661956134276
* cell instance $333 r0 *1 30.67,269.125
X$333 130 193 M2_M1_CDNS_40661956134277
* cell instance $334 r0 *1 30.67,268.53
X$334 130 193 M3_M2_CDNS_40661956134278
* cell instance $335 r0 *1 31.58,268.58
X$335 130 180 M2_M1_CDNS_40661956134279
* cell instance $336 r0 *1 31.58,268.58
X$336 130 180 M3_M2_CDNS_40661956134276
* cell instance $337 r0 *1 34.02,268.58
X$337 130 133 M2_M1_CDNS_40661956134279
* cell instance $338 r0 *1 34.02,268.58
X$338 130 133 M3_M2_CDNS_40661956134276
* cell instance $339 r0 *1 37.4,268.865
X$339 130 198 M2_M1_CDNS_40661956134275
* cell instance $340 r0 *1 37.4,268.53
X$340 130 198 M3_M2_CDNS_40661956134278
* cell instance $341 r0 *1 24.9,263.265
X$341 130 132 M2_M1_CDNS_40661956134232
* cell instance $342 r0 *1 33.42,263.265
X$342 130 133 M2_M1_CDNS_40661956134232
* cell instance $343 r0 *1 11.735,278.165
X$343 134 140 M2_M1_CDNS_40661956134270
* cell instance $344 r0 *1 50.16,276.435
X$344 136 192 M2_M1_CDNS_40661956134277
* cell instance $345 r0 *1 50.16,276.435
X$345 136 192 M3_M2_CDNS_40661956134278
* cell instance $346 r0 *1 51.1,276.885
X$346 136 185 M2_M1_CDNS_40661956134275
* cell instance $347 r0 *1 51.1,276.885
X$347 136 185 M3_M2_CDNS_40661956134276
* cell instance $348 r0 *1 53.54,276.885
X$348 136 184 M2_M1_CDNS_40661956134275
* cell instance $349 r0 *1 53.54,276.885
X$349 136 184 M3_M2_CDNS_40661956134276
* cell instance $350 r0 *1 55.98,276.885
X$350 136 190 M2_M1_CDNS_40661956134275
* cell instance $351 r0 *1 55.98,276.885
X$351 136 190 M3_M2_CDNS_40661956134276
* cell instance $352 r0 *1 56.89,276.435
X$352 136 177 M2_M1_CDNS_40661956134277
* cell instance $353 r0 *1 56.89,276.435
X$353 136 177 M3_M2_CDNS_40661956134278
* cell instance $354 r0 *1 57.8,276.885
X$354 136 182 M2_M1_CDNS_40661956134275
* cell instance $355 r0 *1 57.8,276.885
X$355 136 182 M3_M2_CDNS_40661956134276
* cell instance $356 r0 *1 60.24,276.885
X$356 136 183 M2_M1_CDNS_40661956134275
* cell instance $357 r0 *1 60.24,276.885
X$357 136 183 M3_M2_CDNS_40661956134276
* cell instance $358 r0 *1 62.68,276.885
X$358 136 202 M2_M1_CDNS_40661956134275
* cell instance $359 r0 *1 62.68,276.885
X$359 136 202 M3_M2_CDNS_40661956134276
* cell instance $360 r0 *1 63.62,276.435
X$360 136 195 M2_M1_CDNS_40661956134277
* cell instance $361 r0 *1 63.62,276.435
X$361 136 195 M3_M2_CDNS_40661956134278
* cell instance $362 r0 *1 23.94,276.435
X$362 138 178 M2_M1_CDNS_40661956134277
* cell instance $363 r0 *1 23.94,276.435
X$363 138 178 M3_M2_CDNS_40661956134278
* cell instance $364 r0 *1 24.88,276.84
X$364 138 186 M2_M1_CDNS_40661956134275
* cell instance $365 r0 *1 24.88,276.84
X$365 138 186 M3_M2_CDNS_40661956134276
* cell instance $366 r0 *1 27.32,276.885
X$366 138 187 M2_M1_CDNS_40661956134275
* cell instance $367 r0 *1 27.32,276.885
X$367 138 187 M3_M2_CDNS_40661956134276
* cell instance $368 r0 *1 29.76,276.885
X$368 138 189 M2_M1_CDNS_40661956134275
* cell instance $369 r0 *1 29.76,276.885
X$369 138 189 M3_M2_CDNS_40661956134276
* cell instance $370 r0 *1 30.67,276.435
X$370 138 179 M2_M1_CDNS_40661956134277
* cell instance $371 r0 *1 30.67,276.435
X$371 138 179 M3_M2_CDNS_40661956134278
* cell instance $372 r0 *1 31.58,276.885
X$372 138 203 M2_M1_CDNS_40661956134275
* cell instance $373 r0 *1 31.58,276.885
X$373 138 203 M3_M2_CDNS_40661956134276
* cell instance $374 r0 *1 34.02,276.885
X$374 138 201 M2_M1_CDNS_40661956134275
* cell instance $375 r0 *1 34.02,276.885
X$375 138 201 M3_M2_CDNS_40661956134276
* cell instance $376 r0 *1 36.46,276.885
X$376 138 199 M2_M1_CDNS_40661956134275
* cell instance $377 r0 *1 36.46,276.885
X$377 138 199 M3_M2_CDNS_40661956134276
* cell instance $378 r0 *1 37.4,276.435
X$378 138 194 M2_M1_CDNS_40661956134277
* cell instance $379 r0 *1 37.4,276.435
X$379 138 194 M3_M2_CDNS_40661956134278
* cell instance $380 r0 *1 40.33,281.34
X$380 141 175 M2_M1_CDNS_40661956134315
* cell instance $381 r90 *1 42.665,280.495
X$381 141 147 M1_PACTIVE_CDNS_40661956134274
* cell instance $382 r0 *1 11.88,283.195
X$382 141 147 M1_PACTIVE_CDNS_40661956134273
* cell instance $383 r0 *1 40.33,281.34
X$383 141 175 M3_M2_CDNS_40661956134316
* cell instance $384 r0 *1 40.33,285.05
X$384 141 176 M2_M1_CDNS_40661956134315
* cell instance $385 r90 *1 42.665,285.895
X$385 141 147 M1_PACTIVE_CDNS_40661956134274
* cell instance $386 r0 *1 40.33,285.05
X$386 141 176 M3_M2_CDNS_40661956134316
* cell instance $387 r0 *1 73.45,283.195
X$387 141 147 M1_PACTIVE_CDNS_40661956134273
* cell instance $388 r0 *1 9.62,283.195
X$388 146 145 M3_M2_CDNS_40661956134314
* cell instance $389 r0 *1 9.62,267.465
X$389 146 145 M3_M2_CDNS_40661956134284
* cell instance $390 r0 *1 55.98,268.58
X$390 204 181 M3_M2_CDNS_40661956134276
* cell instance $391 r0 *1 55.98,268.58
X$391 204 181 M2_M1_CDNS_40661956134279
* cell instance $392 r0 *1 62.68,268.58
X$392 204 188 M3_M2_CDNS_40661956134276
* cell instance $393 r0 *1 62.68,268.58
X$393 204 188 M2_M1_CDNS_40661956134279
* cell instance $394 r0 *1 63.62,268.53
X$394 204 196 M3_M2_CDNS_40661956134278
* cell instance $395 r0 *1 63.62,268.865
X$395 204 196 M2_M1_CDNS_40661956134275
* cell instance $396 r0 *1 56.89,268.53
X$396 204 197 M3_M2_CDNS_40661956134278
* cell instance $397 r0 *1 56.89,269.125
X$397 204 197 M2_M1_CDNS_40661956134277
* cell instance $398 r0 *1 50.16,268.865
X$398 204 200 M2_M1_CDNS_40661956134275
* cell instance $399 r0 *1 50.16,268.53
X$399 204 200 M3_M2_CDNS_40661956134278
* cell instance $400 r0 *1 51.1,268.58
X$400 204 215 M2_M1_CDNS_40661956134279
* cell instance $401 r0 *1 51.1,268.58
X$401 204 215 M3_M2_CDNS_40661956134276
* cell instance $402 r0 *1 53.54,268.58
X$402 204 214 M2_M1_CDNS_40661956134279
* cell instance $403 r0 *1 53.54,268.58
X$403 204 214 M3_M2_CDNS_40661956134276
* cell instance $404 r0 *1 57.8,268.58
X$404 204 216 M2_M1_CDNS_40661956134279
* cell instance $405 r0 *1 57.8,268.58
X$405 204 216 M3_M2_CDNS_40661956134276
* cell instance $406 r0 *1 60.24,268.58
X$406 204 217 M2_M1_CDNS_40661956134279
* cell instance $407 r0 *1 60.24,268.58
X$407 204 217 M3_M2_CDNS_40661956134276
* cell instance $408 r0 *1 13.79,205.22
X$408 210 209 M2_M1_CDNS_40661956134291
* cell instance $409 r0 *1 13.985,205.22
X$409 210 209 M3_M2_CDNS_40661956134292
* cell instance $410 r0 *1 18.23,211.465
X$410 210 231 M2_M1_CDNS_40661956134240
* cell instance $411 r0 *1 18.23,211.465
X$411 210 231 M3_M2_CDNS_40661956134284
* cell instance $412 r0 *1 18.23,219.465
X$412 210 281 M2_M1_CDNS_40661956134240
* cell instance $413 r0 *1 18.23,219.465
X$413 210 281 M3_M2_CDNS_40661956134284
* cell instance $414 r0 *1 18.23,236.21
X$414 210 222 M2_M1_CDNS_40661956134289
* cell instance $415 r0 *1 18.23,236.175
X$415 210 222 M3_M2_CDNS_40661956134290
* cell instance $416 r0 *1 54.1,244.33
X$416 227 226 M2_M1_CDNS_40661956134281
* cell instance $417 r0 *1 54.1,244.175
X$417 227 226 M3_M2_CDNS_40661956134290
* cell instance $418 r0 *1 66.39,201.44
X$418 278 277 M2_M1_CDNS_40661956134267
* cell instance $419 r0 *1 66.415,201.44
X$419 278 277 M3_M2_CDNS_40661956134298
* device instance $1 r0 *1 5.945,268.14 pn_6p0
D$1 117 81 pn_6p0 A=1P P=4U
* device instance $2 r0 *1 12.19,268.14 pn_6p0
D$2 126 81 pn_6p0 A=1P P=4U
* device instance $3 r0 *1 5.945,272.64 pn_6p0
D$3 74 81 pn_6p0 A=1P P=4U
* device instance $4 r0 *1 12.19,272.64 pn_6p0
D$4 134 81 pn_6p0 A=1P P=4U
* device instance $5 r0 *1 57.79,206.315 pn_6p0
D$5 74 87 pn_6p0 A=1P P=4U
* device instance $6 r0 *1 57.79,208.635 pn_6p0
D$6 74 87 pn_6p0 A=1P P=4U
* device instance $7 r0 *1 61.3,283.195 nmoscap_6p0
C$7 4 141 1.725e-14 nmoscap_6p0 A=7.5P P=13U
* device instance $8 r0 *1 53.8,283.195 nmoscap_6p0
C$8 4 141 1.725e-14 nmoscap_6p0 A=7.5P P=13U
* device instance $9 r0 *1 68.8,283.195 nmoscap_6p0
C$9 4 141 1.725e-14 nmoscap_6p0 A=7.5P P=13U
* device instance $10 r0 *1 46.3,283.195 nmoscap_6p0
C$10 4 141 1.725e-14 nmoscap_6p0 A=7.5P P=13U
* device instance $11 r0 *1 16.3,283.195 nmoscap_6p0
C$11 4 141 1.725e-14 nmoscap_6p0 A=7.5P P=13U
* device instance $12 r0 *1 38.8,283.195 nmoscap_6p0
C$12 4 141 1.725e-14 nmoscap_6p0 A=7.5P P=13U
* device instance $13 r0 *1 23.8,283.195 nmoscap_6p0
C$13 4 141 1.725e-14 nmoscap_6p0 A=7.5P P=13U
* device instance $14 r0 *1 31.3,283.195 nmoscap_6p0
C$14 4 141 1.725e-14 nmoscap_6p0 A=7.5P P=13U
.ENDS GF_NI_IN_C_BASE

* cell POLY_SUB_FILL
* pin
* pin
* pin
.SUBCKT POLY_SUB_FILL 1 2 5
* cell instance $1 r0 *1 6.58,5.225
X$1 1 5 M2_M1_CDNS_40661956134178
* cell instance $2 m0 *1 6.58,1.765
X$2 1 5 M2_M1_CDNS_40661956134178
* cell instance $3 r0 *1 6.58,3.205
X$3 1 5 M2_M1_CDNS_40661956134178
* cell instance $4 r0 *1 6.58,-0.255
X$4 1 5 M2_M1_CDNS_40661956134178
* device instance $1 r0 *1 6.575,4.215 nmoscap_6p0
C$1 1 2 5.175e-15 nmoscap_6p0 A=2.25P P=6U
* device instance $2 r0 *1 6.575,0.755 nmoscap_6p0
C$2 1 2 5.175e-15 nmoscap_6p0 A=2.25P P=6U
.ENDS POLY_SUB_FILL

* cell M2_M1_CDNS_40661956134173
* pin
* pin
.SUBCKT M2_M1_CDNS_40661956134173 1 2
.ENDS M2_M1_CDNS_40661956134173

* cell M3_M2_CDNS_40661956134177
* pin
* pin
.SUBCKT M3_M2_CDNS_40661956134177 1 2
.ENDS M3_M2_CDNS_40661956134177

* cell M1_PSUB_CDNS_40661956134174
* pin
* pin
.SUBCKT M1_PSUB_CDNS_40661956134174 1 2
.ENDS M1_PSUB_CDNS_40661956134174

* cell GF_NI_COR_BASE
* pin DVSS
* pin DVDD
* pin
* pin
* pin VDD
* pin
* pin gf180mcu_gnd
* pin
* pin VSS
* pin
* pin
* pin
* pin
* pin
* pin
* pin
* pin
* pin
* pin
* pin
* pin
* pin
* pin
* pin
.SUBCKT GF_NI_COR_BASE 1 2 3 4 5 6 7 8 9 10 11 12 13 14 15 16 17 18 19 20 21 24
+ 26 28
* net 1 DVSS
* net 2 DVDD
* net 5 VDD
* net 7 gf180mcu_gnd
* net 9 VSS
* cell instance $1 r0 *1 302.78,344.52
X$1 4 28 27 4 4 4 4 17 3 26 25 3 25 25 3 3 3 25 24 3 20 18 6 6 6 19 6 19 21 6 6
+ 18 18 18 3 20 3 3 20 18 18 20 3 24 3 3 3 4 3 3 26 24 24 24 26 26 24 24 4 4 4
+ 3 4 3 3 4 4 4 3 3 3 4 4 4 moscap_routing
* cell instance $2 r0 *1 106.05,215.665
X$2 25 3 20 18 moscap_corner
* cell instance $3 r0 *1 157.75,215.665
X$3 25 3 20 18 moscap_corner
* cell instance $4 r0 *1 209.45,215.665
X$4 25 3 20 18 moscap_corner
* cell instance $5 r0 *1 54.35,215.665
X$5 25 3 20 18 moscap_corner_1
* cell instance $6 r0 *1 126.49,143.515
X$6 3 25 26 24 moscap_corner_2
* cell instance $7 r0 *1 178.19,143.515
X$7 25 3 26 24 moscap_corner
* cell instance $8 r0 *1 229.89,143.515
X$8 25 3 26 24 moscap_corner
* cell instance $9 r0 *1 176.85,81.755
X$9 4 27 28 28 moscap_corner_3
* cell instance $10 r0 *1 229.89,81.755
X$10 23 4 28 28 moscap_corner
* cell instance $11 r0 *1 67.5,67.5
X$11 7 16 15 14 13 8 9 11 10 12 5 ESD_CLAMP_COR
* cell instance $12 r0 *1 299.385,283.635
X$12 22 6 21 19 moscap_corner
* cell instance $13 r0 *1 324.195,348.715
X$13 6 22 M1_PSUB_CDNS_406619561348
.ENDS GF_NI_COR_BASE

* cell POWER_RAIL_COR
* pin
* pin
* pin DVSS
* pin DVDD
* pin VSS
* pin VDD
.SUBCKT POWER_RAIL_COR 1 2 3 4 5 6
* net 3 DVSS
* net 4 DVDD
* net 5 VSS
* net 6 VDD
* cell instance $1 r180 *1 290.035,65.97
X$1 2 1 M1_PSUB_CDNS_406619561340
* cell instance $2 r0 *1 224.365,66.165
X$2 2 1 M1_PSUB_CDNS_406619561345
* cell instance $3 r90 *1 65.97,290.02
X$3 2 1 M1_PSUB_CDNS_406619561344
* cell instance $4 r90 *1 354.495,208.245
X$4 2 1 M1_PSUB_CDNS_406619561343
* cell instance $5 r0 *1 351.175,349.355
X$5 2 1 M1_PSUB_CDNS_406619561342
* cell instance $6 r90 *1 349.355,351.925
X$6 2 1 M1_PSUB_CDNS_406619561341
* cell instance $7 r0 *1 208.18,354.5
X$7 2 1 M1_PSUB_CDNS_406619561343
* cell instance $8 r0 *1 126.445,163.945
X$8 2 1 M1_PSUB_CDNS_406619561345
* cell instance $9 r0 *1 105.985,184.405
X$9 2 1 M1_PSUB_CDNS_406619561345
* cell instance $10 r0 *1 127.105,163.285
X$10 2 1 M1_PSUB_CDNS_406619561345
* cell instance $11 r0 *1 127.765,162.625
X$11 2 1 M1_PSUB_CDNS_406619561345
* cell instance $12 r0 *1 128.425,161.965
X$12 2 1 M1_PSUB_CDNS_406619561345
* cell instance $13 r0 *1 129.745,160.645
X$13 2 1 M1_PSUB_CDNS_406619561345
* cell instance $14 r0 *1 130.405,159.985
X$14 2 1 M1_PSUB_CDNS_406619561345
* cell instance $15 r0 *1 131.065,159.325
X$15 2 1 M1_PSUB_CDNS_406619561345
* cell instance $16 r0 *1 131.725,158.665
X$16 2 1 M1_PSUB_CDNS_406619561345
* cell instance $17 r0 *1 132.385,158.005
X$17 2 1 M1_PSUB_CDNS_406619561345
* cell instance $18 r0 *1 133.045,157.345
X$18 2 1 M1_PSUB_CDNS_406619561345
* cell instance $19 r0 *1 133.705,156.685
X$19 2 1 M1_PSUB_CDNS_406619561345
* cell instance $20 r0 *1 129.085,161.305
X$20 2 1 M1_PSUB_CDNS_406619561345
* cell instance $21 r0 *1 125.785,164.605
X$21 2 1 M1_PSUB_CDNS_406619561345
* cell instance $22 r0 *1 135.025,155.365
X$22 2 1 M1_PSUB_CDNS_406619561345
* cell instance $23 r0 *1 85.525,204.865
X$23 2 1 M1_PSUB_CDNS_406619561345
* cell instance $24 r0 *1 84.205,206.185
X$24 2 1 M1_PSUB_CDNS_406619561345
* cell instance $25 r0 *1 83.545,206.845
X$25 2 1 M1_PSUB_CDNS_406619561345
* cell instance $26 r0 *1 82.885,207.505
X$26 2 1 M1_PSUB_CDNS_406619561345
* cell instance $27 r0 *1 82.225,208.165
X$27 2 1 M1_PSUB_CDNS_406619561345
* cell instance $28 r0 *1 81.565,208.825
X$28 2 1 M1_PSUB_CDNS_406619561345
* cell instance $29 r0 *1 80.905,209.485
X$29 2 1 M1_PSUB_CDNS_406619561345
* cell instance $30 r0 *1 95.425,194.965
X$30 2 1 M1_PSUB_CDNS_406619561345
* cell instance $31 r0 *1 104.665,185.725
X$31 2 1 M1_PSUB_CDNS_406619561345
* cell instance $32 r0 *1 104.005,186.385
X$32 2 1 M1_PSUB_CDNS_406619561345
* cell instance $33 r0 *1 103.345,187.045
X$33 2 1 M1_PSUB_CDNS_406619561345
* cell instance $34 r0 *1 102.685,187.705
X$34 2 1 M1_PSUB_CDNS_406619561345
* cell instance $35 r0 *1 101.365,189.025
X$35 2 1 M1_PSUB_CDNS_406619561345
* cell instance $36 r0 *1 134.365,156.025
X$36 2 1 M1_PSUB_CDNS_406619561345
* cell instance $37 r0 *1 114.565,175.825
X$37 2 1 M1_PSUB_CDNS_406619561345
* cell instance $38 r0 *1 113.245,177.145
X$38 2 1 M1_PSUB_CDNS_406619561345
* cell instance $39 r0 *1 112.585,177.805
X$39 2 1 M1_PSUB_CDNS_406619561345
* cell instance $40 r0 *1 111.925,178.465
X$40 2 1 M1_PSUB_CDNS_406619561345
* cell instance $41 r0 *1 111.265,179.125
X$41 2 1 M1_PSUB_CDNS_406619561345
* cell instance $42 r0 *1 110.605,179.785
X$42 2 1 M1_PSUB_CDNS_406619561345
* cell instance $43 r0 *1 109.945,180.445
X$43 2 1 M1_PSUB_CDNS_406619561345
* cell instance $44 r0 *1 109.285,181.105
X$44 2 1 M1_PSUB_CDNS_406619561345
* cell instance $45 r0 *1 108.625,181.765
X$45 2 1 M1_PSUB_CDNS_406619561345
* cell instance $46 r0 *1 107.965,182.425
X$46 2 1 M1_PSUB_CDNS_406619561345
* cell instance $47 r0 *1 107.305,183.085
X$47 2 1 M1_PSUB_CDNS_406619561345
* cell instance $48 r0 *1 106.645,183.745
X$48 2 1 M1_PSUB_CDNS_406619561345
* cell instance $49 r0 *1 105.325,185.065
X$49 2 1 M1_PSUB_CDNS_406619561345
* cell instance $50 r0 *1 102.025,188.365
X$50 2 1 M1_PSUB_CDNS_406619561345
* cell instance $51 r0 *1 92.785,197.605
X$51 2 1 M1_PSUB_CDNS_406619561345
* cell instance $52 r0 *1 92.125,198.265
X$52 2 1 M1_PSUB_CDNS_406619561345
* cell instance $53 r0 *1 91.465,198.925
X$53 2 1 M1_PSUB_CDNS_406619561345
* cell instance $54 r0 *1 90.805,199.585
X$54 2 1 M1_PSUB_CDNS_406619561345
* cell instance $55 r0 *1 84.865,205.525
X$55 2 1 M1_PSUB_CDNS_406619561345
* cell instance $56 r0 *1 90.145,200.245
X$56 2 1 M1_PSUB_CDNS_406619561345
* cell instance $57 r0 *1 89.485,200.905
X$57 2 1 M1_PSUB_CDNS_406619561345
* cell instance $58 r0 *1 88.825,201.565
X$58 2 1 M1_PSUB_CDNS_406619561345
* cell instance $59 r0 *1 88.165,202.225
X$59 2 1 M1_PSUB_CDNS_406619561345
* cell instance $60 r0 *1 87.505,202.885
X$60 2 1 M1_PSUB_CDNS_406619561345
* cell instance $61 r0 *1 86.845,203.545
X$61 2 1 M1_PSUB_CDNS_406619561345
* cell instance $62 r0 *1 137.005,153.385
X$62 2 1 M1_PSUB_CDNS_406619561345
* cell instance $63 r0 *1 136.345,154.045
X$63 2 1 M1_PSUB_CDNS_406619561345
* cell instance $64 r0 *1 135.685,154.705
X$64 2 1 M1_PSUB_CDNS_406619561345
* cell instance $65 r0 *1 124.465,165.925
X$65 2 1 M1_PSUB_CDNS_406619561345
* cell instance $66 r0 *1 148.885,141.505
X$66 2 1 M1_PSUB_CDNS_406619561345
* cell instance $67 r0 *1 148.225,142.165
X$67 2 1 M1_PSUB_CDNS_406619561345
* cell instance $68 r0 *1 147.565,142.825
X$68 2 1 M1_PSUB_CDNS_406619561345
* cell instance $69 r0 *1 146.905,143.485
X$69 2 1 M1_PSUB_CDNS_406619561345
* cell instance $70 r0 *1 137.665,152.725
X$70 2 1 M1_PSUB_CDNS_406619561345
* cell instance $71 r0 *1 152.845,137.545
X$71 2 1 M1_PSUB_CDNS_406619561345
* cell instance $72 r0 *1 68.365,222.025
X$72 2 1 M1_PSUB_CDNS_406619561345
* cell instance $73 r0 *1 67.705,222.685
X$73 2 1 M1_PSUB_CDNS_406619561345
* cell instance $74 r0 *1 67.045,223.345
X$74 2 1 M1_PSUB_CDNS_406619561345
* cell instance $75 r0 *1 66.385,224.005
X$75 2 1 M1_PSUB_CDNS_406619561345
* cell instance $76 r0 *1 75.625,214.765
X$76 2 1 M1_PSUB_CDNS_406619561345
* cell instance $77 r0 *1 79.585,210.805
X$77 2 1 M1_PSUB_CDNS_406619561345
* cell instance $78 r0 *1 78.925,211.465
X$78 2 1 M1_PSUB_CDNS_406619561345
* cell instance $79 r0 *1 113.905,176.485
X$79 2 1 M1_PSUB_CDNS_406619561345
* cell instance $80 r0 *1 77.605,212.785
X$80 2 1 M1_PSUB_CDNS_406619561345
* cell instance $81 r0 *1 76.945,213.445
X$81 2 1 M1_PSUB_CDNS_406619561345
* cell instance $82 r0 *1 76.285,214.105
X$82 2 1 M1_PSUB_CDNS_406619561345
* cell instance $83 r0 *1 74.965,215.425
X$83 2 1 M1_PSUB_CDNS_406619561345
* cell instance $84 r0 *1 74.305,216.085
X$84 2 1 M1_PSUB_CDNS_406619561345
* cell instance $85 r0 *1 73.645,216.745
X$85 2 1 M1_PSUB_CDNS_406619561345
* cell instance $86 r0 *1 72.985,217.405
X$86 2 1 M1_PSUB_CDNS_406619561345
* cell instance $87 r0 *1 72.325,218.065
X$87 2 1 M1_PSUB_CDNS_406619561345
* cell instance $88 r0 *1 71.665,218.725
X$88 2 1 M1_PSUB_CDNS_406619561345
* cell instance $89 r0 *1 71.005,219.385
X$89 2 1 M1_PSUB_CDNS_406619561345
* cell instance $90 r0 *1 70.345,220.045
X$90 2 1 M1_PSUB_CDNS_406619561345
* cell instance $91 r0 *1 69.685,220.705
X$91 2 1 M1_PSUB_CDNS_406619561345
* cell instance $92 r0 *1 69.025,221.365
X$92 2 1 M1_PSUB_CDNS_406619561345
* cell instance $93 r0 *1 80.245,210.145
X$93 2 1 M1_PSUB_CDNS_406619561345
* cell instance $94 r0 *1 78.265,212.125
X$94 2 1 M1_PSUB_CDNS_406619561345
* cell instance $95 r0 *1 100.705,189.685
X$95 2 1 M1_PSUB_CDNS_406619561345
* cell instance $96 r0 *1 100.045,190.345
X$96 2 1 M1_PSUB_CDNS_406619561345
* cell instance $97 r0 *1 99.385,191.005
X$97 2 1 M1_PSUB_CDNS_406619561345
* cell instance $98 r0 *1 98.725,191.665
X$98 2 1 M1_PSUB_CDNS_406619561345
* cell instance $99 r0 *1 98.065,192.325
X$99 2 1 M1_PSUB_CDNS_406619561345
* cell instance $100 r0 *1 97.405,192.985
X$100 2 1 M1_PSUB_CDNS_406619561345
* cell instance $101 r0 *1 96.745,193.645
X$101 2 1 M1_PSUB_CDNS_406619561345
* cell instance $102 r0 *1 96.085,194.305
X$102 2 1 M1_PSUB_CDNS_406619561345
* cell instance $103 r0 *1 86.185,204.205
X$103 2 1 M1_PSUB_CDNS_406619561345
* cell instance $104 r0 *1 94.765,195.625
X$104 2 1 M1_PSUB_CDNS_406619561345
* cell instance $105 r0 *1 94.105,196.285
X$105 2 1 M1_PSUB_CDNS_406619561345
* cell instance $106 r0 *1 93.445,196.945
X$106 2 1 M1_PSUB_CDNS_406619561345
* cell instance $107 r0 *1 145.585,144.805
X$107 2 1 M1_PSUB_CDNS_406619561345
* cell instance $108 r0 *1 144.265,146.125
X$108 2 1 M1_PSUB_CDNS_406619561345
* cell instance $109 r0 *1 149.545,140.845
X$109 2 1 M1_PSUB_CDNS_406619561345
* cell instance $110 r0 *1 142.285,148.105
X$110 2 1 M1_PSUB_CDNS_406619561345
* cell instance $111 r0 *1 141.625,148.765
X$111 2 1 M1_PSUB_CDNS_406619561345
* cell instance $112 r0 *1 140.965,149.425
X$112 2 1 M1_PSUB_CDNS_406619561345
* cell instance $113 r0 *1 140.305,150.085
X$113 2 1 M1_PSUB_CDNS_406619561345
* cell instance $114 r0 *1 139.645,150.745
X$114 2 1 M1_PSUB_CDNS_406619561345
* cell instance $115 r0 *1 138.985,151.405
X$115 2 1 M1_PSUB_CDNS_406619561345
* cell instance $116 r0 *1 138.325,152.065
X$116 2 1 M1_PSUB_CDNS_406619561345
* cell instance $117 r0 *1 143.605,146.785
X$117 2 1 M1_PSUB_CDNS_406619561345
* cell instance $118 r0 *1 144.925,145.465
X$118 2 1 M1_PSUB_CDNS_406619561345
* cell instance $119 r0 *1 146.245,144.145
X$119 2 1 M1_PSUB_CDNS_406619561345
* cell instance $120 r0 *1 152.185,138.205
X$120 2 1 M1_PSUB_CDNS_406619561345
* cell instance $121 r0 *1 151.525,138.865
X$121 2 1 M1_PSUB_CDNS_406619561345
* cell instance $122 r0 *1 150.865,139.525
X$122 2 1 M1_PSUB_CDNS_406619561345
* cell instance $123 r0 *1 150.205,140.185
X$123 2 1 M1_PSUB_CDNS_406619561345
* cell instance $124 r0 *1 142.945,147.445
X$124 2 1 M1_PSUB_CDNS_406619561345
* cell instance $125 r0 *1 172.645,117.745
X$125 2 1 M1_PSUB_CDNS_406619561345
* cell instance $126 r0 *1 173.305,117.085
X$126 2 1 M1_PSUB_CDNS_406619561345
* cell instance $127 r0 *1 173.965,116.425
X$127 2 1 M1_PSUB_CDNS_406619561345
* cell instance $128 r0 *1 166.045,124.345
X$128 2 1 M1_PSUB_CDNS_406619561345
* cell instance $129 r0 *1 206.305,84.085
X$129 2 1 M1_PSUB_CDNS_406619561345
* cell instance $130 r0 *1 181.225,109.165
X$130 2 1 M1_PSUB_CDNS_406619561345
* cell instance $131 r0 *1 186.505,103.885
X$131 2 1 M1_PSUB_CDNS_406619561345
* cell instance $132 r0 *1 185.845,104.545
X$132 2 1 M1_PSUB_CDNS_406619561345
* cell instance $133 r0 *1 185.185,105.205
X$133 2 1 M1_PSUB_CDNS_406619561345
* cell instance $134 r0 *1 184.525,105.865
X$134 2 1 M1_PSUB_CDNS_406619561345
* cell instance $135 r0 *1 183.865,106.525
X$135 2 1 M1_PSUB_CDNS_406619561345
* cell instance $136 r0 *1 183.205,107.185
X$136 2 1 M1_PSUB_CDNS_406619561345
* cell instance $137 r0 *1 182.545,107.845
X$137 2 1 M1_PSUB_CDNS_406619561345
* cell instance $138 r0 *1 181.885,108.505
X$138 2 1 M1_PSUB_CDNS_406619561345
* cell instance $139 r0 *1 154.825,135.565
X$139 2 1 M1_PSUB_CDNS_406619561345
* cell instance $140 r0 *1 164.065,126.325
X$140 2 1 M1_PSUB_CDNS_406619561345
* cell instance $141 r0 *1 163.405,126.985
X$141 2 1 M1_PSUB_CDNS_406619561345
* cell instance $142 r0 *1 162.745,127.645
X$142 2 1 M1_PSUB_CDNS_406619561345
* cell instance $143 r0 *1 162.085,128.305
X$143 2 1 M1_PSUB_CDNS_406619561345
* cell instance $144 r0 *1 161.425,128.965
X$144 2 1 M1_PSUB_CDNS_406619561345
* cell instance $145 r0 *1 160.765,129.625
X$145 2 1 M1_PSUB_CDNS_406619561345
* cell instance $146 r0 *1 160.105,130.285
X$146 2 1 M1_PSUB_CDNS_406619561345
* cell instance $147 r0 *1 159.445,130.945
X$147 2 1 M1_PSUB_CDNS_406619561345
* cell instance $148 r0 *1 158.785,131.605
X$148 2 1 M1_PSUB_CDNS_406619561345
* cell instance $149 r0 *1 158.125,132.265
X$149 2 1 M1_PSUB_CDNS_406619561345
* cell instance $150 r0 *1 157.465,132.925
X$150 2 1 M1_PSUB_CDNS_406619561345
* cell instance $151 r0 *1 156.805,133.585
X$151 2 1 M1_PSUB_CDNS_406619561345
* cell instance $152 r0 *1 156.145,134.245
X$152 2 1 M1_PSUB_CDNS_406619561345
* cell instance $153 r0 *1 165.385,125.005
X$153 2 1 M1_PSUB_CDNS_406619561345
* cell instance $154 r0 *1 164.725,125.665
X$154 2 1 M1_PSUB_CDNS_406619561345
* cell instance $155 r0 *1 223.465,66.925
X$155 2 1 M1_PSUB_CDNS_406619561345
* cell instance $156 r0 *1 222.805,67.585
X$156 2 1 M1_PSUB_CDNS_406619561345
* cell instance $157 r0 *1 222.145,68.245
X$157 2 1 M1_PSUB_CDNS_406619561345
* cell instance $158 r0 *1 221.485,68.905
X$158 2 1 M1_PSUB_CDNS_406619561345
* cell instance $159 r0 *1 220.825,69.565
X$159 2 1 M1_PSUB_CDNS_406619561345
* cell instance $160 r0 *1 220.165,70.225
X$160 2 1 M1_PSUB_CDNS_406619561345
* cell instance $161 r0 *1 219.505,70.885
X$161 2 1 M1_PSUB_CDNS_406619561345
* cell instance $162 r0 *1 218.845,71.545
X$162 2 1 M1_PSUB_CDNS_406619561345
* cell instance $163 r0 *1 218.185,72.205
X$163 2 1 M1_PSUB_CDNS_406619561345
* cell instance $164 r0 *1 217.525,72.865
X$164 2 1 M1_PSUB_CDNS_406619561345
* cell instance $165 r0 *1 216.865,73.525
X$165 2 1 M1_PSUB_CDNS_406619561345
* cell instance $166 r0 *1 216.205,74.185
X$166 2 1 M1_PSUB_CDNS_406619561345
* cell instance $167 r0 *1 215.545,74.845
X$167 2 1 M1_PSUB_CDNS_406619561345
* cell instance $168 r0 *1 214.225,76.165
X$168 2 1 M1_PSUB_CDNS_406619561345
* cell instance $169 r0 *1 171.985,118.405
X$169 2 1 M1_PSUB_CDNS_406619561345
* cell instance $170 r0 *1 212.905,77.485
X$170 2 1 M1_PSUB_CDNS_406619561345
* cell instance $171 r0 *1 212.245,78.145
X$171 2 1 M1_PSUB_CDNS_406619561345
* cell instance $172 r0 *1 211.585,78.805
X$172 2 1 M1_PSUB_CDNS_406619561345
* cell instance $173 r0 *1 210.925,79.465
X$173 2 1 M1_PSUB_CDNS_406619561345
* cell instance $174 r0 *1 214.885,75.505
X$174 2 1 M1_PSUB_CDNS_406619561345
* cell instance $175 r0 *1 194.425,95.965
X$175 2 1 M1_PSUB_CDNS_406619561345
* cell instance $176 r0 *1 193.765,96.625
X$176 2 1 M1_PSUB_CDNS_406619561345
* cell instance $177 r0 *1 193.105,97.285
X$177 2 1 M1_PSUB_CDNS_406619561345
* cell instance $178 r0 *1 192.445,97.945
X$178 2 1 M1_PSUB_CDNS_406619561345
* cell instance $179 r0 *1 191.785,98.605
X$179 2 1 M1_PSUB_CDNS_406619561345
* cell instance $180 r0 *1 169.345,121.045
X$180 2 1 M1_PSUB_CDNS_406619561345
* cell instance $181 r0 *1 170.005,120.385
X$181 2 1 M1_PSUB_CDNS_406619561345
* cell instance $182 r0 *1 170.665,119.725
X$182 2 1 M1_PSUB_CDNS_406619561345
* cell instance $183 r0 *1 171.325,119.065
X$183 2 1 M1_PSUB_CDNS_406619561345
* cell instance $184 r0 *1 213.565,76.825
X$184 2 1 M1_PSUB_CDNS_406619561345
* cell instance $185 r0 *1 197.725,92.665
X$185 2 1 M1_PSUB_CDNS_406619561345
* cell instance $186 r0 *1 191.125,99.265
X$186 2 1 M1_PSUB_CDNS_406619561345
* cell instance $187 r0 *1 190.465,99.925
X$187 2 1 M1_PSUB_CDNS_406619561345
* cell instance $188 r0 *1 189.805,100.585
X$188 2 1 M1_PSUB_CDNS_406619561345
* cell instance $189 r0 *1 189.145,101.245
X$189 2 1 M1_PSUB_CDNS_406619561345
* cell instance $190 r0 *1 188.485,101.905
X$190 2 1 M1_PSUB_CDNS_406619561345
* cell instance $191 r0 *1 187.825,102.565
X$191 2 1 M1_PSUB_CDNS_406619561345
* cell instance $192 r0 *1 187.165,103.225
X$192 2 1 M1_PSUB_CDNS_406619561345
* cell instance $193 r0 *1 197.065,93.325
X$193 2 1 M1_PSUB_CDNS_406619561345
* cell instance $194 r0 *1 175.285,115.105
X$194 2 1 M1_PSUB_CDNS_406619561345
* cell instance $195 r0 *1 195.745,94.645
X$195 2 1 M1_PSUB_CDNS_406619561345
* cell instance $196 r0 *1 166.705,123.685
X$196 2 1 M1_PSUB_CDNS_406619561345
* cell instance $197 r0 *1 167.365,123.025
X$197 2 1 M1_PSUB_CDNS_406619561345
* cell instance $198 r0 *1 168.025,122.365
X$198 2 1 M1_PSUB_CDNS_406619561345
* cell instance $199 r0 *1 198.385,92.005
X$199 2 1 M1_PSUB_CDNS_406619561345
* cell instance $200 r0 *1 115.225,175.165
X$200 2 1 M1_PSUB_CDNS_406619561345
* cell instance $201 r0 *1 116.545,173.845
X$201 2 1 M1_PSUB_CDNS_406619561345
* cell instance $202 r0 *1 117.205,173.185
X$202 2 1 M1_PSUB_CDNS_406619561345
* cell instance $203 r0 *1 117.865,172.525
X$203 2 1 M1_PSUB_CDNS_406619561345
* cell instance $204 r0 *1 118.525,171.865
X$204 2 1 M1_PSUB_CDNS_406619561345
* cell instance $205 r0 *1 119.185,171.205
X$205 2 1 M1_PSUB_CDNS_406619561345
* cell instance $206 r0 *1 119.845,170.545
X$206 2 1 M1_PSUB_CDNS_406619561345
* cell instance $207 r0 *1 120.505,169.885
X$207 2 1 M1_PSUB_CDNS_406619561345
* cell instance $208 r0 *1 121.165,169.225
X$208 2 1 M1_PSUB_CDNS_406619561345
* cell instance $209 r0 *1 121.825,168.565
X$209 2 1 M1_PSUB_CDNS_406619561345
* cell instance $210 r0 *1 122.485,167.905
X$210 2 1 M1_PSUB_CDNS_406619561345
* cell instance $211 r0 *1 123.145,167.245
X$211 2 1 M1_PSUB_CDNS_406619561345
* cell instance $212 r0 *1 123.805,166.585
X$212 2 1 M1_PSUB_CDNS_406619561345
* cell instance $213 r0 *1 125.125,165.265
X$213 2 1 M1_PSUB_CDNS_406619561345
* cell instance $214 r0 *1 210.265,80.125
X$214 2 1 M1_PSUB_CDNS_406619561345
* cell instance $215 r0 *1 168.685,121.705
X$215 2 1 M1_PSUB_CDNS_406619561345
* cell instance $216 r0 *1 115.885,174.505
X$216 2 1 M1_PSUB_CDNS_406619561345
* cell instance $217 r0 *1 153.505,136.885
X$217 2 1 M1_PSUB_CDNS_406619561345
* cell instance $218 r0 *1 195.085,95.305
X$218 2 1 M1_PSUB_CDNS_406619561345
* cell instance $219 r0 *1 155.485,134.905
X$219 2 1 M1_PSUB_CDNS_406619561345
* cell instance $220 r0 *1 180.565,109.825
X$220 2 1 M1_PSUB_CDNS_406619561345
* cell instance $221 r0 *1 179.905,110.485
X$221 2 1 M1_PSUB_CDNS_406619561345
* cell instance $222 r0 *1 179.245,111.145
X$222 2 1 M1_PSUB_CDNS_406619561345
* cell instance $223 r0 *1 178.585,111.805
X$223 2 1 M1_PSUB_CDNS_406619561345
* cell instance $224 r0 *1 177.925,112.465
X$224 2 1 M1_PSUB_CDNS_406619561345
* cell instance $225 r0 *1 177.265,113.125
X$225 2 1 M1_PSUB_CDNS_406619561345
* cell instance $226 r0 *1 176.605,113.785
X$226 2 1 M1_PSUB_CDNS_406619561345
* cell instance $227 r0 *1 175.945,114.445
X$227 2 1 M1_PSUB_CDNS_406619561345
* cell instance $228 r0 *1 174.625,115.765
X$228 2 1 M1_PSUB_CDNS_406619561345
* cell instance $229 r0 *1 209.605,80.785
X$229 2 1 M1_PSUB_CDNS_406619561345
* cell instance $230 r0 *1 208.945,81.445
X$230 2 1 M1_PSUB_CDNS_406619561345
* cell instance $231 r0 *1 208.285,82.105
X$231 2 1 M1_PSUB_CDNS_406619561345
* cell instance $232 r0 *1 154.165,136.225
X$232 2 1 M1_PSUB_CDNS_406619561345
* cell instance $233 r0 *1 199.705,90.685
X$233 2 1 M1_PSUB_CDNS_406619561345
* cell instance $234 r0 *1 200.365,90.025
X$234 2 1 M1_PSUB_CDNS_406619561345
* cell instance $235 r0 *1 201.025,89.365
X$235 2 1 M1_PSUB_CDNS_406619561345
* cell instance $236 r0 *1 201.685,88.705
X$236 2 1 M1_PSUB_CDNS_406619561345
* cell instance $237 r0 *1 202.345,88.045
X$237 2 1 M1_PSUB_CDNS_406619561345
* cell instance $238 r0 *1 203.005,87.385
X$238 2 1 M1_PSUB_CDNS_406619561345
* cell instance $239 r0 *1 203.665,86.725
X$239 2 1 M1_PSUB_CDNS_406619561345
* cell instance $240 r0 *1 204.325,86.065
X$240 2 1 M1_PSUB_CDNS_406619561345
* cell instance $241 r0 *1 204.985,85.405
X$241 2 1 M1_PSUB_CDNS_406619561345
* cell instance $242 r0 *1 205.645,84.745
X$242 2 1 M1_PSUB_CDNS_406619561345
* cell instance $243 r0 *1 196.405,93.985
X$243 2 1 M1_PSUB_CDNS_406619561345
* cell instance $244 r0 *1 206.965,83.425
X$244 2 1 M1_PSUB_CDNS_406619561345
* cell instance $245 r0 *1 199.045,91.345
X$245 2 1 M1_PSUB_CDNS_406619561345
* cell instance $246 r0 *1 207.625,82.765
X$246 2 1 M1_PSUB_CDNS_406619561345
* cell instance $247 r0 *1 353.205,121.53
X$247 4 7 M3_M2_CDNS_406619561346
* cell instance $248 r0 *1 353.205,141.6
X$248 4 7 M3_M2_CDNS_406619561347
* cell instance $249 r0 *1 353.205,173.5
X$249 4 7 M3_M2_CDNS_406619561347
* cell instance $250 r0 *1 353.205,189.5
X$250 4 7 M3_M2_CDNS_406619561347
* cell instance $251 r0 *1 353.205,221.535
X$251 4 7 M3_M2_CDNS_406619561347
* cell instance $252 r0 *1 353.205,157.44
X$252 4 7 M3_M2_CDNS_406619561347
* cell instance $253 r0 *1 353.205,281.55
X$253 4 7 M3_M2_CDNS_406619561346
* cell instance $254 r0 *1 353.205,273.51
X$254 4 7 M3_M2_CDNS_406619561346
* cell instance $255 r0 *1 353.205,265.61
X$255 4 7 M3_M2_CDNS_406619561346
* cell instance $256 r0 *1 353.205,337.58
X$256 4 7 M3_M2_CDNS_406619561346
* cell instance $257 r0 *1 353.205,297.6
X$257 4 7 M3_M2_CDNS_406619561346
* cell instance $258 r0 *1 353.205,209.485
X$258 4 7 M3_M2_CDNS_406619561346
.ENDS POWER_RAIL_COR

* cell GF_NI_BI_T_BASE
* pin
* pin
* pin
* pin PAD
* pin
* pin PDRV0
* pin
* pin A
* pin
* pin
* pin
* pin
* pin
* pin
* pin
* pin
* pin
* pin OE
* pin SL
* pin
* pin
* pin PDRV1
* pin
* pin
* pin
* pin
* pin
* pin PU
* pin
* pin PD
* pin
* pin
* pin CS
* pin IE
* pin Y
* pin
* pin
* pin
* pin gf180mcu_gnd
* pin
* pin
* pin
* pin
* pin
* pin
* pin
* pin
* pin
* pin
* pin
* pin
* pin
* pin
* pin
* pin
* pin
* pin
.SUBCKT GF_NI_BI_T_BASE 1 3 4 14 44 73 76 78 80 81 82 84 87 88 89 91 95 96 99
+ 101 103 107 110 113 115 119 120 121 124 129 132 137 138 139 141 146 153 156
+ 160 161 162 163 164 165 166 167 168 169 170 171 172 173 174 213 219 235 288
* net 6 ndrive_x_<0>
* net 7 ndrive_y_<0>
* net 8 ndrive_x_<1>
* net 9 ndrive_Y_<1>
* net 10 pdrive_x_<0>
* net 11 pdrive_y_<0>
* net 12 pdrive_y_<1>
* net 13 pdrive_x_<1>
* net 14 PAD
* net 15 pdrive_x_<2>
* net 16 pdrive_y_<2>
* net 17 pdrive_y_<3>
* net 18 pdrive_x_<3>
* net 19 ndrive_x_<2>
* net 20 ndrive_y_<2>
* net 21 ndrive_x_<3>
* net 22 ndrive_Y_<3>
* net 73 PDRV0
* net 78 A
* net 96 OE
* net 99 SL
* net 107 PDRV1
* net 121 PU
* net 129 PD
* net 138 CS
* net 139 IE
* net 141 Y
* net 160 gf180mcu_gnd
* cell instance $1 r0 *1 37.51,5.605
X$1 1 M1_PSUB_CDNS_40661956134441
* cell instance $2 m90 *1 1.17,30.87
X$2 1 M1_PSUB_CDNS_40661956134442
* cell instance $3 r0 *1 73.84,30.87
X$3 1 M1_PSUB_CDNS_40661956134442
* cell instance $4 r0 *1 0.42,259.35
X$4 1 120 M3_M2_CDNS_40661956134284
* cell instance $5 r0 *1 0.42,259.35
X$5 1 120 M2_M1_CDNS_40661956134240
* cell instance $6 r0 *1 74.9,187.465
X$6 1 80 M2_M1_CDNS_40661956134240
* cell instance $7 r0 *1 74.9,187.465
X$7 1 80 M3_M2_CDNS_40661956134284
* cell instance $8 r0 *1 0.42,187.465
X$8 1 81 M2_M1_CDNS_40661956134240
* cell instance $9 r0 *1 0.42,187.465
X$9 1 81 M3_M2_CDNS_40661956134284
* cell instance $10 r0 *1 74.9,259.35
X$10 1 119 M2_M1_CDNS_40661956134240
* cell instance $11 r0 *1 74.9,259.35
X$11 1 119 M3_M2_CDNS_40661956134284
* cell instance $12 r0 *1 3.97,7.325
X$12 33 31 24 23 36 32 29 30 110 4 9 8 7 6 19 20 21 22 14 166 160 172 171 170
+ 169 168 167 165 164 163 18 18 17 16 15 15 13 13 12 11 10 10 3 2 2 5
+ comp018green_out_paddrv_16T
* cell instance $13 r0 *1 1.37,139.5
X$13 3 2 M3_M2_CDNS_40661956134313
* cell instance $14 r0 *1 1.37,31.5
X$14 3 2 M3_M2_CDNS_40661956134312
* cell instance $15 r0 *1 1.37,47.5
X$15 3 2 M3_M2_CDNS_40661956134312
* cell instance $16 r0 *1 1.37,15.5
X$16 3 2 M3_M2_CDNS_40661956134312
* cell instance $17 r0 *1 1.37,175.5
X$17 3 2 M3_M2_CDNS_40661956134312
* cell instance $18 r0 *1 72.36,245.31
X$18 4 5 M2_M1_CDNS_40661956134436
* cell instance $19 r0 *1 72.36,240.47
X$19 4 5 M2_M1_CDNS_40661956134436
* cell instance $20 r0 *1 72.9,127.5
X$20 4 5 M3_M2_CDNS_40661956134311
* cell instance $21 r0 *1 72.9,111.5
X$21 4 5 M3_M2_CDNS_40661956134311
* cell instance $22 r0 *1 72.9,95.5
X$22 4 5 M3_M2_CDNS_40661956134311
* cell instance $23 r0 *1 72.9,79.5
X$23 4 5 M3_M2_CDNS_40661956134311
* cell instance $24 r180 *1 37.885,179.845
X$24 44 13 279 64 66 55 44 12 59 8 9 259 4 278 54 276 4 275 160 69 72
+ comp018green_out_predrv
* cell instance $25 m0 *1 2.395,179.845
X$25 44 10 279 50 56 55 44 11 59 6 7 263 4 278 54 276 4 275 160 62 52
+ comp018green_out_predrv
* cell instance $26 m0 *1 37.435,179.845
X$26 44 15 279 64 66 55 44 16 59 19 20 258 4 277 54 276 4 275 160 60 70
+ comp018green_out_predrv
* cell instance $27 r180 *1 72.925,179.845
X$27 44 18 279 47 48 55 44 17 59 21 22 268 4 277 54 276 4 275 160 61 79
+ comp018green_out_predrv
* cell instance $28 r0 *1 2.62,159.765
X$28 4 289 M2_M1_CDNS_40661956134236
* cell instance $29 r0 *1 13.31,150.405
X$29 4 281 M2_M1_CDNS_40661956134309
* cell instance $30 r0 *1 13.31,150.405
X$30 4 281 M3_M2_CDNS_40661956134310
* cell instance $31 r0 *1 62.995,150.405
X$31 4 280 M2_M1_CDNS_40661956134309
* cell instance $32 r0 *1 62.995,150.405
X$32 4 280 M3_M2_CDNS_40661956134310
* cell instance $33 r0 *1 72.7,159.765
X$33 4 5 M2_M1_CDNS_40661956134236
* cell instance $34 r0 *1 72.9,147.5
X$34 4 5 M3_M2_CDNS_40661956134285
* cell instance $35 r0 *1 2.62,159.5
X$35 4 289 M3_M2_CDNS_40661956134304
* cell instance $36 r0 *1 5.03,157.86
X$36 4 284 M2_M1_CDNS_40661956134305
* cell instance $37 r0 *1 5.03,157.995
X$37 4 284 M3_M2_CDNS_40661956134306
* cell instance $38 r0 *1 11.99,157.86
X$38 4 282 M2_M1_CDNS_40661956134305
* cell instance $39 r0 *1 11.99,157.995
X$39 4 282 M3_M2_CDNS_40661956134306
* cell instance $40 r0 *1 14.07,157.86
X$40 4 272 M2_M1_CDNS_40661956134305
* cell instance $41 r0 *1 14.07,157.995
X$41 4 272 M3_M2_CDNS_40661956134306
* cell instance $42 r0 *1 35.25,157.86
X$42 4 285 M2_M1_CDNS_40661956134305
* cell instance $43 r0 *1 35.25,157.995
X$43 4 285 M3_M2_CDNS_40661956134306
* cell instance $44 r0 *1 40.07,157.86
X$44 4 274 M2_M1_CDNS_40661956134305
* cell instance $45 r0 *1 40.07,157.995
X$45 4 274 M3_M2_CDNS_40661956134306
* cell instance $46 r0 *1 61.25,157.86
X$46 4 283 M2_M1_CDNS_40661956134305
* cell instance $47 r0 *1 61.25,157.995
X$47 4 283 M3_M2_CDNS_40661956134306
* cell instance $48 r0 *1 63.33,157.86
X$48 4 273 M2_M1_CDNS_40661956134305
* cell instance $49 r0 *1 63.33,157.995
X$49 4 273 M3_M2_CDNS_40661956134306
* cell instance $50 r0 *1 70.29,157.86
X$50 4 286 M2_M1_CDNS_40661956134305
* cell instance $51 r0 *1 70.29,157.995
X$51 4 286 M3_M2_CDNS_40661956134306
* cell instance $52 r0 *1 72.9,159.5
X$52 4 5 M3_M2_CDNS_40661956134311
* cell instance $53 r0 *1 16.51,159.42
X$53 4 266 M2_M1_CDNS_40661956134307
* cell instance $54 r0 *1 16.51,159.42
X$54 4 266 M3_M2_CDNS_40661956134308
* cell instance $55 r0 *1 18.95,159.17
X$55 4 263 M2_M1_CDNS_40661956134307
* cell instance $56 r0 *1 18.95,159.165
X$56 4 263 M3_M2_CDNS_40661956134308
* cell instance $57 r0 *1 20.14,159.575
X$57 4 270 M2_M1_CDNS_40661956134293
* cell instance $58 r0 *1 20.14,159.77
X$58 4 270 M3_M2_CDNS_40661956134300
* cell instance $59 r0 *1 21.33,159.17
X$59 4 259 M2_M1_CDNS_40661956134307
* cell instance $60 r0 *1 21.33,159.165
X$60 4 259 M3_M2_CDNS_40661956134308
* cell instance $61 r0 *1 23.77,159.42
X$61 4 264 M2_M1_CDNS_40661956134307
* cell instance $62 r0 *1 23.77,159.42
X$62 4 264 M3_M2_CDNS_40661956134308
* cell instance $63 r0 *1 26.21,159.42
X$63 4 262 M2_M1_CDNS_40661956134307
* cell instance $64 r0 *1 26.21,159.42
X$64 4 262 M3_M2_CDNS_40661956134308
* cell instance $65 r0 *1 28.29,159.42
X$65 4 261 M2_M1_CDNS_40661956134307
* cell instance $66 r0 *1 28.29,159.42
X$66 4 261 M3_M2_CDNS_40661956134308
* cell instance $67 r0 *1 47.03,159.42
X$67 4 267 M2_M1_CDNS_40661956134307
* cell instance $68 r0 *1 47.03,159.42
X$68 4 267 M3_M2_CDNS_40661956134308
* cell instance $69 r0 *1 49.11,159.42
X$69 4 257 M2_M1_CDNS_40661956134307
* cell instance $70 r0 *1 49.11,159.42
X$70 4 257 M3_M2_CDNS_40661956134308
* cell instance $71 r0 *1 51.55,159.42
X$71 4 260 M2_M1_CDNS_40661956134307
* cell instance $72 r0 *1 51.55,159.42
X$72 4 260 M3_M2_CDNS_40661956134308
* cell instance $73 r0 *1 53.99,159.17
X$73 4 258 M2_M1_CDNS_40661956134307
* cell instance $74 r0 *1 53.99,159.165
X$74 4 258 M3_M2_CDNS_40661956134308
* cell instance $75 r0 *1 55.18,159.575
X$75 4 269 M2_M1_CDNS_40661956134293
* cell instance $76 r0 *1 55.18,159.77
X$76 4 269 M3_M2_CDNS_40661956134300
* cell instance $77 r0 *1 56.37,159.165
X$77 4 268 M3_M2_CDNS_40661956134308
* cell instance $78 r0 *1 56.37,159.17
X$78 4 268 M2_M1_CDNS_40661956134307
* cell instance $79 r0 *1 58.81,159.42
X$79 4 265 M2_M1_CDNS_40661956134307
* cell instance $80 r0 *1 58.81,159.42
X$80 4 265 M3_M2_CDNS_40661956134308
* cell instance $81 r0 *1 72.9,203.465
X$81 4 5 M3_M2_CDNS_40661956134285
* cell instance $82 r0 *1 72.9,235.465
X$82 4 5 M3_M2_CDNS_40661956134285
* cell instance $83 r0 *1 72.9,275.465
X$83 4 5 M3_M2_CDNS_40661956134285
* cell instance $84 r0 *1 51.3,283.185
X$84 4 155 M2_M1_CDNS_40661956134235
* cell instance $85 m45 *1 51.3,282.445
X$85 4 137 179 nmoscap_6p0_CDNS_4066195613423
* cell instance $86 r0 *1 56.3,283.185
X$86 4 155 M2_M1_CDNS_40661956134235
* cell instance $87 r0 *1 36.3,283.185
X$87 4 155 M2_M1_CDNS_40661956134235
* cell instance $88 m45 *1 36.3,282.445
X$88 4 137 182 nmoscap_6p0_CDNS_4066195613423
* cell instance $89 r0 *1 41.3,283.185
X$89 4 155 M2_M1_CDNS_40661956134235
* cell instance $90 r0 *1 43.8,283.185
X$90 4 155 M2_M1_CDNS_40661956134235
* cell instance $91 m45 *1 43.8,282.445
X$91 4 137 176 nmoscap_6p0_CDNS_4066195613423
* cell instance $92 r0 *1 48.8,283.185
X$92 4 155 M2_M1_CDNS_40661956134235
* cell instance $93 r0 *1 21.3,283.185
X$93 4 155 M2_M1_CDNS_40661956134235
* cell instance $94 m45 *1 21.3,282.445
X$94 4 137 178 nmoscap_6p0_CDNS_4066195613423
* cell instance $95 r0 *1 26.3,283.185
X$95 4 155 M2_M1_CDNS_40661956134235
* cell instance $96 r0 *1 28.8,283.185
X$96 4 155 M2_M1_CDNS_40661956134235
* cell instance $97 m45 *1 28.8,282.445
X$97 4 137 177 nmoscap_6p0_CDNS_4066195613423
* cell instance $98 r0 *1 33.8,283.185
X$98 4 155 M2_M1_CDNS_40661956134235
* cell instance $99 r0 *1 13.8,283.185
X$99 4 155 M2_M1_CDNS_40661956134235
* cell instance $100 m45 *1 13.8,282.445
X$100 4 137 175 nmoscap_6p0_CDNS_4066195613423
* cell instance $101 r0 *1 18.8,283.185
X$101 4 155 M2_M1_CDNS_40661956134235
* cell instance $102 r0 *1 58.8,283.185
X$102 4 155 M2_M1_CDNS_40661956134235
* cell instance $103 m45 *1 58.8,282.445
X$103 4 137 180 nmoscap_6p0_CDNS_4066195613423
* cell instance $104 r0 *1 63.8,283.185
X$104 4 155 M2_M1_CDNS_40661956134235
* cell instance $105 r0 *1 66.3,283.185
X$105 4 155 M2_M1_CDNS_40661956134235
* cell instance $106 m45 *1 66.3,282.445
X$106 4 137 181 nmoscap_6p0_CDNS_4066195613423
* cell instance $107 r0 *1 72.35,283.185
X$107 4 5 M2_M1_CDNS_40661956134235
* cell instance $108 r0 *1 7.47,152.48
X$108 6 23 M2_M1_CDNS_40661956134320
* cell instance $109 r0 *1 8.69,152.48
X$109 7 24 M2_M1_CDNS_40661956134320
* cell instance $110 r0 *1 32.81,152.48
X$110 8 39 M2_M1_CDNS_40661956134320
* cell instance $111 r0 *1 32.61,148.955
X$111 8 39 M2_M1_CDNS_40661956134237
* cell instance $112 r0 *1 7.285,148.955
X$112 8 31 M2_M1_CDNS_40661956134237
* cell instance $113 r0 *1 34.03,152.48
X$113 9 37 M2_M1_CDNS_40661956134320
* cell instance $114 r0 *1 33.83,148.055
X$114 9 37 M2_M1_CDNS_40661956134237
* cell instance $115 r0 *1 8.185,148.055
X$115 9 33 M2_M1_CDNS_40661956134237
* cell instance $116 r0 *1 17.73,152.48
X$116 10 34 M2_M1_CDNS_40661956134320
* cell instance $117 r0 *1 17.93,147.02
X$117 10 34 M2_M1_CDNS_40661956134237
* cell instance $118 r0 *1 15.29,153.38
X$118 11 25 M2_M1_CDNS_40661956134320
* cell instance $119 r0 *1 20.965,146.955
X$119 11 25 M2_M1_CDNS_40661956134270
* cell instance $120 r0 *1 24.99,152.48
X$120 12 35 M2_M1_CDNS_40661956134320
* cell instance $121 m90 *1 24.99,146.955
X$121 12 35 M2_M1_CDNS_40661956134270
* cell instance $122 r0 *1 22.55,153.38
X$122 13 26 M2_M1_CDNS_40661956134320
* cell instance $123 m90 *1 29.76,146.955
X$123 13 26 M2_M1_CDNS_40661956134270
* cell instance $124 m0 *1 22.915,247.295
X$124 124 101 118 174 117 116 101 127 216 173 118 14 110 160
+ comp018green_esd_cdm
* cell instance $125 m90 *1 52.77,153.38
X$125 15 27 M2_M1_CDNS_40661956134320
* cell instance $126 r0 *1 45.57,146.955
X$126 15 27 M2_M1_CDNS_40661956134270
* cell instance $127 m90 *1 50.33,152.48
X$127 16 42 M2_M1_CDNS_40661956134320
* cell instance $128 r0 *1 50.34,146.955
X$128 16 42 M2_M1_CDNS_40661956134270
* cell instance $129 m90 *1 60.03,153.38
X$129 17 28 M2_M1_CDNS_40661956134320
* cell instance $130 m90 *1 54.365,146.955
X$130 17 28 M2_M1_CDNS_40661956134270
* cell instance $131 m90 *1 57.59,152.48
X$131 18 38 M2_M1_CDNS_40661956134320
* cell instance $132 m90 *1 57.4,147.02
X$132 18 38 M2_M1_CDNS_40661956134237
* cell instance $133 r0 *1 42.51,152.48
X$133 19 41 M2_M1_CDNS_40661956134320
* cell instance $134 m90 *1 67.145,148.055
X$134 19 36 M2_M1_CDNS_40661956134237
* cell instance $135 r0 *1 42.71,148.055
X$135 19 41 M2_M1_CDNS_40661956134237
* cell instance $136 r0 *1 43.73,152.48
X$136 20 40 M2_M1_CDNS_40661956134320
* cell instance $137 m90 *1 68.045,148.955
X$137 20 32 M2_M1_CDNS_40661956134237
* cell instance $138 r0 *1 43.93,148.955
X$138 20 40 M2_M1_CDNS_40661956134237
* cell instance $139 m90 *1 67.85,152.48
X$139 21 29 M2_M1_CDNS_40661956134320
* cell instance $140 m90 *1 69.07,152.48
X$140 22 30 M2_M1_CDNS_40661956134320
* cell instance $141 r0 *1 17.325,190.09
X$141 44 43 M2_M1_CDNS_40661956134281
* cell instance $142 r0 *1 15.65,176.22
X$142 44 43 M2_M1_CDNS_40661956134299
* cell instance $143 r0 *1 15.65,176.22
X$143 44 43 M3_M2_CDNS_40661956134301
* cell instance $144 r0 *1 54.63,227.37
X$144 44 112 M3_M2_CDNS_40661956134433
* cell instance $145 r0 *1 55.275,227.37
X$145 44 112 M3_M2_CDNS_40661956134433
* cell instance $146 r0 *1 55.96,187.505
X$146 54 88 59 288 238 237 236 44 99 89 89 160 comp018green_sigbuf_1
* cell instance $147 m90 *1 56.41,187.505
X$147 88 55 89 238 242 241 237 240 236 78 44 95 96 95 89 160
+ comp018green_out_sigbuf_a
* cell instance $148 r0 *1 30.21,187.505
X$148 109 47 48 96 242 241 250 248 246 240 183 76 76 91 95 44 76 95 160
+ comp018green_out_sigbuf_oe
* cell instance $149 r0 *1 43.545,190.09
X$149 44 93 M2_M1_CDNS_40661956134281
* cell instance $150 m90 *1 30.66,187.505
X$150 105 64 66 96 253 252 250 248 246 251 108 107 76 91 87 44 76 87 160
+ comp018green_out_sigbuf_oe
* cell instance $151 r0 *1 3.99,187.505
X$151 106 50 56 96 253 252 249 247 245 251 74 73 82 84 87 44 82 87 160
+ comp018green_out_sigbuf_oe
* cell instance $152 r0 *1 2.62,175.18
X$152 44 271 M2_M1_CDNS_40661956134293
* cell instance $153 r0 *1 2.62,175.18
X$153 44 271 M3_M2_CDNS_40661956134300
* cell instance $154 r0 *1 20.14,173.1
X$154 44 278 M2_M1_CDNS_40661956134302
* cell instance $155 r0 *1 20.14,174.255
X$155 44 278 M3_M2_CDNS_40661956134303
* cell instance $156 r0 *1 55.18,173.1
X$156 44 277 M2_M1_CDNS_40661956134302
* cell instance $157 r0 *1 55.18,174.255
X$157 44 277 M3_M2_CDNS_40661956134303
* cell instance $158 r0 *1 3.81,176.22
X$158 44 255 M2_M1_CDNS_40661956134299
* cell instance $159 r0 *1 3.81,176.22
X$159 44 255 M3_M2_CDNS_40661956134301
* cell instance $160 r0 *1 24.63,176.22
X$160 44 254 M2_M1_CDNS_40661956134299
* cell instance $161 r0 *1 24.63,176.22
X$161 44 254 M3_M2_CDNS_40661956134301
* cell instance $162 r0 *1 43.285,179.6
X$162 44 93 M2_M1_CDNS_40661956134237
* cell instance $163 r0 *1 43.545,176.22
X$163 44 93 M3_M2_CDNS_40661956134301
* cell instance $164 r0 *1 50.69,176.22
X$164 44 256 M2_M1_CDNS_40661956134299
* cell instance $165 r0 *1 50.69,176.22
X$165 44 256 M3_M2_CDNS_40661956134301
* cell instance $166 r0 *1 59.67,176.22
X$166 44 45 M2_M1_CDNS_40661956134299
* cell instance $167 r0 *1 59.67,176.22
X$167 44 45 M3_M2_CDNS_40661956134301
* cell instance $168 r0 *1 52.57,240.04
X$168 44 112 M3_M2_CDNS_40661956134417
* cell instance $169 r0 *1 58.96,204.285
X$169 44 45 M2_M1_CDNS_40661956134237
* cell instance $170 r0 *1 55.275,204.47
X$170 44 112 M2_M1_CDNS_40661956134270
* cell instance $171 r0 *1 65.76,184.36
X$171 47 46 M2_M1_CDNS_40661956134237
* cell instance $172 m90 *1 66.02,171.785
X$172 47 46 M2_M1_CDNS_40661956134270
* cell instance $173 r90 *1 42.385,184.62
X$173 47 94 M2_M1_CDNS_40661956134237
* cell instance $174 m90 *1 42.385,189.305
X$174 47 94 M2_M1_CDNS_40661956134270
* cell instance $175 r0 *1 41.915,183.68
X$175 48 92 M2_M1_CDNS_40661956134237
* cell instance $176 r0 *1 65.06,183.68
X$176 48 49 M2_M1_CDNS_40661956134237
* cell instance $177 m90 *1 64.8,171.785
X$177 48 49 M2_M1_CDNS_40661956134270
* cell instance $178 m90 *1 41.655,193.05
X$178 48 92 M2_M1_CDNS_40661956134270
* cell instance $179 r0 *1 9.56,182.32
X$179 50 53 M2_M1_CDNS_40661956134237
* cell instance $180 r0 *1 15.905,182.32
X$180 50 86 M2_M1_CDNS_40661956134237
* cell instance $181 r0 *1 9.3,171.785
X$181 50 53 M2_M1_CDNS_40661956134270
* cell instance $182 r0 *1 16.165,189.305
X$182 50 86 M2_M1_CDNS_40661956134270
* cell instance $183 m90 *1 62.98,181.64
X$183 55 51 M2_M1_CDNS_40661956134237
* cell instance $184 m90 *1 62.72,171.785
X$184 55 51 M2_M1_CDNS_40661956134270
* cell instance $185 r0 *1 7,180.96
X$185 54 52 M2_M1_CDNS_40661956134237
* cell instance $186 m90 *1 68.32,180.96
X$186 54 79 M2_M1_CDNS_40661956134237
* cell instance $187 m90 *1 33.28,180.96
X$187 54 72 M2_M1_CDNS_40661956134237
* cell instance $188 r0 *1 42.04,180.96
X$188 54 70 M2_M1_CDNS_40661956134237
* cell instance $189 r0 *1 66.705,192.985
X$189 54 79 M2_M1_CDNS_40661956134270
* cell instance $190 m90 *1 27.42,181.64
X$190 55 68 M2_M1_CDNS_40661956134237
* cell instance $191 r0 *1 12.86,181.64
X$191 55 58 M2_M1_CDNS_40661956134237
* cell instance $192 r0 *1 47.9,181.64
X$192 55 77 M2_M1_CDNS_40661956134237
* cell instance $193 m90 *1 27.68,171.785
X$193 55 68 M2_M1_CDNS_40661956134270
* cell instance $194 r0 *1 47.64,171.785
X$194 55 77 M2_M1_CDNS_40661956134270
* cell instance $195 r0 *1 44.665,189.305
X$195 55 77 M2_M1_CDNS_40661956134270
* cell instance $196 r0 *1 12.6,171.785
X$196 55 58 M2_M1_CDNS_40661956134270
* cell instance $197 r0 *1 11.35,183
X$197 56 57 M2_M1_CDNS_40661956134286
* cell instance $198 r0 *1 10.52,171.785
X$198 56 57 M2_M1_CDNS_40661956134270
* cell instance $199 r0 *1 13.725,189.305
X$199 56 57 M2_M1_CDNS_40661956134270
* cell instance $200 m90 *1 57.94,180.28
X$200 59 61 M2_M1_CDNS_40661956134237
* cell instance $201 m90 *1 22.9,180.28
X$201 59 69 M2_M1_CDNS_40661956134237
* cell instance $202 r0 *1 17.38,180.28
X$202 59 62 M2_M1_CDNS_40661956134237
* cell instance $203 r0 *1 52.42,180.28
X$203 59 60 M2_M1_CDNS_40661956134237
* cell instance $204 r0 *1 67.125,180.28
X$204 59 83 M2_M1_CDNS_40661956134237
* cell instance $205 r0 *1 67.385,189.725
X$205 59 83 M2_M1_CDNS_40661956134270
* cell instance $206 r0 *1 44.6,182.32
X$206 64 63 M2_M1_CDNS_40661956134237
* cell instance $207 m90 *1 44.34,171.785
X$207 64 63 M2_M1_CDNS_40661956134270
* cell instance $208 m90 *1 18.745,182.32
X$208 64 85 M2_M1_CDNS_40661956134237
* cell instance $209 m90 *1 30.72,182.32
X$209 64 65 M2_M1_CDNS_40661956134237
* cell instance $210 m90 *1 18.485,189.305
X$210 64 85 M2_M1_CDNS_40661956134270
* cell instance $211 r0 *1 30.98,171.785
X$211 64 65 M2_M1_CDNS_40661956134270
* cell instance $212 m90 *1 22.755,183
X$212 66 75 M2_M1_CDNS_40661956134237
* cell instance $213 m90 *1 29.5,183
X$213 66 67 M2_M1_CDNS_40661956134237
* cell instance $214 m90 *1 45.3,183
X$214 66 71 M2_M1_CDNS_40661956134237
* cell instance $215 m90 *1 20.925,189.305
X$215 66 75 M2_M1_CDNS_40661956134270
* cell instance $216 r0 *1 29.76,171.785
X$216 66 67 M2_M1_CDNS_40661956134270
* cell instance $217 r0 *1 45.56,171.785
X$217 66 71 M2_M1_CDNS_40661956134270
* cell instance $218 r0 *1 30.435,196.32
X$218 76 231 M2_M1_CDNS_40661956134281
* cell instance $219 r0 *1 30.435,196.145
X$219 76 231 M3_M2_CDNS_40661956134290
* cell instance $220 r0 *1 25.605,197.36
X$220 76 229 M2_M1_CDNS_40661956134279
* cell instance $221 r0 *1 25.605,197.24
X$221 76 229 M3_M2_CDNS_40661956134294
* cell instance $222 r0 *1 35.265,197.36
X$222 76 223 M2_M1_CDNS_40661956134279
* cell instance $223 r0 *1 35.265,197.24
X$223 76 223 M3_M2_CDNS_40661956134294
* cell instance $224 r0 *1 57.29,205.815
X$224 215 78 89 214 89 pn_6p0_CDNS_4066195613428
* cell instance $225 r0 *1 58.045,206.315
X$225 78 100 M2_M1_CDNS_40661956134270
* cell instance $226 r0 *1 53.67,202.18
X$226 78 90 M2_M1_CDNS_40661956134237
* cell instance $227 r0 *1 60.37,202.18
X$227 78 100 M2_M1_CDNS_40661956134237
* cell instance $228 r0 *1 69.49,202.18
X$228 78 158 M2_M1_CDNS_40661956134237
* cell instance $229 r0 *1 53.41,194.84
X$229 78 90 M2_M1_CDNS_40661956134270
* cell instance $230 r0 *1 1.92,274.725
X$230 82 142 M2_M1_CDNS_40661956134283
* cell instance $231 r0 *1 1.92,270.18
X$231 82 142 M2_M1_CDNS_40661956134283
* cell instance $232 r0 *1 66.56,276.435
X$232 82 140 M2_M1_CDNS_40661956134277
* cell instance $233 m0 *1 4.24,279.26
X$233 121 138 144 82 156 82 153 82 139 151 128 129 84 84 132 84 213 116 117 147
+ 161 141 132 124 162 122 160 115 126 124 235 115 116 113 152 152 152 152 219
+ 216 124 159 comp018green_inpath_cms_smt
* cell instance $234 r0 *1 17.54,276.675
X$234 82 140 M2_M1_CDNS_40661956134281
* cell instance $235 r0 *1 18.655,276.675
X$235 82 140 M2_M1_CDNS_40661956134281
* cell instance $236 r0 *1 21,276.675
X$236 82 140 M2_M1_CDNS_40661956134281
* cell instance $237 r0 *1 9.045,197.51
X$237 82 230 M2_M1_CDNS_40661956134279
* cell instance $238 r0 *1 9.045,197.24
X$238 82 230 M3_M2_CDNS_40661956134294
* cell instance $239 r0 *1 40.34,276.675
X$239 82 140 M2_M1_CDNS_40661956134281
* cell instance $240 r0 *1 42.685,276.675
X$240 82 140 M2_M1_CDNS_40661956134281
* cell instance $241 r0 *1 43.76,276.675
X$241 82 140 M2_M1_CDNS_40661956134281
* cell instance $242 r0 *1 44.875,276.675
X$242 82 140 M2_M1_CDNS_40661956134281
* cell instance $243 r0 *1 47.22,276.675
X$243 82 140 M2_M1_CDNS_40661956134281
* cell instance $244 r0 *1 1.92,201.4
X$244 82 142 M2_M1_CDNS_40661956134286
* cell instance $245 r0 *1 1.92,195.465
X$245 82 142 M3_M2_CDNS_40661956134285
* cell instance $246 r0 *1 1.92,251.465
X$246 82 142 M3_M2_CDNS_40661956134285
* cell instance $247 r0 *1 66.56,268.865
X$247 84 130 M2_M1_CDNS_40661956134275
* cell instance $248 r0 *1 40.34,268.865
X$248 84 130 M2_M1_CDNS_40661956134275
* cell instance $249 r0 *1 43.78,269.385
X$249 84 130 M2_M1_CDNS_40661956134281
* cell instance $250 r0 *1 4.215,190.09
X$250 84 131 M2_M1_CDNS_40661956134281
* cell instance $251 r0 *1 4.52,187.465
X$251 84 131 M3_M2_CDNS_40661956134285
* cell instance $252 r0 *1 17.54,269.385
X$252 84 136 M2_M1_CDNS_40661956134281
* cell instance $253 r0 *1 21,268.865
X$253 84 130 M2_M1_CDNS_40661956134275
* cell instance $254 r0 *1 4.52,264.905
X$254 84 131 M2_M1_CDNS_40661956134286
* cell instance $255 r0 *1 4.52,259.465
X$255 84 131 M3_M2_CDNS_40661956134285
* cell instance $256 r0 *1 18.865,264.905
X$256 84 130 M2_M1_CDNS_40661956134237
* cell instance $257 r0 *1 17.28,264.905
X$257 84 136 M2_M1_CDNS_40661956134237
* cell instance $258 r0 *1 17.295,201.44
X$258 87 220 M2_M1_CDNS_40661956134318
* cell instance $259 r0 *1 17.3,201.44
X$259 87 220 M3_M2_CDNS_40661956134435
* cell instance $260 r0 *1 54.705,187.71
X$260 88 239 M2_M1_CDNS_40661956134234
* cell instance $261 r0 *1 54.8,187.71
X$261 88 239 M3_M2_CDNS_40661956134298
* cell instance $262 r0 *1 51.825,196.47
X$262 89 233 M2_M1_CDNS_40661956134281
* cell instance $263 r0 *1 51.825,196.175
X$263 89 233 M3_M2_CDNS_40661956134290
* cell instance $264 r0 *1 56.19,196.47
X$264 89 97 M2_M1_CDNS_40661956134281
* cell instance $265 r0 *1 56.19,196.175
X$265 89 97 M3_M2_CDNS_40661956134290
* cell instance $266 r0 *1 57.29,208.135
X$266 215 99 89 214 89 pn_6p0_CDNS_4066195613428
* cell instance $267 r0 *1 56.62,205.425
X$267 89 97 M2_M1_CDNS_40661956134270
* cell instance $268 r0 *1 30.435,190.09
X$268 91 243 M2_M1_CDNS_40661956134281
* cell instance $269 r0 *1 30.435,187.465
X$269 91 243 M3_M2_CDNS_40661956134284
* cell instance $270 r0 *1 44.05,201.44
X$270 95 218 M2_M1_CDNS_40661956134291
* cell instance $271 r0 *1 44.385,201.44
X$271 95 218 M3_M2_CDNS_40661956134297
* cell instance $272 m90 *1 24.635,203.54
X$272 96 105 M2_M1_CDNS_40661956134237
* cell instance $273 m90 *1 35.715,203.54
X$273 96 109 M2_M1_CDNS_40661956134237
* cell instance $274 r90 *1 70.48,203.8
X$274 96 157 M2_M1_CDNS_40661956134237
* cell instance $275 r0 *1 10.015,203.54
X$275 96 106 M2_M1_CDNS_40661956134237
* cell instance $276 r0 *1 54.89,203.54
X$276 96 111 M2_M1_CDNS_40661956134237
* cell instance $277 r0 *1 54.63,194.84
X$277 96 111 M2_M1_CDNS_40661956134270
* cell instance $278 r90 *1 57.79,193.035
X$278 99 98 M2_M1_CDNS_40661956134237
* cell instance $279 r0 *1 57.53,202.86
X$279 99 98 M2_M1_CDNS_40661956134237
* cell instance $280 r0 *1 58.045,208.685
X$280 99 98 M2_M1_CDNS_40661956134270
* cell instance $281 r0 *1 68.76,202.86
X$281 99 154 M2_M1_CDNS_40661956134237
* cell instance $282 r0 *1 66.665,217.77
X$282 101 104 M1_PACTIVE_CDNS_40661956134272
* cell instance $283 r0 *1 66.665,205.55
X$283 101 104 M1_PACTIVE_CDNS_40661956134272
* cell instance $284 r0 *1 56.5,215.745
X$284 101 M1_PSUB_CDNS_40661956134319
* cell instance $285 r0 *1 73.075,211.66
X$285 101 104 M1_PACTIVE_CDNS_40661956134271
* cell instance $286 m45 *1 62.41,207.74
X$286 103 101 nmoscap_6p0_CDNS_4066195613422
* cell instance $287 r0 *1 60.49,211.66
X$287 101 104 M1_PACTIVE_CDNS_40661956134271
* cell instance $288 m45 *1 62.41,212.58
X$288 103 101 nmoscap_6p0_CDNS_4066195613422
* cell instance $289 m45 *1 68.11,207.74
X$289 103 101 nmoscap_6p0_CDNS_4066195613422
* cell instance $290 m45 *1 68.11,212.58
X$290 103 101 nmoscap_6p0_CDNS_4066195613422
* cell instance $291 r0 *1 46.745,267.465
X$291 101 118 M3_M2_CDNS_40661956134285
* cell instance $292 r0 *1 66.655,211.9
X$292 103 102 M3_M2_CDNS_40661956134317
* cell instance $293 r0 *1 65.67,213.95
X$293 103 102 M2_M1_CDNS_40661956134270
* cell instance $294 r0 *1 67.85,213.95
X$294 103 102 M2_M1_CDNS_40661956134270
* cell instance $295 r0 *1 67.85,209.315
X$295 103 102 M2_M1_CDNS_40661956134270
* cell instance $296 r0 *1 65.67,209.315
X$296 103 102 M2_M1_CDNS_40661956134270
* cell instance $297 r0 *1 28.28,202.71
X$297 107 108 M2_M1_CDNS_40661956134237
* cell instance $298 r0 *1 8.43,202.71
X$298 107 150 M2_M1_CDNS_40661956134237
* cell instance $299 r0 *1 62.575,187.465
X$299 113 114 M3_M2_CDNS_40661956134313
* cell instance $300 r0 *1 62.56,220.135
X$300 113 114 M2_M1_CDNS_40661956134237
* cell instance $301 r0 *1 58.34,248.81
X$301 115 123 M3_M2_CDNS_40661956134280
* cell instance $302 r0 *1 62.3,234.7
X$302 115 M2_M1_CDNS_40661956134434
* cell instance $303 r0 *1 58.28,239.32
X$303 115 123 M2_M1_CDNS_40661956134270
* cell instance $304 r0 *1 16.375,231.35
X$304 116 117 M2_M1_CDNS_40661956134269
* cell instance $305 r0 *1 71.21,229.575
X$305 121 122 M2_M1_CDNS_40661956134270
* cell instance $306 r0 *1 21.67,251.215
X$306 124 127 M2_M1_CDNS_40661956134432
* cell instance $307 r0 *1 39.57,251.215
X$307 124 126 M2_M1_CDNS_40661956134286
* cell instance $308 r0 *1 43.08,251.215
X$308 124 125 M2_M1_CDNS_40661956134286
* cell instance $309 r0 *1 23.97,243.27
X$309 124 127 M2_M1_CDNS_40661956134282
* cell instance $310 r0 *1 55.195,237.16
X$310 124 226 M2_M1_CDNS_40661956134279
* cell instance $311 r0 *1 55.195,237.16
X$311 124 226 M3_M2_CDNS_40661956134294
* cell instance $312 r0 *1 28.565,246.34
X$312 124 127 M2_M1_CDNS_40661956134287
* cell instance $313 r0 *1 33.08,246.34
X$313 124 127 M2_M1_CDNS_40661956134287
* cell instance $314 r0 *1 39.57,246.34
X$314 124 126 M2_M1_CDNS_40661956134287
* cell instance $315 r0 *1 43.08,246.34
X$315 124 125 M2_M1_CDNS_40661956134287
* cell instance $316 r0 *1 23.94,268.865
X$316 132 198 M2_M1_CDNS_40661956134275
* cell instance $317 r0 *1 23.94,268.53
X$317 132 198 M3_M2_CDNS_40661956134278
* cell instance $318 r0 *1 24.88,268.58
X$318 132 134 M2_M1_CDNS_40661956134279
* cell instance $319 r0 *1 24.88,268.58
X$319 132 134 M3_M2_CDNS_40661956134276
* cell instance $320 r0 *1 27.32,268.58
X$320 132 193 M2_M1_CDNS_40661956134279
* cell instance $321 r0 *1 27.32,268.58
X$321 132 193 M3_M2_CDNS_40661956134276
* cell instance $322 r0 *1 29.76,268.58
X$322 132 221 M2_M1_CDNS_40661956134279
* cell instance $323 r0 *1 29.76,268.58
X$323 132 221 M3_M2_CDNS_40661956134276
* cell instance $324 r0 *1 30.67,269.125
X$324 132 187 M2_M1_CDNS_40661956134277
* cell instance $325 r0 *1 30.67,268.53
X$325 132 187 M3_M2_CDNS_40661956134278
* cell instance $326 r0 *1 31.58,268.58
X$326 132 188 M2_M1_CDNS_40661956134279
* cell instance $327 r0 *1 31.58,268.58
X$327 132 188 M3_M2_CDNS_40661956134276
* cell instance $328 r0 *1 34.02,268.58
X$328 132 135 M2_M1_CDNS_40661956134279
* cell instance $329 r0 *1 34.02,268.58
X$329 132 135 M3_M2_CDNS_40661956134276
* cell instance $330 r0 *1 36.46,268.58
X$330 132 133 M2_M1_CDNS_40661956134279
* cell instance $331 r0 *1 36.46,268.58
X$331 132 133 M3_M2_CDNS_40661956134276
* cell instance $332 r0 *1 37.4,268.865
X$332 132 200 M2_M1_CDNS_40661956134275
* cell instance $333 r0 *1 37.4,268.53
X$333 132 200 M3_M2_CDNS_40661956134278
* cell instance $334 r0 *1 24.9,263.265
X$334 132 134 M2_M1_CDNS_40661956134232
* cell instance $335 r0 *1 33.42,263.265
X$335 132 135 M2_M1_CDNS_40661956134232
* cell instance $336 r0 *1 36.72,263.265
X$336 132 133 M2_M1_CDNS_40661956134237
* cell instance $337 r0 *1 7.245,277.605
X$337 137 143 M1_PACTIVE_CDNS_40661956134440
* cell instance $338 r0 *1 73.45,283.195
X$338 137 143 M1_PACTIVE_CDNS_40661956134273
* cell instance $339 r0 *1 11.88,283.195
X$339 137 143 M1_PACTIVE_CDNS_40661956134273
* cell instance $340 r0 *1 40.33,285.05
X$340 137 185 M2_M1_CDNS_40661956134315
* cell instance $341 r0 *1 40.33,285.05
X$341 137 185 M3_M2_CDNS_40661956134316
* cell instance $342 r0 *1 40.33,281.34
X$342 137 184 M2_M1_CDNS_40661956134315
* cell instance $343 r90 *1 42.665,280.495
X$343 137 143 M1_PACTIVE_CDNS_40661956134274
* cell instance $344 r0 *1 40.33,281.34
X$344 137 184 M3_M2_CDNS_40661956134316
* cell instance $345 m45 *1 4.87,282.445
X$345 146 137 148 nmoscap_6p0_CDNS_4066195613423
* cell instance $346 r0 *1 2.95,281.365
X$346 137 143 M1_PACTIVE_CDNS_40661956134353
* cell instance $347 m45 *1 4.87,279.665
X$347 146 137 148 nmoscap_6p0_CDNS_4066195613423
* cell instance $348 r0 *1 9.62,278.785
X$348 137 149 M2_M1_CDNS_40661956134437
* cell instance $349 r0 *1 9.62,285.08
X$349 137 149 M2_M1_CDNS_40661956134437
* cell instance $350 r90 *1 38.2,285.895
X$350 137 143 M1_PACTIVE_CDNS_40661956134439
* cell instance $351 r0 *1 9.62,283.195
X$351 137 149 M3_M2_CDNS_40661956134314
* cell instance $352 r0 *1 9.62,267.465
X$352 137 149 M3_M2_CDNS_40661956134284
* cell instance $353 r0 *1 5.135,276.32
X$353 146 145 M3_M2_CDNS_40661956134438
* cell instance $354 r0 *1 5.135,280.51
X$354 146 145 M2_M1_CDNS_40661956134235
* cell instance $355 r0 *1 5.135,283.195
X$355 146 145 M2_M1_CDNS_40661956134235
* cell instance $356 r0 *1 23.94,276.435
X$356 153 199 M2_M1_CDNS_40661956134277
* cell instance $357 r0 *1 23.94,276.435
X$357 153 199 M3_M2_CDNS_40661956134278
* cell instance $358 r0 *1 24.88,276.84
X$358 153 209 M2_M1_CDNS_40661956134275
* cell instance $359 r0 *1 24.88,276.84
X$359 153 209 M3_M2_CDNS_40661956134276
* cell instance $360 r0 *1 27.32,276.885
X$360 153 192 M2_M1_CDNS_40661956134275
* cell instance $361 r0 *1 27.32,276.885
X$361 153 192 M3_M2_CDNS_40661956134276
* cell instance $362 r0 *1 29.76,276.885
X$362 153 191 M2_M1_CDNS_40661956134275
* cell instance $363 r0 *1 29.76,276.885
X$363 153 191 M3_M2_CDNS_40661956134276
* cell instance $364 r0 *1 30.67,276.435
X$364 153 203 M2_M1_CDNS_40661956134277
* cell instance $365 r0 *1 30.67,276.435
X$365 153 203 M3_M2_CDNS_40661956134278
* cell instance $366 r0 *1 31.58,276.885
X$366 153 210 M2_M1_CDNS_40661956134275
* cell instance $367 r0 *1 31.58,276.885
X$367 153 210 M3_M2_CDNS_40661956134276
* cell instance $368 r0 *1 34.02,276.885
X$368 153 212 M2_M1_CDNS_40661956134275
* cell instance $369 r0 *1 34.02,276.885
X$369 153 212 M3_M2_CDNS_40661956134276
* cell instance $370 r0 *1 36.46,276.885
X$370 153 189 M2_M1_CDNS_40661956134275
* cell instance $371 r0 *1 36.46,276.885
X$371 153 189 M3_M2_CDNS_40661956134276
* cell instance $372 r0 *1 37.4,276.435
X$372 153 206 M2_M1_CDNS_40661956134277
* cell instance $373 r0 *1 37.4,276.435
X$373 153 206 M3_M2_CDNS_40661956134278
* cell instance $374 r0 *1 50.16,276.435
X$374 156 201 M2_M1_CDNS_40661956134277
* cell instance $375 r0 *1 50.16,276.435
X$375 156 201 M3_M2_CDNS_40661956134278
* cell instance $376 r0 *1 51.1,276.885
X$376 156 196 M2_M1_CDNS_40661956134275
* cell instance $377 r0 *1 51.1,276.885
X$377 156 196 M3_M2_CDNS_40661956134276
* cell instance $378 r0 *1 53.54,276.885
X$378 156 195 M2_M1_CDNS_40661956134275
* cell instance $379 r0 *1 53.54,276.885
X$379 156 195 M3_M2_CDNS_40661956134276
* cell instance $380 r0 *1 55.98,276.885
X$380 156 197 M2_M1_CDNS_40661956134275
* cell instance $381 r0 *1 55.98,276.885
X$381 156 197 M3_M2_CDNS_40661956134276
* cell instance $382 r0 *1 56.89,276.435
X$382 156 186 M2_M1_CDNS_40661956134277
* cell instance $383 r0 *1 56.89,276.435
X$383 156 186 M3_M2_CDNS_40661956134278
* cell instance $384 r0 *1 57.8,276.885
X$384 156 211 M2_M1_CDNS_40661956134275
* cell instance $385 r0 *1 57.8,276.885
X$385 156 211 M3_M2_CDNS_40661956134276
* cell instance $386 r0 *1 60.24,276.885
X$386 156 194 M2_M1_CDNS_40661956134275
* cell instance $387 r0 *1 60.24,276.885
X$387 156 194 M3_M2_CDNS_40661956134276
* cell instance $388 r0 *1 62.68,276.885
X$388 156 208 M2_M1_CDNS_40661956134275
* cell instance $389 r0 *1 62.68,276.885
X$389 156 208 M3_M2_CDNS_40661956134276
* cell instance $390 r0 *1 63.62,276.435
X$390 156 205 M2_M1_CDNS_40661956134277
* cell instance $391 r0 *1 63.62,276.435
X$391 156 205 M3_M2_CDNS_40661956134278
* cell instance $392 r0 *1 51.1,268.58
X$392 213 190 M3_M2_CDNS_40661956134276
* cell instance $393 r0 *1 51.1,268.58
X$393 213 190 M2_M1_CDNS_40661956134279
* cell instance $394 r0 *1 50.16,268.53
X$394 213 202 M3_M2_CDNS_40661956134278
* cell instance $395 r0 *1 50.16,268.865
X$395 213 202 M2_M1_CDNS_40661956134275
* cell instance $396 r0 *1 63.62,268.53
X$396 213 204 M3_M2_CDNS_40661956134278
* cell instance $397 r0 *1 63.62,268.865
X$397 213 204 M2_M1_CDNS_40661956134275
* cell instance $398 r0 *1 56.89,268.53
X$398 213 207 M3_M2_CDNS_40661956134278
* cell instance $399 r0 *1 56.89,269.125
X$399 213 207 M2_M1_CDNS_40661956134277
* cell instance $400 r0 *1 53.54,268.58
X$400 213 224 M2_M1_CDNS_40661956134279
* cell instance $401 r0 *1 53.54,268.58
X$401 213 224 M3_M2_CDNS_40661956134276
* cell instance $402 r0 *1 55.98,268.58
X$402 213 225 M2_M1_CDNS_40661956134279
* cell instance $403 r0 *1 55.98,268.58
X$403 213 225 M3_M2_CDNS_40661956134276
* cell instance $404 r0 *1 57.8,268.58
X$404 213 222 M2_M1_CDNS_40661956134279
* cell instance $405 r0 *1 57.8,268.58
X$405 213 222 M3_M2_CDNS_40661956134276
* cell instance $406 r0 *1 60.24,268.58
X$406 213 227 M2_M1_CDNS_40661956134279
* cell instance $407 r0 *1 60.24,268.58
X$407 213 227 M3_M2_CDNS_40661956134276
* cell instance $408 r0 *1 62.68,268.58
X$408 213 228 M2_M1_CDNS_40661956134279
* cell instance $409 r0 *1 62.68,268.58
X$409 213 228 M3_M2_CDNS_40661956134276
* cell instance $410 r0 *1 13.79,205.22
X$410 219 217 M2_M1_CDNS_40661956134291
* cell instance $411 r0 *1 13.985,205.22
X$411 219 217 M3_M2_CDNS_40661956134292
* cell instance $412 r0 *1 18.23,211.465
X$412 219 244 M2_M1_CDNS_40661956134240
* cell instance $413 r0 *1 18.23,211.465
X$413 219 244 M3_M2_CDNS_40661956134284
* cell instance $414 r0 *1 18.23,219.465
X$414 219 290 M2_M1_CDNS_40661956134240
* cell instance $415 r0 *1 18.23,219.465
X$415 219 290 M3_M2_CDNS_40661956134284
* cell instance $416 r0 *1 18.23,236.21
X$416 219 232 M2_M1_CDNS_40661956134289
* cell instance $417 r0 *1 18.23,236.175
X$417 219 232 M3_M2_CDNS_40661956134290
* cell instance $418 r0 *1 54.1,244.33
X$418 235 234 M2_M1_CDNS_40661956134281
* cell instance $419 r0 *1 54.1,244.175
X$419 235 234 M3_M2_CDNS_40661956134290
* cell instance $420 r0 *1 66.39,201.44
X$420 288 287 M2_M1_CDNS_40661956134267
* cell instance $421 r0 *1 66.415,201.44
X$421 288 287 M3_M2_CDNS_40661956134298
* device instance $1 r0 *1 5.945,268.14 pn_6p0
D$1 121 82 pn_6p0 A=1P P=4U
* device instance $2 r0 *1 12.19,268.14 pn_6p0
D$2 129 82 pn_6p0 A=1P P=4U
* device instance $3 r0 *1 5.945,272.64 pn_6p0
D$3 138 82 pn_6p0 A=1P P=4U
* device instance $4 r0 *1 12.19,272.64 pn_6p0
D$4 139 82 pn_6p0 A=1P P=4U
* device instance $5 r0 *1 57.79,206.315 pn_6p0
D$5 78 89 pn_6p0 A=1P P=4U
* device instance $6 r0 *1 57.79,208.635 pn_6p0
D$6 99 89 pn_6p0 A=1P P=4U
* device instance $7 r0 *1 7.37,280.415 nmoscap_6p0
C$7 146 137 1.725e-14 nmoscap_6p0 A=7.5P P=13U
* device instance $8 r0 *1 7.37,283.195 nmoscap_6p0
C$8 146 137 1.725e-14 nmoscap_6p0 A=7.5P P=13U
* device instance $9 r0 *1 38.8,283.195 nmoscap_6p0
C$9 4 137 1.725e-14 nmoscap_6p0 A=7.5P P=13U
* device instance $10 r0 *1 23.8,283.195 nmoscap_6p0
C$10 4 137 1.725e-14 nmoscap_6p0 A=7.5P P=13U
* device instance $11 r0 *1 31.3,283.195 nmoscap_6p0
C$11 4 137 1.725e-14 nmoscap_6p0 A=7.5P P=13U
* device instance $12 r0 *1 16.3,283.195 nmoscap_6p0
C$12 4 137 1.725e-14 nmoscap_6p0 A=7.5P P=13U
* device instance $13 r0 *1 53.8,283.195 nmoscap_6p0
C$13 4 137 1.725e-14 nmoscap_6p0 A=7.5P P=13U
* device instance $14 r0 *1 61.3,283.195 nmoscap_6p0
C$14 4 137 1.725e-14 nmoscap_6p0 A=7.5P P=13U
* device instance $15 r0 *1 68.8,283.195 nmoscap_6p0
C$15 4 137 1.725e-14 nmoscap_6p0 A=7.5P P=13U
* device instance $16 r0 *1 46.3,283.195 nmoscap_6p0
C$16 4 137 1.725e-14 nmoscap_6p0 A=7.5P P=13U
.ENDS GF_NI_BI_T_BASE

* cell M3_M2_CDNS_40661956134181
* pin
* pin
.SUBCKT M3_M2_CDNS_40661956134181 1 2
.ENDS M3_M2_CDNS_40661956134181

* cell M2_M1_CDNS_40661956134179
* pin
* pin
.SUBCKT M2_M1_CDNS_40661956134179 1 2
.ENDS M2_M1_CDNS_40661956134179

* cell POLY_SUB_FILL_1
* pin
* pin
* pin
.SUBCKT POLY_SUB_FILL_1 1 2 3
* device instance $1 r0 *1 6.425,4.615 nmoscap_6p0
C$1 2 1 9.66e-14 nmoscap_6p0 A=42P P=26U
* device instance $2 r0 *1 6.425,12.175 nmoscap_6p0
C$2 2 1 9.66e-14 nmoscap_6p0 A=42P P=26U
.ENDS POLY_SUB_FILL_1

* cell M3_M2_CDNS_40661956134172
* pin
* pin
.SUBCKT M3_M2_CDNS_40661956134172 1 2
.ENDS M3_M2_CDNS_40661956134172

* cell M3_M2_CDNS_40661956134175
* pin
* pin
.SUBCKT M3_M2_CDNS_40661956134175 1 2
.ENDS M3_M2_CDNS_40661956134175

* cell M1_PSUB_CDNS_40661956134182
* pin
* pin
.SUBCKT M1_PSUB_CDNS_40661956134182 1 2
.ENDS M1_PSUB_CDNS_40661956134182

* cell GF_NI_IN_S_BASE
* pin
* pin
* pin
* pin PAD
* pin
* pin
* pin
* pin
* pin
* pin
* pin
* pin
* pin
* pin
* pin
* pin
* pin
* pin
* pin
* pin
* pin
* pin
* pin PU
* pin
* pin PD
* pin
* pin
* pin
* pin
* pin Y
* pin
* pin gf180mcu_gnd
* pin
* pin
* pin
* pin
* pin
* pin
* pin
* pin
* pin
* pin
* pin
* pin
* pin
* pin
* pin
* pin
* pin
* pin
.SUBCKT GF_NI_IN_S_BASE 1 2 4 14 44 76 79 80 81 83 86 87 88 89 94 98 99 106 110
+ 111 115 116 118 121 125 130 136 139 141 142 145 151 152 153 154 155 156 157
+ 158 159 160 161 162 163 164 165 207 213 227 279
* net 6 ndrive_x_<0>
* net 7 ndrive_y_<0>
* net 8 ndrive_x_<1>
* net 9 ndrive_Y_<1>
* net 10 pdrive_x_<0>
* net 11 pdrive_y_<0>
* net 12 pdrive_y_<1>
* net 13 pdrive_x_<1>
* net 14 PAD
* net 15 pdrive_x_<2>
* net 16 pdrive_y_<2>
* net 17 pdrive_y_<3>
* net 18 pdrive_x_<3>
* net 19 ndrive_x_<2>
* net 20 ndrive_y_<2>
* net 21 ndrive_x_<3>
* net 22 ndrive_Y_<3>
* net 118 PU
* net 125 PD
* net 142 Y
* net 151 gf180mcu_gnd
* cell instance $1 r0 *1 37.51,5.605
X$1 1 M1_PSUB_CDNS_40661956134441
* cell instance $2 m90 *1 1.17,30.87
X$2 1 M1_PSUB_CDNS_40661956134442
* cell instance $3 r0 *1 73.84,30.87
X$3 1 M1_PSUB_CDNS_40661956134442
* cell instance $4 r0 *1 0.42,259.465
X$4 1 115 M2_M1_CDNS_40661956134240
* cell instance $5 r0 *1 0.42,259.465
X$5 1 115 M3_M2_CDNS_40661956134284
* cell instance $6 r0 *1 74.9,187.465
X$6 1 80 M2_M1_CDNS_40661956134240
* cell instance $7 r0 *1 74.9,187.465
X$7 1 80 M3_M2_CDNS_40661956134284
* cell instance $8 r0 *1 74.9,259.465
X$8 1 116 M2_M1_CDNS_40661956134240
* cell instance $9 r0 *1 74.9,259.465
X$9 1 116 M3_M2_CDNS_40661956134284
* cell instance $10 r0 *1 0.42,187.465
X$10 1 79 M2_M1_CDNS_40661956134240
* cell instance $11 r0 *1 0.42,187.465
X$11 1 79 M3_M2_CDNS_40661956134284
* cell instance $12 r0 *1 3.97,7.325
X$12 32 30 24 23 36 33 29 31 106 4 9 8 7 6 19 20 21 22 14 157 151 163 162 161
+ 160 159 158 156 155 154 18 18 17 16 15 15 13 13 12 11 10 10 2 3 3 5
+ comp018green_out_paddrv_16T
* cell instance $13 r0 *1 1.37,139.5
X$13 2 3 M3_M2_CDNS_40661956134313
* cell instance $14 r0 *1 1.37,15.5
X$14 2 3 M3_M2_CDNS_40661956134312
* cell instance $15 r0 *1 1.37,47.5
X$15 2 3 M3_M2_CDNS_40661956134312
* cell instance $16 r0 *1 1.37,31.5
X$16 2 3 M3_M2_CDNS_40661956134312
* cell instance $17 r0 *1 1.37,175.5
X$17 2 3 M3_M2_CDNS_40661956134312
* cell instance $18 r0 *1 72.36,245.31
X$18 4 5 M2_M1_CDNS_40661956134436
* cell instance $19 r0 *1 72.36,240.47
X$19 4 5 M2_M1_CDNS_40661956134436
* cell instance $20 r0 *1 72.9,127.5
X$20 4 5 M3_M2_CDNS_40661956134311
* cell instance $21 r0 *1 72.9,79.5
X$21 4 5 M3_M2_CDNS_40661956134311
* cell instance $22 r0 *1 72.9,95.5
X$22 4 5 M3_M2_CDNS_40661956134311
* cell instance $23 r0 *1 72.9,111.5
X$23 4 5 M3_M2_CDNS_40661956134311
* cell instance $24 r180 *1 37.885,179.845
X$24 44 13 270 63 65 51 44 12 59 8 9 250 4 268 54 267 4 266 151 68 72
+ comp018green_out_predrv
* cell instance $25 m0 *1 2.395,179.845
X$25 44 10 270 52 56 51 44 11 59 6 7 254 4 268 54 267 4 266 151 61 53
+ comp018green_out_predrv
* cell instance $26 m0 *1 37.435,179.845
X$26 44 15 270 63 65 51 44 16 59 19 20 253 4 269 54 267 4 266 151 60 69
+ comp018green_out_predrv
* cell instance $27 r180 *1 72.925,179.845
X$27 44 18 270 46 48 51 44 17 59 21 22 256 4 269 54 267 4 266 151 62 78
+ comp018green_out_predrv
* cell instance $28 r0 *1 2.62,159.765
X$28 4 280 M2_M1_CDNS_40661956134236
* cell instance $29 r0 *1 13.31,150.405
X$29 4 271 M2_M1_CDNS_40661956134309
* cell instance $30 r0 *1 13.31,150.405
X$30 4 271 M3_M2_CDNS_40661956134310
* cell instance $31 r0 *1 62.995,150.405
X$31 4 272 M2_M1_CDNS_40661956134309
* cell instance $32 r0 *1 62.995,150.405
X$32 4 272 M3_M2_CDNS_40661956134310
* cell instance $33 r0 *1 72.7,159.765
X$33 4 5 M2_M1_CDNS_40661956134236
* cell instance $34 r0 *1 72.9,147.5
X$34 4 5 M3_M2_CDNS_40661956134285
* cell instance $35 r0 *1 2.62,159.5
X$35 4 280 M3_M2_CDNS_40661956134304
* cell instance $36 r0 *1 5.03,157.86
X$36 4 275 M2_M1_CDNS_40661956134305
* cell instance $37 r0 *1 5.03,157.995
X$37 4 275 M3_M2_CDNS_40661956134306
* cell instance $38 r0 *1 11.99,157.86
X$38 4 264 M2_M1_CDNS_40661956134305
* cell instance $39 r0 *1 11.99,157.995
X$39 4 264 M3_M2_CDNS_40661956134306
* cell instance $40 r0 *1 14.07,157.86
X$40 4 274 M2_M1_CDNS_40661956134305
* cell instance $41 r0 *1 14.07,157.995
X$41 4 274 M3_M2_CDNS_40661956134306
* cell instance $42 r0 *1 35.25,157.86
X$42 4 273 M2_M1_CDNS_40661956134305
* cell instance $43 r0 *1 35.25,157.995
X$43 4 273 M3_M2_CDNS_40661956134306
* cell instance $44 r0 *1 40.07,157.86
X$44 4 276 M2_M1_CDNS_40661956134305
* cell instance $45 r0 *1 40.07,157.995
X$45 4 276 M3_M2_CDNS_40661956134306
* cell instance $46 r0 *1 61.25,157.86
X$46 4 265 M2_M1_CDNS_40661956134305
* cell instance $47 r0 *1 61.25,157.995
X$47 4 265 M3_M2_CDNS_40661956134306
* cell instance $48 r0 *1 63.33,157.86
X$48 4 263 M2_M1_CDNS_40661956134305
* cell instance $49 r0 *1 63.33,157.995
X$49 4 263 M3_M2_CDNS_40661956134306
* cell instance $50 r0 *1 70.29,157.86
X$50 4 277 M2_M1_CDNS_40661956134305
* cell instance $51 r0 *1 70.29,157.995
X$51 4 277 M3_M2_CDNS_40661956134306
* cell instance $52 r0 *1 72.9,159.5
X$52 4 5 M3_M2_CDNS_40661956134311
* cell instance $53 r0 *1 16.51,159.42
X$53 4 259 M2_M1_CDNS_40661956134307
* cell instance $54 r0 *1 16.51,159.42
X$54 4 259 M3_M2_CDNS_40661956134308
* cell instance $55 r0 *1 18.95,159.17
X$55 4 254 M2_M1_CDNS_40661956134307
* cell instance $56 r0 *1 18.95,159.165
X$56 4 254 M3_M2_CDNS_40661956134308
* cell instance $57 r0 *1 20.14,159.575
X$57 4 261 M2_M1_CDNS_40661956134293
* cell instance $58 r0 *1 20.14,159.77
X$58 4 261 M3_M2_CDNS_40661956134300
* cell instance $59 r0 *1 21.33,159.17
X$59 4 250 M2_M1_CDNS_40661956134307
* cell instance $60 r0 *1 21.33,159.165
X$60 4 250 M3_M2_CDNS_40661956134308
* cell instance $61 r0 *1 23.77,159.42
X$61 4 255 M2_M1_CDNS_40661956134307
* cell instance $62 r0 *1 23.77,159.42
X$62 4 255 M3_M2_CDNS_40661956134308
* cell instance $63 r0 *1 26.21,159.42
X$63 4 249 M2_M1_CDNS_40661956134307
* cell instance $64 r0 *1 26.21,159.42
X$64 4 249 M3_M2_CDNS_40661956134308
* cell instance $65 r0 *1 28.29,159.42
X$65 4 248 M2_M1_CDNS_40661956134307
* cell instance $66 r0 *1 28.29,159.42
X$66 4 248 M3_M2_CDNS_40661956134308
* cell instance $67 r0 *1 47.03,159.42
X$67 4 258 M2_M1_CDNS_40661956134307
* cell instance $68 r0 *1 47.03,159.42
X$68 4 258 M3_M2_CDNS_40661956134308
* cell instance $69 r0 *1 49.11,159.42
X$69 4 251 M2_M1_CDNS_40661956134307
* cell instance $70 r0 *1 49.11,159.42
X$70 4 251 M3_M2_CDNS_40661956134308
* cell instance $71 r0 *1 51.55,159.42
X$71 4 252 M2_M1_CDNS_40661956134307
* cell instance $72 r0 *1 51.55,159.42
X$72 4 252 M3_M2_CDNS_40661956134308
* cell instance $73 r0 *1 53.99,159.17
X$73 4 253 M2_M1_CDNS_40661956134307
* cell instance $74 r0 *1 53.99,159.165
X$74 4 253 M3_M2_CDNS_40661956134308
* cell instance $75 r0 *1 55.18,159.575
X$75 4 262 M2_M1_CDNS_40661956134293
* cell instance $76 r0 *1 55.18,159.77
X$76 4 262 M3_M2_CDNS_40661956134300
* cell instance $77 r0 *1 56.37,159.165
X$77 4 256 M3_M2_CDNS_40661956134308
* cell instance $78 r0 *1 56.37,159.17
X$78 4 256 M2_M1_CDNS_40661956134307
* cell instance $79 r0 *1 58.81,159.42
X$79 4 257 M2_M1_CDNS_40661956134307
* cell instance $80 r0 *1 58.81,159.42
X$80 4 257 M3_M2_CDNS_40661956134308
* cell instance $81 r0 *1 72.9,275.5
X$81 4 5 M3_M2_CDNS_40661956134285
* cell instance $82 r0 *1 72.9,235.465
X$82 4 5 M3_M2_CDNS_40661956134285
* cell instance $83 r0 *1 72.9,203.465
X$83 4 5 M3_M2_CDNS_40661956134285
* cell instance $84 r0 *1 51.3,283.185
X$84 4 148 M2_M1_CDNS_40661956134235
* cell instance $85 m45 *1 51.3,282.445
X$85 4 141 172 nmoscap_6p0_CDNS_4066195613423
* cell instance $86 r0 *1 56.3,283.185
X$86 4 148 M2_M1_CDNS_40661956134235
* cell instance $87 r0 *1 43.8,283.185
X$87 4 148 M2_M1_CDNS_40661956134235
* cell instance $88 m45 *1 43.8,282.445
X$88 4 141 170 nmoscap_6p0_CDNS_4066195613423
* cell instance $89 r0 *1 48.8,283.185
X$89 4 148 M2_M1_CDNS_40661956134235
* cell instance $90 r0 *1 13.8,283.185
X$90 4 148 M2_M1_CDNS_40661956134235
* cell instance $91 m45 *1 13.8,282.445
X$91 4 141 171 nmoscap_6p0_CDNS_4066195613423
* cell instance $92 r0 *1 18.8,283.185
X$92 4 148 M2_M1_CDNS_40661956134235
* cell instance $93 r0 *1 21.3,283.185
X$93 4 148 M2_M1_CDNS_40661956134235
* cell instance $94 m45 *1 21.3,282.445
X$94 4 141 167 nmoscap_6p0_CDNS_4066195613423
* cell instance $95 r0 *1 26.3,283.185
X$95 4 148 M2_M1_CDNS_40661956134235
* cell instance $96 r0 *1 28.8,283.185
X$96 4 148 M2_M1_CDNS_40661956134235
* cell instance $97 m45 *1 28.8,282.445
X$97 4 141 166 nmoscap_6p0_CDNS_4066195613423
* cell instance $98 r0 *1 33.8,283.185
X$98 4 148 M2_M1_CDNS_40661956134235
* cell instance $99 r0 *1 66.3,283.185
X$99 4 148 M2_M1_CDNS_40661956134235
* cell instance $100 m45 *1 66.3,282.445
X$100 4 141 168 nmoscap_6p0_CDNS_4066195613423
* cell instance $101 r0 *1 72.35,283.185
X$101 4 5 M2_M1_CDNS_40661956134235
* cell instance $102 r0 *1 36.3,283.185
X$102 4 148 M2_M1_CDNS_40661956134235
* cell instance $103 m45 *1 36.3,282.445
X$103 4 141 169 nmoscap_6p0_CDNS_4066195613423
* cell instance $104 r0 *1 41.3,283.185
X$104 4 148 M2_M1_CDNS_40661956134235
* cell instance $105 r0 *1 58.8,283.185
X$105 4 148 M2_M1_CDNS_40661956134235
* cell instance $106 m45 *1 58.8,282.445
X$106 4 141 173 nmoscap_6p0_CDNS_4066195613423
* cell instance $107 r0 *1 63.8,283.185
X$107 4 148 M2_M1_CDNS_40661956134235
* cell instance $108 r0 *1 7.47,152.48
X$108 6 23 M2_M1_CDNS_40661956134320
* cell instance $109 r0 *1 8.69,152.48
X$109 7 24 M2_M1_CDNS_40661956134320
* cell instance $110 r0 *1 32.81,152.48
X$110 8 38 M2_M1_CDNS_40661956134320
* cell instance $111 r0 *1 32.61,148.955
X$111 8 38 M2_M1_CDNS_40661956134237
* cell instance $112 r0 *1 7.285,148.955
X$112 8 30 M2_M1_CDNS_40661956134237
* cell instance $113 r0 *1 34.03,152.48
X$113 9 37 M2_M1_CDNS_40661956134320
* cell instance $114 r0 *1 33.83,148.055
X$114 9 37 M2_M1_CDNS_40661956134237
* cell instance $115 r0 *1 8.185,148.055
X$115 9 32 M2_M1_CDNS_40661956134237
* cell instance $116 r0 *1 17.73,152.48
X$116 10 34 M2_M1_CDNS_40661956134320
* cell instance $117 r0 *1 17.93,147.02
X$117 10 34 M2_M1_CDNS_40661956134237
* cell instance $118 r0 *1 15.29,153.38
X$118 11 25 M2_M1_CDNS_40661956134320
* cell instance $119 r0 *1 20.965,146.955
X$119 11 25 M2_M1_CDNS_40661956134270
* cell instance $120 r0 *1 24.99,152.48
X$120 12 35 M2_M1_CDNS_40661956134320
* cell instance $121 m90 *1 24.99,146.955
X$121 12 35 M2_M1_CDNS_40661956134270
* cell instance $122 r0 *1 22.55,153.38
X$122 13 26 M2_M1_CDNS_40661956134320
* cell instance $123 m90 *1 29.76,146.955
X$123 13 26 M2_M1_CDNS_40661956134270
* cell instance $124 m0 *1 22.915,247.295
X$124 121 98 114 165 112 113 98 123 211 164 114 14 106 151 comp018green_esd_cdm
* cell instance $125 m90 *1 52.77,153.38
X$125 15 27 M2_M1_CDNS_40661956134320
* cell instance $126 r0 *1 45.57,146.955
X$126 15 27 M2_M1_CDNS_40661956134270
* cell instance $127 m90 *1 50.33,152.48
X$127 16 42 M2_M1_CDNS_40661956134320
* cell instance $128 r0 *1 50.34,146.955
X$128 16 42 M2_M1_CDNS_40661956134270
* cell instance $129 m90 *1 60.03,153.38
X$129 17 28 M2_M1_CDNS_40661956134320
* cell instance $130 m90 *1 54.365,146.955
X$130 17 28 M2_M1_CDNS_40661956134270
* cell instance $131 m90 *1 57.59,152.48
X$131 18 39 M2_M1_CDNS_40661956134320
* cell instance $132 m90 *1 57.4,147.02
X$132 18 39 M2_M1_CDNS_40661956134237
* cell instance $133 r0 *1 42.51,152.48
X$133 19 41 M2_M1_CDNS_40661956134320
* cell instance $134 m90 *1 67.145,148.055
X$134 19 36 M2_M1_CDNS_40661956134237
* cell instance $135 r0 *1 42.71,148.055
X$135 19 41 M2_M1_CDNS_40661956134237
* cell instance $136 r0 *1 43.73,152.48
X$136 20 40 M2_M1_CDNS_40661956134320
* cell instance $137 m90 *1 68.045,148.955
X$137 20 33 M2_M1_CDNS_40661956134237
* cell instance $138 r0 *1 43.93,148.955
X$138 20 40 M2_M1_CDNS_40661956134237
* cell instance $139 m90 *1 67.85,152.48
X$139 21 29 M2_M1_CDNS_40661956134320
* cell instance $140 m90 *1 69.07,152.48
X$140 22 31 M2_M1_CDNS_40661956134320
* cell instance $141 r0 *1 17.325,190.09
X$141 44 43 M2_M1_CDNS_40661956134281
* cell instance $142 r0 *1 15.65,176.22
X$142 44 43 M2_M1_CDNS_40661956134299
* cell instance $143 r0 *1 15.65,176.22
X$143 44 43 M3_M2_CDNS_40661956134301
* cell instance $144 r0 *1 55.275,227.37
X$144 44 108 M3_M2_CDNS_40661956134433
* cell instance $145 r0 *1 54.63,227.37
X$145 44 108 M3_M2_CDNS_40661956134433
* cell instance $146 r0 *1 55.96,187.505
X$146 54 88 59 279 230 229 228 44 74 87 87 151 comp018green_sigbuf_1
* cell instance $147 m90 *1 56.41,187.505
X$147 88 51 87 230 234 233 229 232 228 74 44 94 74 94 87 151
+ comp018green_out_sigbuf_a
* cell instance $148 r0 *1 30.21,187.505
X$148 105 46 48 74 234 233 240 238 236 232 174 76 76 89 94 44 76 94 151
+ comp018green_out_sigbuf_oe
* cell instance $149 r0 *1 43.545,190.09
X$149 44 92 M2_M1_CDNS_40661956134281
* cell instance $150 m90 *1 30.66,187.505
X$150 102 63 65 74 244 243 240 238 236 242 104 74 76 89 86 44 76 86 151
+ comp018green_out_sigbuf_oe
* cell instance $151 r0 *1 3.99,187.505
X$151 103 52 56 74 244 243 241 239 237 242 73 74 81 83 86 44 81 86 151
+ comp018green_out_sigbuf_oe
* cell instance $152 r0 *1 2.62,175.18
X$152 44 260 M2_M1_CDNS_40661956134293
* cell instance $153 r0 *1 2.62,175.18
X$153 44 260 M3_M2_CDNS_40661956134300
* cell instance $154 r0 *1 20.14,173.1
X$154 44 268 M2_M1_CDNS_40661956134302
* cell instance $155 r0 *1 20.14,174.255
X$155 44 268 M3_M2_CDNS_40661956134303
* cell instance $156 r0 *1 55.18,173.1
X$156 44 269 M2_M1_CDNS_40661956134302
* cell instance $157 r0 *1 55.18,174.255
X$157 44 269 M3_M2_CDNS_40661956134303
* cell instance $158 r0 *1 3.81,176.22
X$158 44 247 M2_M1_CDNS_40661956134299
* cell instance $159 r0 *1 3.81,176.22
X$159 44 247 M3_M2_CDNS_40661956134301
* cell instance $160 r0 *1 24.63,176.22
X$160 44 245 M2_M1_CDNS_40661956134299
* cell instance $161 r0 *1 24.63,176.22
X$161 44 245 M3_M2_CDNS_40661956134301
* cell instance $162 r0 *1 43.285,179.6
X$162 44 92 M2_M1_CDNS_40661956134237
* cell instance $163 r0 *1 43.545,176.22
X$163 44 92 M3_M2_CDNS_40661956134301
* cell instance $164 r0 *1 50.69,176.22
X$164 44 246 M2_M1_CDNS_40661956134299
* cell instance $165 r0 *1 50.69,176.22
X$165 44 246 M3_M2_CDNS_40661956134301
* cell instance $166 r0 *1 59.67,176.22
X$166 44 45 M2_M1_CDNS_40661956134299
* cell instance $167 r0 *1 59.67,176.22
X$167 44 45 M3_M2_CDNS_40661956134301
* cell instance $168 r0 *1 52.57,240.04
X$168 44 108 M3_M2_CDNS_40661956134417
* cell instance $169 r0 *1 58.96,204.285
X$169 44 45 M2_M1_CDNS_40661956134237
* cell instance $170 r0 *1 55.275,204.47
X$170 44 108 M2_M1_CDNS_40661956134270
* cell instance $171 r90 *1 42.385,184.62
X$171 46 93 M2_M1_CDNS_40661956134237
* cell instance $172 r0 *1 65.76,184.36
X$172 46 47 M2_M1_CDNS_40661956134237
* cell instance $173 m90 *1 66.02,171.785
X$173 46 47 M2_M1_CDNS_40661956134270
* cell instance $174 m90 *1 42.385,189.305
X$174 46 93 M2_M1_CDNS_40661956134270
* cell instance $175 r0 *1 65.06,183.68
X$175 48 49 M2_M1_CDNS_40661956134237
* cell instance $176 r0 *1 41.915,183.68
X$176 48 91 M2_M1_CDNS_40661956134237
* cell instance $177 m90 *1 64.8,171.785
X$177 48 49 M2_M1_CDNS_40661956134270
* cell instance $178 m90 *1 41.655,193.05
X$178 48 91 M2_M1_CDNS_40661956134270
* cell instance $179 r0 *1 9.56,182.32
X$179 52 50 M2_M1_CDNS_40661956134237
* cell instance $180 r0 *1 9.3,171.785
X$180 52 50 M2_M1_CDNS_40661956134270
* cell instance $181 m90 *1 27.42,181.64
X$181 51 67 M2_M1_CDNS_40661956134237
* cell instance $182 m90 *1 62.98,181.64
X$182 51 55 M2_M1_CDNS_40661956134237
* cell instance $183 r0 *1 12.86,181.64
X$183 51 58 M2_M1_CDNS_40661956134237
* cell instance $184 r0 *1 47.9,181.64
X$184 51 77 M2_M1_CDNS_40661956134237
* cell instance $185 m90 *1 62.72,171.785
X$185 51 55 M2_M1_CDNS_40661956134270
* cell instance $186 m90 *1 27.68,171.785
X$186 51 67 M2_M1_CDNS_40661956134270
* cell instance $187 r0 *1 44.665,189.305
X$187 51 77 M2_M1_CDNS_40661956134270
* cell instance $188 r0 *1 12.6,171.785
X$188 51 58 M2_M1_CDNS_40661956134270
* cell instance $189 r0 *1 47.64,171.785
X$189 51 77 M2_M1_CDNS_40661956134270
* cell instance $190 r0 *1 15.905,182.32
X$190 52 85 M2_M1_CDNS_40661956134237
* cell instance $191 r0 *1 16.165,189.305
X$191 52 85 M2_M1_CDNS_40661956134270
* cell instance $192 r0 *1 7,180.96
X$192 54 53 M2_M1_CDNS_40661956134237
* cell instance $193 m90 *1 33.28,180.96
X$193 54 72 M2_M1_CDNS_40661956134237
* cell instance $194 m90 *1 68.32,180.96
X$194 54 78 M2_M1_CDNS_40661956134237
* cell instance $195 r0 *1 42.04,180.96
X$195 54 69 M2_M1_CDNS_40661956134237
* cell instance $196 r0 *1 66.705,192.985
X$196 54 78 M2_M1_CDNS_40661956134270
* cell instance $197 r0 *1 11.35,183
X$197 56 57 M2_M1_CDNS_40661956134286
* cell instance $198 r0 *1 10.52,171.785
X$198 56 57 M2_M1_CDNS_40661956134270
* cell instance $199 r0 *1 13.725,189.305
X$199 56 57 M2_M1_CDNS_40661956134270
* cell instance $200 m90 *1 57.94,180.28
X$200 59 62 M2_M1_CDNS_40661956134237
* cell instance $201 m90 *1 22.9,180.28
X$201 59 68 M2_M1_CDNS_40661956134237
* cell instance $202 r0 *1 17.38,180.28
X$202 59 61 M2_M1_CDNS_40661956134237
* cell instance $203 r0 *1 52.42,180.28
X$203 59 60 M2_M1_CDNS_40661956134237
* cell instance $204 r0 *1 67.125,180.28
X$204 59 82 M2_M1_CDNS_40661956134237
* cell instance $205 r0 *1 67.385,189.725
X$205 59 82 M2_M1_CDNS_40661956134270
* cell instance $206 m90 *1 18.745,182.32
X$206 63 84 M2_M1_CDNS_40661956134237
* cell instance $207 m90 *1 30.72,182.32
X$207 63 64 M2_M1_CDNS_40661956134237
* cell instance $208 r0 *1 44.6,182.32
X$208 63 70 M2_M1_CDNS_40661956134237
* cell instance $209 m90 *1 18.485,189.305
X$209 63 84 M2_M1_CDNS_40661956134270
* cell instance $210 m90 *1 44.34,171.785
X$210 63 70 M2_M1_CDNS_40661956134270
* cell instance $211 r0 *1 30.98,171.785
X$211 63 64 M2_M1_CDNS_40661956134270
* cell instance $212 m90 *1 45.3,183
X$212 65 71 M2_M1_CDNS_40661956134237
* cell instance $213 m90 *1 22.755,183
X$213 65 75 M2_M1_CDNS_40661956134237
* cell instance $214 m90 *1 29.5,183
X$214 65 66 M2_M1_CDNS_40661956134237
* cell instance $215 m90 *1 20.925,189.305
X$215 65 75 M2_M1_CDNS_40661956134270
* cell instance $216 r0 *1 29.76,171.785
X$216 65 66 M2_M1_CDNS_40661956134270
* cell instance $217 r0 *1 45.56,171.785
X$217 65 71 M2_M1_CDNS_40661956134270
* cell instance $218 r0 *1 8.43,202.71
X$218 74 73 M2_M1_CDNS_40661956134237
* cell instance $219 r0 *1 7.82,286.505
X$219 74 73 M2_M1_CDNS_40661956134237
* cell instance $220 r90 *1 6.095,277.005
X$220 74 83 151 ppolyf_u_CDNS_4066195613451
* cell instance $221 r0 *1 57.29,205.815
X$221 209 74 87 208 87 pn_6p0_CDNS_4066195613428
* cell instance $222 r0 *1 58.045,206.315
X$222 74 97 M2_M1_CDNS_40661956134270
* cell instance $223 r0 *1 57.29,208.135
X$223 209 74 87 208 87 pn_6p0_CDNS_4066195613428
* cell instance $224 r0 *1 58.045,208.685
X$224 74 96 M2_M1_CDNS_40661956134270
* cell instance $225 r0 *1 69.76,286.505
X$225 74 149 M2_M1_CDNS_40661956134245
* cell instance $226 m90 *1 35.715,203.54
X$226 74 105 M2_M1_CDNS_40661956134237
* cell instance $227 m90 *1 24.635,203.54
X$227 74 102 M2_M1_CDNS_40661956134237
* cell instance $228 r90 *1 57.79,193.035
X$228 74 96 M2_M1_CDNS_40661956134237
* cell instance $229 r90 *1 70.48,203.8
X$229 74 149 M2_M1_CDNS_40661956134237
* cell instance $230 r0 *1 28.28,202.71
X$230 74 104 M2_M1_CDNS_40661956134237
* cell instance $231 r0 *1 10.015,203.54
X$231 74 103 M2_M1_CDNS_40661956134237
* cell instance $232 r0 *1 69.49,202.18
X$232 74 149 M2_M1_CDNS_40661956134237
* cell instance $233 r0 *1 57.53,202.86
X$233 74 96 M2_M1_CDNS_40661956134237
* cell instance $234 r0 *1 68.76,202.86
X$234 74 149 M2_M1_CDNS_40661956134237
* cell instance $235 r0 *1 54.89,203.54
X$235 74 107 M2_M1_CDNS_40661956134237
* cell instance $236 r0 *1 53.67,202.18
X$236 74 90 M2_M1_CDNS_40661956134237
* cell instance $237 r0 *1 60.37,202.18
X$237 74 97 M2_M1_CDNS_40661956134237
* cell instance $238 r0 *1 53.41,194.84
X$238 74 90 M2_M1_CDNS_40661956134270
* cell instance $239 r0 *1 54.63,194.84
X$239 74 107 M2_M1_CDNS_40661956134270
* cell instance $240 r0 *1 30.435,196.32
X$240 76 222 M2_M1_CDNS_40661956134281
* cell instance $241 r0 *1 30.435,196.145
X$241 76 222 M3_M2_CDNS_40661956134290
* cell instance $242 r0 *1 25.605,197.36
X$242 76 216 M2_M1_CDNS_40661956134279
* cell instance $243 r0 *1 25.605,197.24
X$243 76 216 M3_M2_CDNS_40661956134294
* cell instance $244 r0 *1 35.265,197.36
X$244 76 221 M2_M1_CDNS_40661956134279
* cell instance $245 r0 *1 35.265,197.24
X$245 76 221 M3_M2_CDNS_40661956134294
* cell instance $246 r90 *1 4.695,277.005
X$246 134 81 151 ppolyf_u_CDNS_4066195613451
* cell instance $247 r0 *1 2.41,279.5
X$247 81 138 124 81 M1_NWELL_CDNS_40661956134480
* cell instance $248 r0 *1 1.92,270.18
X$248 81 137 M2_M1_CDNS_40661956134283
* cell instance $249 r0 *1 66.56,276.435
X$249 81 135 M2_M1_CDNS_40661956134277
* cell instance $250 m0 *1 4.24,279.26
X$250 118 134 144 81 136 81 139 81 134 140 126 125 83 83 130 83 207 113 112 143
+ 152 142 130 121 153 117 151 111 122 121 227 111 113 110 124 124 124 124 213
+ 211 121 150 comp018green_inpath_cms_smt
* cell instance $251 r0 *1 4.995,275.675
X$251 81 138 124 81 M1_NWELL_CDNS_40661956134425
* cell instance $252 r0 *1 1.92,274.725
X$252 81 137 M2_M1_CDNS_40661956134283
* cell instance $253 r0 *1 18.99,279.055
X$253 81 135 M2_M1_CDNS_40661956134481
* cell instance $254 r0 *1 9.045,197.51
X$254 81 220 M2_M1_CDNS_40661956134279
* cell instance $255 r0 *1 9.045,197.24
X$255 81 220 M3_M2_CDNS_40661956134294
* cell instance $256 r0 *1 40.34,276.675
X$256 81 135 M2_M1_CDNS_40661956134281
* cell instance $257 r0 *1 42.685,276.675
X$257 81 135 M2_M1_CDNS_40661956134281
* cell instance $258 r0 *1 43.76,276.675
X$258 81 135 M2_M1_CDNS_40661956134281
* cell instance $259 r0 *1 44.875,276.675
X$259 81 135 M2_M1_CDNS_40661956134281
* cell instance $260 r0 *1 47.22,276.675
X$260 81 135 M2_M1_CDNS_40661956134281
* cell instance $261 r0 *1 1.92,201.4
X$261 81 137 M2_M1_CDNS_40661956134286
* cell instance $262 r0 *1 1.92,195.465
X$262 81 137 M3_M2_CDNS_40661956134285
* cell instance $263 r0 *1 1.92,251.465
X$263 81 137 M3_M2_CDNS_40661956134285
* cell instance $264 r0 *1 40.34,268.865
X$264 83 127 M2_M1_CDNS_40661956134275
* cell instance $265 r0 *1 43.78,269.385
X$265 83 127 M2_M1_CDNS_40661956134281
* cell instance $266 r0 *1 66.56,268.865
X$266 83 127 M2_M1_CDNS_40661956134275
* cell instance $267 r0 *1 4.215,190.09
X$267 83 128 M2_M1_CDNS_40661956134281
* cell instance $268 r0 *1 4.52,187.465
X$268 83 128 M3_M2_CDNS_40661956134285
* cell instance $269 r0 *1 17.54,269.385
X$269 83 131 M2_M1_CDNS_40661956134281
* cell instance $270 r0 *1 21,268.865
X$270 83 127 M2_M1_CDNS_40661956134275
* cell instance $271 r0 *1 4.52,264.905
X$271 83 128 M2_M1_CDNS_40661956134286
* cell instance $272 r0 *1 4.52,259.465
X$272 83 128 M3_M2_CDNS_40661956134285
* cell instance $273 r0 *1 17.28,264.905
X$273 83 131 M2_M1_CDNS_40661956134237
* cell instance $274 r0 *1 18.865,264.905
X$274 83 127 M2_M1_CDNS_40661956134237
* cell instance $275 r0 *1 13.415,277.185
X$275 83 127 M2_M1_CDNS_40661956134237
* cell instance $276 r0 *1 17.295,201.44
X$276 86 214 M2_M1_CDNS_40661956134318
* cell instance $277 r0 *1 17.3,201.44
X$277 86 214 M3_M2_CDNS_40661956134435
* cell instance $278 r0 *1 51.825,196.47
X$278 87 225 M2_M1_CDNS_40661956134281
* cell instance $279 r0 *1 51.825,196.175
X$279 87 225 M3_M2_CDNS_40661956134290
* cell instance $280 r0 *1 56.19,196.47
X$280 87 95 M2_M1_CDNS_40661956134281
* cell instance $281 r0 *1 56.19,196.175
X$281 87 95 M3_M2_CDNS_40661956134290
* cell instance $282 r0 *1 56.62,205.425
X$282 87 95 M2_M1_CDNS_40661956134270
* cell instance $283 r0 *1 54.705,187.71
X$283 88 231 M2_M1_CDNS_40661956134234
* cell instance $284 r0 *1 54.8,187.71
X$284 88 231 M3_M2_CDNS_40661956134298
* cell instance $285 r0 *1 30.435,190.09
X$285 89 224 M2_M1_CDNS_40661956134281
* cell instance $286 r0 *1 30.435,187.465
X$286 89 224 M3_M2_CDNS_40661956134284
* cell instance $287 r0 *1 44.05,201.44
X$287 94 212 M2_M1_CDNS_40661956134291
* cell instance $288 r0 *1 44.385,201.44
X$288 94 212 M3_M2_CDNS_40661956134297
* cell instance $289 r0 *1 66.665,205.55
X$289 98 101 M1_PACTIVE_CDNS_40661956134272
* cell instance $290 r0 *1 66.665,217.77
X$290 98 101 M1_PACTIVE_CDNS_40661956134272
* cell instance $291 r0 *1 56.5,215.745
X$291 98 M1_PSUB_CDNS_40661956134319
* cell instance $292 r0 *1 73.075,211.66
X$292 98 101 M1_PACTIVE_CDNS_40661956134271
* cell instance $293 m45 *1 68.11,207.74
X$293 99 98 nmoscap_6p0_CDNS_4066195613422
* cell instance $294 m45 *1 68.11,212.58
X$294 99 98 nmoscap_6p0_CDNS_4066195613422
* cell instance $295 m45 *1 62.41,207.74
X$295 99 98 nmoscap_6p0_CDNS_4066195613422
* cell instance $296 r0 *1 60.49,211.66
X$296 98 101 M1_PACTIVE_CDNS_40661956134271
* cell instance $297 m45 *1 62.41,212.58
X$297 99 98 nmoscap_6p0_CDNS_4066195613422
* cell instance $298 r0 *1 46.745,267.465
X$298 98 114 M3_M2_CDNS_40661956134285
* cell instance $299 r0 *1 66.655,211.9
X$299 99 100 M3_M2_CDNS_40661956134317
* cell instance $300 r0 *1 67.85,209.315
X$300 99 100 M2_M1_CDNS_40661956134270
* cell instance $301 r0 *1 67.85,213.95
X$301 99 100 M2_M1_CDNS_40661956134270
* cell instance $302 r0 *1 65.67,209.315
X$302 99 100 M2_M1_CDNS_40661956134270
* cell instance $303 r0 *1 65.67,213.95
X$303 99 100 M2_M1_CDNS_40661956134270
* cell instance $304 r0 *1 62.575,187.465
X$304 110 109 M3_M2_CDNS_40661956134313
* cell instance $305 r0 *1 62.56,220.135
X$305 110 109 M2_M1_CDNS_40661956134237
* cell instance $306 r0 *1 58.34,248.81
X$306 111 119 M3_M2_CDNS_40661956134280
* cell instance $307 r0 *1 62.3,234.7
X$307 111 M2_M1_CDNS_40661956134434
* cell instance $308 r0 *1 58.28,239.32
X$308 111 119 M2_M1_CDNS_40661956134270
* cell instance $309 r0 *1 16.375,231.35
X$309 113 112 M2_M1_CDNS_40661956134269
* cell instance $310 r0 *1 71.21,229.575
X$310 118 117 M2_M1_CDNS_40661956134270
* cell instance $311 r0 *1 43.08,246.34
X$311 121 120 M2_M1_CDNS_40661956134287
* cell instance $312 r0 *1 43.08,251.215
X$312 121 120 M2_M1_CDNS_40661956134286
* cell instance $313 r0 *1 21.67,251.215
X$313 121 123 M2_M1_CDNS_40661956134432
* cell instance $314 r0 *1 39.57,251.215
X$314 121 122 M2_M1_CDNS_40661956134286
* cell instance $315 r0 *1 23.97,243.27
X$315 121 123 M2_M1_CDNS_40661956134282
* cell instance $316 r0 *1 55.195,237.16
X$316 121 215 M2_M1_CDNS_40661956134279
* cell instance $317 r0 *1 55.195,237.16
X$317 121 215 M3_M2_CDNS_40661956134294
* cell instance $318 r0 *1 28.565,246.34
X$318 121 123 M2_M1_CDNS_40661956134287
* cell instance $319 r0 *1 33.08,246.34
X$319 121 123 M2_M1_CDNS_40661956134287
* cell instance $320 r0 *1 39.57,246.34
X$320 121 122 M2_M1_CDNS_40661956134287
* cell instance $321 r0 *1 36.46,268.58
X$321 130 129 M3_M2_CDNS_40661956134276
* cell instance $322 r0 *1 36.46,268.58
X$322 130 129 M2_M1_CDNS_40661956134279
* cell instance $323 r0 *1 36.72,263.265
X$323 130 129 M2_M1_CDNS_40661956134237
* cell instance $324 r0 *1 23.94,268.865
X$324 130 202 M2_M1_CDNS_40661956134275
* cell instance $325 r0 *1 23.94,268.53
X$325 130 202 M3_M2_CDNS_40661956134278
* cell instance $326 r0 *1 24.88,268.58
X$326 130 132 M2_M1_CDNS_40661956134279
* cell instance $327 r0 *1 24.88,268.58
X$327 130 132 M3_M2_CDNS_40661956134276
* cell instance $328 r0 *1 27.32,268.58
X$328 130 217 M2_M1_CDNS_40661956134279
* cell instance $329 r0 *1 27.32,268.58
X$329 130 217 M3_M2_CDNS_40661956134276
* cell instance $330 r0 *1 29.76,268.58
X$330 130 218 M2_M1_CDNS_40661956134279
* cell instance $331 r0 *1 29.76,268.58
X$331 130 218 M3_M2_CDNS_40661956134276
* cell instance $332 r0 *1 30.67,269.125
X$332 130 179 M2_M1_CDNS_40661956134277
* cell instance $333 r0 *1 30.67,268.53
X$333 130 179 M3_M2_CDNS_40661956134278
* cell instance $334 r0 *1 31.58,268.58
X$334 130 219 M2_M1_CDNS_40661956134279
* cell instance $335 r0 *1 31.58,268.58
X$335 130 219 M3_M2_CDNS_40661956134276
* cell instance $336 r0 *1 34.02,268.58
X$336 130 133 M2_M1_CDNS_40661956134279
* cell instance $337 r0 *1 34.02,268.58
X$337 130 133 M3_M2_CDNS_40661956134276
* cell instance $338 r0 *1 37.4,268.865
X$338 130 203 M2_M1_CDNS_40661956134275
* cell instance $339 r0 *1 37.4,268.53
X$339 130 203 M3_M2_CDNS_40661956134278
* cell instance $340 r0 *1 24.9,263.265
X$340 130 132 M2_M1_CDNS_40661956134232
* cell instance $341 r0 *1 33.42,263.265
X$341 130 133 M2_M1_CDNS_40661956134232
* cell instance $342 r0 *1 4.075,281.725
X$342 134 144 M2_M1_CDNS_40661956134237
* cell instance $343 r0 *1 11.735,278.165
X$343 134 140 M2_M1_CDNS_40661956134270
* cell instance $344 r0 *1 50.16,276.435
X$344 136 198 M2_M1_CDNS_40661956134277
* cell instance $345 r0 *1 50.16,276.435
X$345 136 198 M3_M2_CDNS_40661956134278
* cell instance $346 r0 *1 51.1,276.885
X$346 136 199 M2_M1_CDNS_40661956134275
* cell instance $347 r0 *1 51.1,276.885
X$347 136 199 M3_M2_CDNS_40661956134276
* cell instance $348 r0 *1 53.54,276.885
X$348 136 190 M2_M1_CDNS_40661956134275
* cell instance $349 r0 *1 53.54,276.885
X$349 136 190 M3_M2_CDNS_40661956134276
* cell instance $350 r0 *1 55.98,276.885
X$350 136 191 M2_M1_CDNS_40661956134275
* cell instance $351 r0 *1 55.98,276.885
X$351 136 191 M3_M2_CDNS_40661956134276
* cell instance $352 r0 *1 56.89,276.435
X$352 136 195 M2_M1_CDNS_40661956134277
* cell instance $353 r0 *1 56.89,276.435
X$353 136 195 M3_M2_CDNS_40661956134278
* cell instance $354 r0 *1 57.8,276.885
X$354 136 205 M2_M1_CDNS_40661956134275
* cell instance $355 r0 *1 57.8,276.885
X$355 136 205 M3_M2_CDNS_40661956134276
* cell instance $356 r0 *1 60.24,276.885
X$356 136 184 M2_M1_CDNS_40661956134275
* cell instance $357 r0 *1 60.24,276.885
X$357 136 184 M3_M2_CDNS_40661956134276
* cell instance $358 r0 *1 62.68,276.885
X$358 136 204 M2_M1_CDNS_40661956134275
* cell instance $359 r0 *1 62.68,276.885
X$359 136 204 M3_M2_CDNS_40661956134276
* cell instance $360 r0 *1 63.62,276.435
X$360 136 197 M2_M1_CDNS_40661956134277
* cell instance $361 r0 *1 63.62,276.435
X$361 136 197 M3_M2_CDNS_40661956134278
* cell instance $362 r0 *1 23.94,276.435
X$362 139 180 M2_M1_CDNS_40661956134277
* cell instance $363 r0 *1 23.94,276.435
X$363 139 180 M3_M2_CDNS_40661956134278
* cell instance $364 r0 *1 24.88,276.84
X$364 139 187 M2_M1_CDNS_40661956134275
* cell instance $365 r0 *1 24.88,276.84
X$365 139 187 M3_M2_CDNS_40661956134276
* cell instance $366 r0 *1 27.32,276.885
X$366 139 188 M2_M1_CDNS_40661956134275
* cell instance $367 r0 *1 27.32,276.885
X$367 139 188 M3_M2_CDNS_40661956134276
* cell instance $368 r0 *1 29.76,276.885
X$368 139 182 M2_M1_CDNS_40661956134275
* cell instance $369 r0 *1 29.76,276.885
X$369 139 182 M3_M2_CDNS_40661956134276
* cell instance $370 r0 *1 30.67,276.435
X$370 139 178 M2_M1_CDNS_40661956134277
* cell instance $371 r0 *1 30.67,276.435
X$371 139 178 M3_M2_CDNS_40661956134278
* cell instance $372 r0 *1 31.58,276.885
X$372 139 206 M2_M1_CDNS_40661956134275
* cell instance $373 r0 *1 31.58,276.885
X$373 139 206 M3_M2_CDNS_40661956134276
* cell instance $374 r0 *1 34.02,276.885
X$374 139 200 M2_M1_CDNS_40661956134275
* cell instance $375 r0 *1 34.02,276.885
X$375 139 200 M3_M2_CDNS_40661956134276
* cell instance $376 r0 *1 36.46,276.885
X$376 139 181 M2_M1_CDNS_40661956134275
* cell instance $377 r0 *1 36.46,276.885
X$377 139 181 M3_M2_CDNS_40661956134276
* cell instance $378 r0 *1 37.4,276.435
X$378 139 194 M2_M1_CDNS_40661956134277
* cell instance $379 r0 *1 37.4,276.435
X$379 139 194 M3_M2_CDNS_40661956134278
* cell instance $380 r0 *1 40.33,281.34
X$380 141 176 M2_M1_CDNS_40661956134315
* cell instance $381 r90 *1 42.665,280.495
X$381 141 147 M1_PACTIVE_CDNS_40661956134274
* cell instance $382 r0 *1 11.88,283.195
X$382 141 147 M1_PACTIVE_CDNS_40661956134273
* cell instance $383 r0 *1 40.33,281.34
X$383 141 176 M3_M2_CDNS_40661956134316
* cell instance $384 r0 *1 40.33,285.05
X$384 141 175 M2_M1_CDNS_40661956134315
* cell instance $385 r90 *1 42.665,285.895
X$385 141 147 M1_PACTIVE_CDNS_40661956134274
* cell instance $386 r0 *1 40.33,285.05
X$386 141 175 M3_M2_CDNS_40661956134316
* cell instance $387 r0 *1 73.45,283.195
X$387 141 147 M1_PACTIVE_CDNS_40661956134273
* cell instance $388 r0 *1 9.62,283.195
X$388 145 146 M3_M2_CDNS_40661956134314
* cell instance $389 r0 *1 9.62,267.465
X$389 145 146 M3_M2_CDNS_40661956134284
* cell instance $390 r0 *1 56.89,269.125
X$390 207 177 M2_M1_CDNS_40661956134277
* cell instance $391 r0 *1 56.89,268.53
X$391 207 177 M3_M2_CDNS_40661956134278
* cell instance $392 r0 *1 57.8,268.58
X$392 207 183 M3_M2_CDNS_40661956134276
* cell instance $393 r0 *1 57.8,268.58
X$393 207 183 M2_M1_CDNS_40661956134279
* cell instance $394 r0 *1 51.1,268.58
X$394 207 185 M3_M2_CDNS_40661956134276
* cell instance $395 r0 *1 51.1,268.58
X$395 207 185 M2_M1_CDNS_40661956134279
* cell instance $396 r0 *1 53.54,268.58
X$396 207 186 M3_M2_CDNS_40661956134276
* cell instance $397 r0 *1 53.54,268.58
X$397 207 186 M2_M1_CDNS_40661956134279
* cell instance $398 r0 *1 55.98,268.58
X$398 207 189 M3_M2_CDNS_40661956134276
* cell instance $399 r0 *1 55.98,268.58
X$399 207 189 M2_M1_CDNS_40661956134279
* cell instance $400 r0 *1 62.68,268.58
X$400 207 192 M3_M2_CDNS_40661956134276
* cell instance $401 r0 *1 62.68,268.58
X$401 207 192 M2_M1_CDNS_40661956134279
* cell instance $402 r0 *1 60.24,268.58
X$402 207 193 M3_M2_CDNS_40661956134276
* cell instance $403 r0 *1 60.24,268.58
X$403 207 193 M2_M1_CDNS_40661956134279
* cell instance $404 r0 *1 63.62,268.53
X$404 207 196 M3_M2_CDNS_40661956134278
* cell instance $405 r0 *1 63.62,268.865
X$405 207 196 M2_M1_CDNS_40661956134275
* cell instance $406 r0 *1 50.16,268.865
X$406 207 201 M2_M1_CDNS_40661956134275
* cell instance $407 r0 *1 50.16,268.53
X$407 207 201 M3_M2_CDNS_40661956134278
* cell instance $408 r0 *1 13.985,205.22
X$408 213 210 M3_M2_CDNS_40661956134292
* cell instance $409 r0 *1 13.79,205.22
X$409 213 210 M2_M1_CDNS_40661956134291
* cell instance $410 r0 *1 18.23,211.465
X$410 213 235 M2_M1_CDNS_40661956134240
* cell instance $411 r0 *1 18.23,211.465
X$411 213 235 M3_M2_CDNS_40661956134284
* cell instance $412 r0 *1 18.23,219.465
X$412 213 281 M2_M1_CDNS_40661956134240
* cell instance $413 r0 *1 18.23,219.465
X$413 213 281 M3_M2_CDNS_40661956134284
* cell instance $414 r0 *1 18.23,236.21
X$414 213 223 M2_M1_CDNS_40661956134289
* cell instance $415 r0 *1 18.23,236.175
X$415 213 223 M3_M2_CDNS_40661956134290
* cell instance $416 r0 *1 54.1,244.33
X$416 227 226 M2_M1_CDNS_40661956134281
* cell instance $417 r0 *1 54.1,244.175
X$417 227 226 M3_M2_CDNS_40661956134290
* cell instance $418 r0 *1 66.39,201.44
X$418 279 278 M2_M1_CDNS_40661956134267
* cell instance $419 r0 *1 66.415,201.44
X$419 279 278 M3_M2_CDNS_40661956134298
* device instance $1 r0 *1 5.945,268.14 pn_6p0
D$1 118 81 pn_6p0 A=1P P=4U
* device instance $2 r0 *1 12.19,268.14 pn_6p0
D$2 125 81 pn_6p0 A=1P P=4U
* device instance $3 r0 *1 5.945,272.64 pn_6p0
D$3 134 81 pn_6p0 A=1P P=4U
* device instance $4 r0 *1 12.19,272.64 pn_6p0
D$4 134 81 pn_6p0 A=1P P=4U
* device instance $5 r0 *1 57.79,206.315 pn_6p0
D$5 74 87 pn_6p0 A=1P P=4U
* device instance $6 r0 *1 57.79,208.635 pn_6p0
D$6 74 87 pn_6p0 A=1P P=4U
* device instance $7 r0 *1 38.8,283.195 nmoscap_6p0
C$7 4 141 1.725e-14 nmoscap_6p0 A=7.5P P=13U
* device instance $8 r0 *1 46.3,283.195 nmoscap_6p0
C$8 4 141 1.725e-14 nmoscap_6p0 A=7.5P P=13U
* device instance $9 r0 *1 68.8,283.195 nmoscap_6p0
C$9 4 141 1.725e-14 nmoscap_6p0 A=7.5P P=13U
* device instance $10 r0 *1 16.3,283.195 nmoscap_6p0
C$10 4 141 1.725e-14 nmoscap_6p0 A=7.5P P=13U
* device instance $11 r0 *1 31.3,283.195 nmoscap_6p0
C$11 4 141 1.725e-14 nmoscap_6p0 A=7.5P P=13U
* device instance $12 r0 *1 23.8,283.195 nmoscap_6p0
C$12 4 141 1.725e-14 nmoscap_6p0 A=7.5P P=13U
* device instance $13 r0 *1 53.8,283.195 nmoscap_6p0
C$13 4 141 1.725e-14 nmoscap_6p0 A=7.5P P=13U
* device instance $14 r0 *1 61.3,283.195 nmoscap_6p0
C$14 4 141 1.725e-14 nmoscap_6p0 A=7.5P P=13U
.ENDS GF_NI_IN_S_BASE

* cell 3LM_METAL_RAIL_PAD_60
* pin
* pin
* pin
* pin
* pin
* pin
* pin
* pin
.SUBCKT 3LM_METAL_RAIL_PAD_60 1 2 3 4 5 6 7 8
* cell instance $1 r0 *1 0,0
X$1 1 8 4 7 6 5 3LM_METAL_RAIL
* cell instance $2 r0 *1 5.5,0
X$2 3 2 Bondpad_3LM
.ENDS 3LM_METAL_RAIL_PAD_60

* cell M2_M1_CDNS_40661956134208
* pin
* pin
.SUBCKT M2_M1_CDNS_40661956134208 1 2
.ENDS M2_M1_CDNS_40661956134208

* cell M2_M1_CDNS_40661956134209
* pin
* pin
.SUBCKT M2_M1_CDNS_40661956134209 1 2
.ENDS M2_M1_CDNS_40661956134209

* cell M2_M1_CDNS_40661956134210
* pin
* pin
.SUBCKT M2_M1_CDNS_40661956134210 1 2
.ENDS M2_M1_CDNS_40661956134210

* cell M2_M1_CDNS_40661956134211
* pin
* pin
.SUBCKT M2_M1_CDNS_40661956134211 1 2
.ENDS M2_M1_CDNS_40661956134211

* cell M2_M1_CDNS_40661956134212
* pin
* pin
.SUBCKT M2_M1_CDNS_40661956134212 1 2
.ENDS M2_M1_CDNS_40661956134212

* cell M2_M1_CDNS_40661956134213
* pin
* pin
.SUBCKT M2_M1_CDNS_40661956134213 1 2
.ENDS M2_M1_CDNS_40661956134213

* cell M2_M1_CDNS_40661956134214
* pin
* pin
.SUBCKT M2_M1_CDNS_40661956134214 1 2
.ENDS M2_M1_CDNS_40661956134214

* cell M2_M1_CDNS_40661956134216
* pin
* pin
.SUBCKT M2_M1_CDNS_40661956134216 1 2
.ENDS M2_M1_CDNS_40661956134216

* cell M2_M1_CDNS_40661956134215
* pin
* pin
.SUBCKT M2_M1_CDNS_40661956134215 1 2
.ENDS M2_M1_CDNS_40661956134215

* cell M2_M1_CDNS_40661956134220
* pin
* pin
.SUBCKT M2_M1_CDNS_40661956134220 1 2
.ENDS M2_M1_CDNS_40661956134220

* cell M3_M2_CDNS_40661956134224
* pin
* pin
.SUBCKT M3_M2_CDNS_40661956134224 1 2
.ENDS M3_M2_CDNS_40661956134224

* cell comp018green_esd_clamp_v5p0_DVDD
* pin
* pin
* pin
* pin
* pin
* pin
* pin
* pin
* pin
* pin
* pin
* pin
* pin
* pin gf180mcu_gnd
.SUBCKT comp018green_esd_clamp_v5p0_DVDD 1 3 8 9 11 12 13 14 15 16 18 19 20 21
* net 21 gf180mcu_gnd
* cell instance $1 m90 *1 32.405,128.805
X$1 1 14 M2_M1_CDNS_40661956134232
* cell instance $2 r0 *1 0,0
X$2 6 3 1 8 25 9 18 16 15 14 13 12 11 24 19 20 21 nmos_clamp_20_50_4_DVDD
* cell instance $3 r0 *1 7.865,208.275
X$3 1 9 M2_M1_CDNS_40661956134235
* cell instance $4 m0 *1 -1.78,232.535
X$4 3 2 1 21 comp018green_esd_rc_v5p0
* cell instance $5 r0 *1 7.865,178.31
X$5 1 9 M2_M1_CDNS_40661956134239
* cell instance $6 r0 *1 7.865,147.855
X$6 1 9 M2_M1_CDNS_40661956134235
* cell instance $7 r0 *1 19.715,178.31
X$7 1 11 M2_M1_CDNS_40661956134239
* cell instance $8 r0 *1 19.715,147.855
X$8 1 11 M2_M1_CDNS_40661956134235
* cell instance $9 r0 *1 19.715,208.275
X$9 1 11 M2_M1_CDNS_40661956134235
* cell instance $10 r0 *1 32.405,208.275
X$10 1 14 M2_M1_CDNS_40661956134231
* cell instance $11 r0 *1 32.405,147.855
X$11 1 14 M2_M1_CDNS_40661956134231
* cell instance $12 r0 *1 32.405,178.31
X$12 1 14 M2_M1_CDNS_40661956134241
* cell instance $13 r0 *1 45.095,147.855
X$13 1 16 M2_M1_CDNS_40661956134235
* cell instance $14 r0 *1 45.095,208.275
X$14 1 16 M2_M1_CDNS_40661956134235
* cell instance $15 r0 *1 45.095,178.31
X$15 1 16 M2_M1_CDNS_40661956134239
* cell instance $16 r0 *1 56.945,208.275
X$16 1 19 M2_M1_CDNS_40661956134235
* cell instance $17 r0 *1 56.945,178.31
X$17 1 19 M2_M1_CDNS_40661956134239
* cell instance $18 r0 *1 56.945,147.855
X$18 1 19 M2_M1_CDNS_40661956134235
* cell instance $19 m90 *1 45.095,128.805
X$19 1 16 M2_M1_CDNS_40661956134237
* cell instance $20 m90 *1 19.715,137.29
X$20 1 11 M2_M1_CDNS_40661956134237
* cell instance $21 r0 *1 25.66,137.31
X$21 1 4 M1_PSUB_CDNS_40661956134243
* cell instance $22 m90 *1 31.935,137.29
X$22 1 14 M2_M1_CDNS_40661956134245
* cell instance $23 m90 *1 56.945,128.805
X$23 1 19 M2_M1_CDNS_40661956134237
* cell instance $24 m90 *1 19.715,128.805
X$24 1 11 M2_M1_CDNS_40661956134237
* cell instance $25 m90 *1 45.095,137.29
X$25 1 16 M2_M1_CDNS_40661956134237
* cell instance $26 r0 *1 42.775,137.31
X$26 1 4 M1_PSUB_CDNS_40661956134244
* cell instance $27 r0 *1 7.865,128.805
X$27 1 9 M2_M1_CDNS_40661956134237
* cell instance $28 r0 *1 20.645,130.03
X$28 1 5 2 21 nmos_6p0_CDNS_406619561347
* cell instance $29 m0 *1 53.32,132.61
X$29 1 4 M1_PSUB_CDNS_40661956134125
* cell instance $30 m0 *1 11.49,132.61
X$30 1 4 M1_PSUB_CDNS_40661956134125
* cell instance $31 r0 *1 33.275,130.03
X$31 23 1 6 1 6 1 6 1 7 7 7 7 7 7 nmos_6p0_CDNS_406619561346
* cell instance $32 r0 *1 25.955,130.03
X$32 23 1 7 1 7 1 7 1 5 5 5 5 5 5 nmos_6p0_CDNS_406619561346
* cell instance $33 r0 *1 20.71,135.54
X$33 2 M1_POLY2_CDNS_40661956134128
* cell instance $34 r0 *1 15.505,138.435
X$34 2 M1_POLY2_CDNS_40661956134127
* cell instance $35 r0 *1 13.325,139.585
X$35 22 5 3 5 3 3 2 2 2 2 17 3 pmos_6p0_CDNS_406619561344
* cell instance $36 r0 *1 22.725,139.585
X$36 3 6 3 6 3 6 3 6 3 6 3 6 3 6 3 6 3 6 3 6 3 6 3 6 3 7 7 7 7 7 7 7 7 7 7 7 7
+ 7 7 7 7 7 7 7 7 7 7 7 7 3 17 pmos_6p0_CDNS_406619561342
* cell instance $37 r0 *1 18.205,139.585
X$37 22 7 3 3 7 5 5 5 17 3 pmos_6p0_CDNS_406619561343
* cell instance $38 r0 *1 13.065,142.635
X$38 3 12 M2_M1_CDNS_40661956134242
* cell instance $39 r0 *1 11.49,142.235
X$39 3 10 17 3 M1_NWELL_CDNS_40661956134133
* cell instance $40 r0 *1 11.51,142.555
X$40 3 12 M2_M1_CDNS_40661956134240
* cell instance $41 r0 *1 32.405,145.825
X$41 3 10 17 3 M1_NWELL_CDNS_40661956134129
* cell instance $42 r0 *1 15.505,142.635
X$42 3 12 M2_M1_CDNS_40661956134242
* cell instance $43 r0 *1 17.945,142.635
X$43 3 12 M2_M1_CDNS_40661956134242
* cell instance $44 r0 *1 22.465,142.635
X$44 3 13 M2_M1_CDNS_40661956134242
* cell instance $45 r0 *1 24.905,142.635
X$45 3 13 M2_M1_CDNS_40661956134242
* cell instance $46 r0 *1 27.345,142.635
X$46 3 13 M2_M1_CDNS_40661956134242
* cell instance $47 r0 *1 29.785,142.635
X$47 3 13 M2_M1_CDNS_40661956134242
* cell instance $48 r0 *1 34.665,142.635
X$48 3 15 M2_M1_CDNS_40661956134242
* cell instance $49 r0 *1 37.105,142.635
X$49 3 15 M2_M1_CDNS_40661956134242
* cell instance $50 r0 *1 39.545,142.635
X$50 3 15 M2_M1_CDNS_40661956134242
* cell instance $51 r0 *1 41.985,142.635
X$51 3 15 M2_M1_CDNS_40661956134242
* cell instance $52 r0 *1 46.865,142.635
X$52 3 18 M2_M1_CDNS_40661956134242
* cell instance $53 r0 *1 49.305,142.635
X$53 3 18 M2_M1_CDNS_40661956134242
* cell instance $54 r0 *1 51.745,142.635
X$54 3 18 M2_M1_CDNS_40661956134242
* cell instance $55 r0 *1 53.3,142.635
X$55 3 18 M2_M1_CDNS_40661956134242
* cell instance $56 r0 *1 53.32,142.235
X$56 3 10 17 3 M1_NWELL_CDNS_40661956134133
* cell instance $57 r0 *1 -1.415,220.08
X$57 3 8 M2_M1_CDNS_40661956134236
* cell instance $58 r0 *1 2.47,229.44
X$58 3 8 M2_M1_CDNS_40661956134234
* cell instance $59 r0 *1 3.225,210.74
X$59 3 8 M2_M1_CDNS_40661956134233
* cell instance $60 r0 *1 13.79,210.74
X$60 3 12 M2_M1_CDNS_40661956134238
* cell instance $61 r0 *1 13.79,229.44
X$61 3 12 M2_M1_CDNS_40661956134238
* cell instance $62 r0 *1 25.64,210.74
X$62 3 13 M2_M1_CDNS_40661956134238
* cell instance $63 r0 *1 25.64,229.44
X$63 3 13 M2_M1_CDNS_40661956134238
* cell instance $64 r0 *1 39.17,210.74
X$64 3 15 M2_M1_CDNS_40661956134238
* cell instance $65 r0 *1 39.17,229.44
X$65 3 15 M2_M1_CDNS_40661956134238
* cell instance $66 r0 *1 51.02,229.44
X$66 3 18 M2_M1_CDNS_40661956134238
* cell instance $67 r0 *1 51.02,210.74
X$67 3 18 M2_M1_CDNS_40661956134238
* cell instance $68 r0 *1 62.405,210.74
X$68 3 20 M2_M1_CDNS_40661956134234
* cell instance $69 r0 *1 62.405,229.44
X$69 3 20 M2_M1_CDNS_40661956134234
* cell instance $70 r0 *1 66.225,220.08
X$70 3 20 M2_M1_CDNS_40661956134236
* cell instance $71 r0 *1 29.355,136.18
X$71 5 M1_POLY2_CDNS_40661956134131
* cell instance $72 r0 *1 19.775,138.435
X$72 5 M1_POLY2_CDNS_40661956134130
* cell instance $73 r0 *1 6.565,127.585
X$73 6 25 M2_M1_CDNS_40661956134126
* cell instance $74 r0 *1 58.245,127.585
X$74 6 24 M2_M1_CDNS_40661956134126
* cell instance $75 r0 *1 36.675,136.18
X$75 7 M1_POLY2_CDNS_40661956134131
* cell instance $76 r0 *1 37.105,138.435
X$76 7 M1_POLY2_CDNS_40661956134132
* device instance $1 r0 *1 13.675,142.085 pmos_6p0
M$1 5 2 3 3 pmos_6p0 L=0.7U W=5U AS=2.2P AD=1.3P PS=10.88U PD=5.52U
* device instance $2 r0 *1 14.895,142.085 pmos_6p0
M$2 3 2 5 3 pmos_6p0 L=0.7U W=5U AS=1.3P AD=1.3P PS=5.52U PD=5.52U
* device instance $3 r0 *1 16.115,142.085 pmos_6p0
M$3 5 2 3 3 pmos_6p0 L=0.7U W=5U AS=1.3P AD=1.3P PS=5.52U PD=5.52U
* device instance $4 r0 *1 17.335,142.085 pmos_6p0
M$4 3 2 5 3 pmos_6p0 L=0.7U W=5U AS=1.3P AD=1.3P PS=5.52U PD=5.52U
* device instance $5 r0 *1 18.555,142.085 pmos_6p0
M$5 7 5 3 3 pmos_6p0 L=0.7U W=5U AS=1.3P AD=1.3P PS=5.52U PD=5.52U
* device instance $6 r0 *1 19.775,142.085 pmos_6p0
M$6 3 5 7 3 pmos_6p0 L=0.7U W=5U AS=1.3P AD=1.3P PS=5.52U PD=5.52U
* device instance $7 r0 *1 20.995,142.085 pmos_6p0
M$7 7 5 3 3 pmos_6p0 L=0.7U W=5U AS=1.3P AD=2.2P PS=5.52U PD=10.88U
* device instance $8 r0 *1 23.075,142.085 pmos_6p0
M$8 6 7 3 3 pmos_6p0 L=0.7U W=5U AS=2.2P AD=1.3P PS=10.88U PD=5.52U
* device instance $9 r0 *1 24.295,142.085 pmos_6p0
M$9 3 7 6 3 pmos_6p0 L=0.7U W=5U AS=1.3P AD=1.3P PS=5.52U PD=5.52U
* device instance $10 r0 *1 25.515,142.085 pmos_6p0
M$10 6 7 3 3 pmos_6p0 L=0.7U W=5U AS=1.3P AD=1.3P PS=5.52U PD=5.52U
* device instance $11 r0 *1 26.735,142.085 pmos_6p0
M$11 3 7 6 3 pmos_6p0 L=0.7U W=5U AS=1.3P AD=1.3P PS=5.52U PD=5.52U
* device instance $12 r0 *1 27.955,142.085 pmos_6p0
M$12 6 7 3 3 pmos_6p0 L=0.7U W=5U AS=1.3P AD=1.3P PS=5.52U PD=5.52U
* device instance $13 r0 *1 29.175,142.085 pmos_6p0
M$13 3 7 6 3 pmos_6p0 L=0.7U W=5U AS=1.3P AD=1.3P PS=5.52U PD=5.52U
* device instance $14 r0 *1 30.395,142.085 pmos_6p0
M$14 6 7 3 3 pmos_6p0 L=0.7U W=5U AS=1.3P AD=1.3P PS=5.52U PD=5.52U
* device instance $15 r0 *1 31.615,142.085 pmos_6p0
M$15 3 7 6 3 pmos_6p0 L=0.7U W=5U AS=1.3P AD=1.3P PS=5.52U PD=5.52U
* device instance $16 r0 *1 32.835,142.085 pmos_6p0
M$16 6 7 3 3 pmos_6p0 L=0.7U W=5U AS=1.3P AD=1.3P PS=5.52U PD=5.52U
* device instance $17 r0 *1 34.055,142.085 pmos_6p0
M$17 3 7 6 3 pmos_6p0 L=0.7U W=5U AS=1.3P AD=1.3P PS=5.52U PD=5.52U
* device instance $18 r0 *1 35.275,142.085 pmos_6p0
M$18 6 7 3 3 pmos_6p0 L=0.7U W=5U AS=1.3P AD=1.3P PS=5.52U PD=5.52U
* device instance $19 r0 *1 36.495,142.085 pmos_6p0
M$19 3 7 6 3 pmos_6p0 L=0.7U W=5U AS=1.3P AD=1.3P PS=5.52U PD=5.52U
* device instance $20 r0 *1 37.715,142.085 pmos_6p0
M$20 6 7 3 3 pmos_6p0 L=0.7U W=5U AS=1.3P AD=1.3P PS=5.52U PD=5.52U
* device instance $21 r0 *1 38.935,142.085 pmos_6p0
M$21 3 7 6 3 pmos_6p0 L=0.7U W=5U AS=1.3P AD=1.3P PS=5.52U PD=5.52U
* device instance $22 r0 *1 40.155,142.085 pmos_6p0
M$22 6 7 3 3 pmos_6p0 L=0.7U W=5U AS=1.3P AD=1.3P PS=5.52U PD=5.52U
* device instance $23 r0 *1 41.375,142.085 pmos_6p0
M$23 3 7 6 3 pmos_6p0 L=0.7U W=5U AS=1.3P AD=1.3P PS=5.52U PD=5.52U
* device instance $24 r0 *1 42.595,142.085 pmos_6p0
M$24 6 7 3 3 pmos_6p0 L=0.7U W=5U AS=1.3P AD=1.3P PS=5.52U PD=5.52U
* device instance $25 r0 *1 43.815,142.085 pmos_6p0
M$25 3 7 6 3 pmos_6p0 L=0.7U W=5U AS=1.3P AD=1.3P PS=5.52U PD=5.52U
* device instance $26 r0 *1 45.035,142.085 pmos_6p0
M$26 6 7 3 3 pmos_6p0 L=0.7U W=5U AS=1.3P AD=1.3P PS=5.52U PD=5.52U
* device instance $27 r0 *1 46.255,142.085 pmos_6p0
M$27 3 7 6 3 pmos_6p0 L=0.7U W=5U AS=1.3P AD=1.3P PS=5.52U PD=5.52U
* device instance $28 r0 *1 47.475,142.085 pmos_6p0
M$28 6 7 3 3 pmos_6p0 L=0.7U W=5U AS=1.3P AD=1.3P PS=5.52U PD=5.52U
* device instance $29 r0 *1 48.695,142.085 pmos_6p0
M$29 3 7 6 3 pmos_6p0 L=0.7U W=5U AS=1.3P AD=1.3P PS=5.52U PD=5.52U
* device instance $30 r0 *1 49.915,142.085 pmos_6p0
M$30 6 7 3 3 pmos_6p0 L=0.7U W=5U AS=1.3P AD=1.3P PS=5.52U PD=5.52U
* device instance $31 r0 *1 51.135,142.085 pmos_6p0
M$31 3 7 6 3 pmos_6p0 L=0.7U W=5U AS=1.3P AD=2.2P PS=5.52U PD=10.88U
* device instance $32 r0 *1 26.305,132.53 nmos_6p0
M$32 7 5 1 21 nmos_6p0 L=0.7U W=5U AS=2.2P AD=1.3P PS=10.88U PD=5.52U
* device instance $33 r0 *1 27.525,132.53 nmos_6p0
M$33 1 5 7 21 nmos_6p0 L=0.7U W=5U AS=1.3P AD=1.3P PS=5.52U PD=5.52U
* device instance $34 r0 *1 28.745,132.53 nmos_6p0
M$34 7 5 1 21 nmos_6p0 L=0.7U W=5U AS=1.3P AD=1.3P PS=5.52U PD=5.52U
* device instance $35 r0 *1 29.965,132.53 nmos_6p0
M$35 1 5 7 21 nmos_6p0 L=0.7U W=5U AS=1.3P AD=1.3P PS=5.52U PD=5.52U
* device instance $36 r0 *1 31.185,132.53 nmos_6p0
M$36 7 5 1 21 nmos_6p0 L=0.7U W=5U AS=1.3P AD=1.3P PS=5.52U PD=5.52U
* device instance $37 r0 *1 32.405,132.53 nmos_6p0
M$37 1 5 7 21 nmos_6p0 L=0.7U W=5U AS=1.3P AD=1.3P PS=5.52U PD=5.52U
* device instance $38 r0 *1 33.625,132.53 nmos_6p0
M$38 6 7 1 21 nmos_6p0 L=0.7U W=5U AS=1.3P AD=1.3P PS=5.52U PD=5.52U
* device instance $39 r0 *1 34.845,132.53 nmos_6p0
M$39 1 7 6 21 nmos_6p0 L=0.7U W=5U AS=1.3P AD=1.3P PS=5.52U PD=5.52U
* device instance $40 r0 *1 36.065,132.53 nmos_6p0
M$40 6 7 1 21 nmos_6p0 L=0.7U W=5U AS=1.3P AD=1.3P PS=5.52U PD=5.52U
* device instance $41 r0 *1 37.285,132.53 nmos_6p0
M$41 1 7 6 21 nmos_6p0 L=0.7U W=5U AS=1.3P AD=1.3P PS=5.52U PD=5.52U
* device instance $42 r0 *1 38.505,132.53 nmos_6p0
M$42 6 7 1 21 nmos_6p0 L=0.7U W=5U AS=1.3P AD=1.3P PS=5.52U PD=5.52U
* device instance $43 r0 *1 39.725,132.53 nmos_6p0
M$43 1 7 6 21 nmos_6p0 L=0.7U W=5U AS=1.3P AD=2.2P PS=5.52U PD=10.88U
.ENDS comp018green_esd_clamp_v5p0_DVDD

* cell M3_M2_CDNS_40661956134219
* pin
* pin
.SUBCKT M3_M2_CDNS_40661956134219 1 2
.ENDS M3_M2_CDNS_40661956134219

* cell M2_M1_CDNS_40661956134261
* pin
* pin
.SUBCKT M2_M1_CDNS_40661956134261 1 2
.ENDS M2_M1_CDNS_40661956134261

* cell M2_M1_CDNS_40661956134263
* pin
* pin
.SUBCKT M2_M1_CDNS_40661956134263 1 2
.ENDS M2_M1_CDNS_40661956134263

* cell M2_M1_CDNS_40661956134264
* pin
* pin
.SUBCKT M2_M1_CDNS_40661956134264 1 2
.ENDS M2_M1_CDNS_40661956134264

* cell M3_M2_CDNS_40661956134226
* pin
* pin
.SUBCKT M3_M2_CDNS_40661956134226 1 2
.ENDS M3_M2_CDNS_40661956134226

* cell M2_M1_CDNS_40661956134251
* pin
* pin
.SUBCKT M2_M1_CDNS_40661956134251 1 2
.ENDS M2_M1_CDNS_40661956134251

* cell M2_M1_CDNS_40661956134252
* pin
* pin
.SUBCKT M2_M1_CDNS_40661956134252 1 2
.ENDS M2_M1_CDNS_40661956134252

* cell M2_M1_CDNS_40661956134253
* pin
* pin
.SUBCKT M2_M1_CDNS_40661956134253 1 2
.ENDS M2_M1_CDNS_40661956134253

* cell M2_M1_CDNS_40661956134254
* pin
* pin
.SUBCKT M2_M1_CDNS_40661956134254 1 2
.ENDS M2_M1_CDNS_40661956134254

* cell M2_M1_CDNS_40661956134256
* pin
* pin
.SUBCKT M2_M1_CDNS_40661956134256 1 2
.ENDS M2_M1_CDNS_40661956134256

* cell M2_M1_CDNS_40661956134258
* pin
* pin
.SUBCKT M2_M1_CDNS_40661956134258 1 2
.ENDS M2_M1_CDNS_40661956134258

* cell M1_PSUB_CDNS_40661956134197
* pin
* pin
.SUBCKT M1_PSUB_CDNS_40661956134197 1 2
.ENDS M1_PSUB_CDNS_40661956134197

* cell M3_M2_CDNS_40661956134262
* pin
* pin
.SUBCKT M3_M2_CDNS_40661956134262 1 2
.ENDS M3_M2_CDNS_40661956134262

* cell M3_M2_CDNS_40661956134260
* pin
* pin
.SUBCKT M3_M2_CDNS_40661956134260 1 2
.ENDS M3_M2_CDNS_40661956134260

* cell M3_M2_CDNS_40661956134259
* pin
* pin
.SUBCKT M3_M2_CDNS_40661956134259 1 2
.ENDS M3_M2_CDNS_40661956134259

* cell M3_M2_CDNS_40661956134257
* pin
* pin
.SUBCKT M3_M2_CDNS_40661956134257 1 2
.ENDS M3_M2_CDNS_40661956134257

* cell M1_PSUB_CDNS_40661956134230
* pin
.SUBCKT M1_PSUB_CDNS_40661956134230 1
.ENDS M1_PSUB_CDNS_40661956134230

* cell M1_PSUB_CDNS_40661956134203
* pin
* pin
.SUBCKT M1_PSUB_CDNS_40661956134203 1 2
.ENDS M1_PSUB_CDNS_40661956134203

* cell M1_NWELL_CDNS_40661956134204
* pin
* pin
* pin
* pin
.SUBCKT M1_NWELL_CDNS_40661956134204 1 2 3 4
.ENDS M1_NWELL_CDNS_40661956134204

* cell M3_M2_CDNS_40661956134221
* pin
* pin
.SUBCKT M3_M2_CDNS_40661956134221 1 2
.ENDS M3_M2_CDNS_40661956134221

* cell M3_M2_CDNS_40661956134222
* pin
* pin
.SUBCKT M3_M2_CDNS_40661956134222 1 2
.ENDS M3_M2_CDNS_40661956134222

* cell M1_PSUB_CDNS_40661956134198
* pin
* pin
.SUBCKT M1_PSUB_CDNS_40661956134198 1 2
.ENDS M1_PSUB_CDNS_40661956134198

* cell M1_PSUB_CDNS_40661956134200
* pin
* pin
.SUBCKT M1_PSUB_CDNS_40661956134200 1 2
.ENDS M1_PSUB_CDNS_40661956134200

* cell M1_PSUB_CDNS_40661956134201
* pin
* pin
.SUBCKT M1_PSUB_CDNS_40661956134201 1 2
.ENDS M1_PSUB_CDNS_40661956134201

* cell M1_PSUB_CDNS_40661956134202
* pin
* pin
.SUBCKT M1_PSUB_CDNS_40661956134202 1 2
.ENDS M1_PSUB_CDNS_40661956134202

* cell M1_NWELL_CDNS_40661956134205
* pin
* pin
* pin
* pin
.SUBCKT M1_NWELL_CDNS_40661956134205 1 2 3 4
.ENDS M1_NWELL_CDNS_40661956134205

* cell M3_M2_CDNS_40661956134223
* pin
* pin
.SUBCKT M3_M2_CDNS_40661956134223 1 2
.ENDS M3_M2_CDNS_40661956134223

* cell M3_M2_CDNS_40661956134225
* pin
* pin
.SUBCKT M3_M2_CDNS_40661956134225 1 2
.ENDS M3_M2_CDNS_40661956134225

* cell M3_M2_CDNS_40661956134227
* pin
* pin
.SUBCKT M3_M2_CDNS_40661956134227 1 2
.ENDS M3_M2_CDNS_40661956134227

* cell M1_PSUB_CDNS_40661956134228
* pin
.SUBCKT M1_PSUB_CDNS_40661956134228 1
.ENDS M1_PSUB_CDNS_40661956134228

* cell M1_PSUB_CDNS_40661956134229
* pin
.SUBCKT M1_PSUB_CDNS_40661956134229 1
.ENDS M1_PSUB_CDNS_40661956134229

* cell nmoscap_6p0_CDNS_406619561348
* pin
* pin
.SUBCKT nmoscap_6p0_CDNS_406619561348 1 2
* device instance $1 r0 *1 7.5,7.5 nmoscap_6p0
C$1 2 1 5.175e-13 nmoscap_6p0 A=225P P=60U
.ENDS nmoscap_6p0_CDNS_406619561348

* cell np_6p0_CDNS_406619561349
* pin
.SUBCKT np_6p0_CDNS_406619561349 1
.ENDS np_6p0_CDNS_406619561349

* cell comp018green_esd_clamp_v5p0_DVSS
* pin
* pin
* pin
* pin
* pin
* pin
* pin
* pin
* pin
* pin
* pin
* pin
* pin
* pin gf180mcu_gnd
.SUBCKT comp018green_esd_clamp_v5p0_DVSS 1 3 8 9 11 12 13 14 15 16 18 19 20 21
* net 21 gf180mcu_gnd
* cell instance $1 r0 *1 0,0
X$1 6 3 1 8 25 9 18 16 15 14 13 12 11 24 19 20 21 nmos_clamp_20_50_4_DVSS
* cell instance $2 r0 *1 14.89,128.765
X$2 1 12 M2_M1_CDNS_40661956134265
* cell instance $3 m90 *1 49.92,128.765
X$3 1 18 M2_M1_CDNS_40661956134265
* cell instance $4 r0 *1 25.64,128.765
X$4 1 13 M2_M1_CDNS_40661956134238
* cell instance $5 r0 *1 25.64,137.29
X$5 1 13 M2_M1_CDNS_40661956134238
* cell instance $6 r0 *1 25.67,137.31
X$6 1 4 M1_PSUB_CDNS_40661956134243
* cell instance $7 r0 *1 42.025,128.765
X$7 1 15 M2_M1_CDNS_40661956134233
* cell instance $8 m90 *1 53.3,132.785
X$8 1 18 M2_M1_CDNS_40661956134242
* cell instance $9 m0 *1 53.32,132.61
X$9 1 4 M1_PSUB_CDNS_40661956134125
* cell instance $10 r0 *1 11.51,132.785
X$10 1 12 M2_M1_CDNS_40661956134242
* cell instance $11 m0 *1 11.49,132.61
X$11 1 4 M1_PSUB_CDNS_40661956134125
* cell instance $12 r0 *1 42.785,137.31
X$12 1 4 M1_PSUB_CDNS_40661956134244
* cell instance $13 r0 *1 39.17,137.29
X$13 1 15 M2_M1_CDNS_40661956134238
* cell instance $14 r0 *1 48.65,137.29
X$14 1 18 M2_M1_CDNS_40661956134267
* cell instance $15 r0 *1 37.89,128.765
X$15 1 15 M2_M1_CDNS_40661956134245
* cell instance $16 r0 *1 35.445,128.765
X$16 1 15 M2_M1_CDNS_40661956134245
* cell instance $17 r0 *1 20.645,130.03
X$17 1 5 2 21 nmos_6p0_CDNS_406619561347
* cell instance $18 r0 *1 33.275,130.03
X$18 23 1 6 1 6 1 6 1 7 7 7 7 7 7 nmos_6p0_CDNS_406619561346
* cell instance $19 r0 *1 25.955,130.03
X$19 23 1 7 1 7 1 7 1 5 5 5 5 5 5 nmos_6p0_CDNS_406619561346
* cell instance $20 r0 *1 13.79,208.275
X$20 1 12 M2_M1_CDNS_40661956134255
* cell instance $21 m0 *1 -1.78,232.535
X$21 3 2 1 21 comp018green_esd_rc_v5p0
* cell instance $22 r0 *1 13.79,147.855
X$22 1 12 M2_M1_CDNS_40661956134255
* cell instance $23 r0 *1 13.79,178.31
X$23 1 12 M2_M1_CDNS_40661956134266
* cell instance $24 r0 *1 25.64,208.275
X$24 1 13 M2_M1_CDNS_40661956134255
* cell instance $25 r0 *1 25.64,147.855
X$25 1 13 M2_M1_CDNS_40661956134255
* cell instance $26 r0 *1 25.64,178.31
X$26 1 13 M2_M1_CDNS_40661956134266
* cell instance $27 r0 *1 39.17,208.275
X$27 1 15 M2_M1_CDNS_40661956134255
* cell instance $28 r0 *1 39.17,147.855
X$28 1 15 M2_M1_CDNS_40661956134255
* cell instance $29 r0 *1 39.17,178.31
X$29 1 15 M2_M1_CDNS_40661956134266
* cell instance $30 r0 *1 51.02,147.855
X$30 1 18 M2_M1_CDNS_40661956134255
* cell instance $31 r0 *1 51.02,208.275
X$31 1 18 M2_M1_CDNS_40661956134255
* cell instance $32 r0 *1 51.02,178.31
X$32 1 18 M2_M1_CDNS_40661956134266
* cell instance $33 r0 *1 20.71,135.54
X$33 2 M1_POLY2_CDNS_40661956134128
* cell instance $34 r0 *1 15.505,138.435
X$34 2 M1_POLY2_CDNS_40661956134127
* cell instance $35 r0 *1 13.325,139.585
X$35 22 5 3 5 3 3 2 2 2 2 17 3 pmos_6p0_CDNS_406619561344
* cell instance $36 m90 *1 56.945,145.805
X$36 3 19 M2_M1_CDNS_40661956134237
* cell instance $37 m90 *1 19.715,145.805
X$37 3 11 M2_M1_CDNS_40661956134237
* cell instance $38 r0 *1 32.405,145.825
X$38 3 10 17 3 M1_NWELL_CDNS_40661956134129
* cell instance $39 m90 *1 32.405,145.805
X$39 3 14 M2_M1_CDNS_40661956134232
* cell instance $40 m90 *1 45.095,145.805
X$40 3 16 M2_M1_CDNS_40661956134237
* cell instance $41 r0 *1 7.865,145.805
X$41 3 9 M2_M1_CDNS_40661956134237
* cell instance $42 r0 *1 53.32,142.235
X$42 3 10 17 3 M1_NWELL_CDNS_40661956134133
* cell instance $43 r0 *1 11.49,142.235
X$43 3 10 17 3 M1_NWELL_CDNS_40661956134133
* cell instance $44 r0 *1 22.725,139.585
X$44 3 6 3 6 3 6 3 6 3 6 3 6 3 6 3 6 3 6 3 6 3 6 3 6 3 7 7 7 7 7 7 7 7 7 7 7 7
+ 7 7 7 7 7 7 7 7 7 7 7 7 3 17 pmos_6p0_CDNS_406619561342
* cell instance $45 r0 *1 18.205,139.585
X$45 22 7 3 3 7 5 5 5 17 3 pmos_6p0_CDNS_406619561343
* cell instance $46 r0 *1 7.865,210.74
X$46 3 9 M2_M1_CDNS_40661956134218
* cell instance $47 r0 *1 7.865,229.44
X$47 3 9 M2_M1_CDNS_40661956134218
* cell instance $48 r0 *1 19.715,210.74
X$48 3 11 M2_M1_CDNS_40661956134218
* cell instance $49 r0 *1 19.715,229.44
X$49 3 11 M2_M1_CDNS_40661956134218
* cell instance $50 r0 *1 32.405,210.74
X$50 3 14 M2_M1_CDNS_40661956134217
* cell instance $51 r0 *1 32.405,229.44
X$51 3 14 M2_M1_CDNS_40661956134217
* cell instance $52 r0 *1 45.095,210.74
X$52 3 16 M2_M1_CDNS_40661956134218
* cell instance $53 r0 *1 45.095,229.44
X$53 3 16 M2_M1_CDNS_40661956134218
* cell instance $54 r0 *1 56.945,210.74
X$54 3 19 M2_M1_CDNS_40661956134218
* cell instance $55 r0 *1 56.945,229.44
X$55 3 19 M2_M1_CDNS_40661956134218
* cell instance $56 r0 *1 29.355,136.18
X$56 5 M1_POLY2_CDNS_40661956134131
* cell instance $57 r0 *1 19.775,138.435
X$57 5 M1_POLY2_CDNS_40661956134130
* cell instance $58 r0 *1 6.565,127.585
X$58 6 25 M2_M1_CDNS_40661956134126
* cell instance $59 r0 *1 58.245,127.585
X$59 6 24 M2_M1_CDNS_40661956134126
* cell instance $60 r0 *1 36.675,136.18
X$60 7 M1_POLY2_CDNS_40661956134131
* cell instance $61 r0 *1 37.105,138.435
X$61 7 M1_POLY2_CDNS_40661956134132
* device instance $1 r0 *1 13.675,142.085 pmos_6p0
M$1 5 2 3 3 pmos_6p0 L=0.7U W=5U AS=2.2P AD=1.3P PS=10.88U PD=5.52U
* device instance $2 r0 *1 14.895,142.085 pmos_6p0
M$2 3 2 5 3 pmos_6p0 L=0.7U W=5U AS=1.3P AD=1.3P PS=5.52U PD=5.52U
* device instance $3 r0 *1 16.115,142.085 pmos_6p0
M$3 5 2 3 3 pmos_6p0 L=0.7U W=5U AS=1.3P AD=1.3P PS=5.52U PD=5.52U
* device instance $4 r0 *1 17.335,142.085 pmos_6p0
M$4 3 2 5 3 pmos_6p0 L=0.7U W=5U AS=1.3P AD=1.3P PS=5.52U PD=5.52U
* device instance $5 r0 *1 18.555,142.085 pmos_6p0
M$5 7 5 3 3 pmos_6p0 L=0.7U W=5U AS=1.3P AD=1.3P PS=5.52U PD=5.52U
* device instance $6 r0 *1 19.775,142.085 pmos_6p0
M$6 3 5 7 3 pmos_6p0 L=0.7U W=5U AS=1.3P AD=1.3P PS=5.52U PD=5.52U
* device instance $7 r0 *1 20.995,142.085 pmos_6p0
M$7 7 5 3 3 pmos_6p0 L=0.7U W=5U AS=1.3P AD=2.2P PS=5.52U PD=10.88U
* device instance $8 r0 *1 23.075,142.085 pmos_6p0
M$8 6 7 3 3 pmos_6p0 L=0.7U W=5U AS=2.2P AD=1.3P PS=10.88U PD=5.52U
* device instance $9 r0 *1 24.295,142.085 pmos_6p0
M$9 3 7 6 3 pmos_6p0 L=0.7U W=5U AS=1.3P AD=1.3P PS=5.52U PD=5.52U
* device instance $10 r0 *1 25.515,142.085 pmos_6p0
M$10 6 7 3 3 pmos_6p0 L=0.7U W=5U AS=1.3P AD=1.3P PS=5.52U PD=5.52U
* device instance $11 r0 *1 26.735,142.085 pmos_6p0
M$11 3 7 6 3 pmos_6p0 L=0.7U W=5U AS=1.3P AD=1.3P PS=5.52U PD=5.52U
* device instance $12 r0 *1 27.955,142.085 pmos_6p0
M$12 6 7 3 3 pmos_6p0 L=0.7U W=5U AS=1.3P AD=1.3P PS=5.52U PD=5.52U
* device instance $13 r0 *1 29.175,142.085 pmos_6p0
M$13 3 7 6 3 pmos_6p0 L=0.7U W=5U AS=1.3P AD=1.3P PS=5.52U PD=5.52U
* device instance $14 r0 *1 30.395,142.085 pmos_6p0
M$14 6 7 3 3 pmos_6p0 L=0.7U W=5U AS=1.3P AD=1.3P PS=5.52U PD=5.52U
* device instance $15 r0 *1 31.615,142.085 pmos_6p0
M$15 3 7 6 3 pmos_6p0 L=0.7U W=5U AS=1.3P AD=1.3P PS=5.52U PD=5.52U
* device instance $16 r0 *1 32.835,142.085 pmos_6p0
M$16 6 7 3 3 pmos_6p0 L=0.7U W=5U AS=1.3P AD=1.3P PS=5.52U PD=5.52U
* device instance $17 r0 *1 34.055,142.085 pmos_6p0
M$17 3 7 6 3 pmos_6p0 L=0.7U W=5U AS=1.3P AD=1.3P PS=5.52U PD=5.52U
* device instance $18 r0 *1 35.275,142.085 pmos_6p0
M$18 6 7 3 3 pmos_6p0 L=0.7U W=5U AS=1.3P AD=1.3P PS=5.52U PD=5.52U
* device instance $19 r0 *1 36.495,142.085 pmos_6p0
M$19 3 7 6 3 pmos_6p0 L=0.7U W=5U AS=1.3P AD=1.3P PS=5.52U PD=5.52U
* device instance $20 r0 *1 37.715,142.085 pmos_6p0
M$20 6 7 3 3 pmos_6p0 L=0.7U W=5U AS=1.3P AD=1.3P PS=5.52U PD=5.52U
* device instance $21 r0 *1 38.935,142.085 pmos_6p0
M$21 3 7 6 3 pmos_6p0 L=0.7U W=5U AS=1.3P AD=1.3P PS=5.52U PD=5.52U
* device instance $22 r0 *1 40.155,142.085 pmos_6p0
M$22 6 7 3 3 pmos_6p0 L=0.7U W=5U AS=1.3P AD=1.3P PS=5.52U PD=5.52U
* device instance $23 r0 *1 41.375,142.085 pmos_6p0
M$23 3 7 6 3 pmos_6p0 L=0.7U W=5U AS=1.3P AD=1.3P PS=5.52U PD=5.52U
* device instance $24 r0 *1 42.595,142.085 pmos_6p0
M$24 6 7 3 3 pmos_6p0 L=0.7U W=5U AS=1.3P AD=1.3P PS=5.52U PD=5.52U
* device instance $25 r0 *1 43.815,142.085 pmos_6p0
M$25 3 7 6 3 pmos_6p0 L=0.7U W=5U AS=1.3P AD=1.3P PS=5.52U PD=5.52U
* device instance $26 r0 *1 45.035,142.085 pmos_6p0
M$26 6 7 3 3 pmos_6p0 L=0.7U W=5U AS=1.3P AD=1.3P PS=5.52U PD=5.52U
* device instance $27 r0 *1 46.255,142.085 pmos_6p0
M$27 3 7 6 3 pmos_6p0 L=0.7U W=5U AS=1.3P AD=1.3P PS=5.52U PD=5.52U
* device instance $28 r0 *1 47.475,142.085 pmos_6p0
M$28 6 7 3 3 pmos_6p0 L=0.7U W=5U AS=1.3P AD=1.3P PS=5.52U PD=5.52U
* device instance $29 r0 *1 48.695,142.085 pmos_6p0
M$29 3 7 6 3 pmos_6p0 L=0.7U W=5U AS=1.3P AD=1.3P PS=5.52U PD=5.52U
* device instance $30 r0 *1 49.915,142.085 pmos_6p0
M$30 6 7 3 3 pmos_6p0 L=0.7U W=5U AS=1.3P AD=1.3P PS=5.52U PD=5.52U
* device instance $31 r0 *1 51.135,142.085 pmos_6p0
M$31 3 7 6 3 pmos_6p0 L=0.7U W=5U AS=1.3P AD=2.2P PS=5.52U PD=10.88U
* device instance $32 r0 *1 26.305,132.53 nmos_6p0
M$32 7 5 1 21 nmos_6p0 L=0.7U W=5U AS=2.2P AD=1.3P PS=10.88U PD=5.52U
* device instance $33 r0 *1 27.525,132.53 nmos_6p0
M$33 1 5 7 21 nmos_6p0 L=0.7U W=5U AS=1.3P AD=1.3P PS=5.52U PD=5.52U
* device instance $34 r0 *1 28.745,132.53 nmos_6p0
M$34 7 5 1 21 nmos_6p0 L=0.7U W=5U AS=1.3P AD=1.3P PS=5.52U PD=5.52U
* device instance $35 r0 *1 29.965,132.53 nmos_6p0
M$35 1 5 7 21 nmos_6p0 L=0.7U W=5U AS=1.3P AD=1.3P PS=5.52U PD=5.52U
* device instance $36 r0 *1 31.185,132.53 nmos_6p0
M$36 7 5 1 21 nmos_6p0 L=0.7U W=5U AS=1.3P AD=1.3P PS=5.52U PD=5.52U
* device instance $37 r0 *1 32.405,132.53 nmos_6p0
M$37 1 5 7 21 nmos_6p0 L=0.7U W=5U AS=1.3P AD=1.3P PS=5.52U PD=5.52U
* device instance $38 r0 *1 33.625,132.53 nmos_6p0
M$38 6 7 1 21 nmos_6p0 L=0.7U W=5U AS=1.3P AD=1.3P PS=5.52U PD=5.52U
* device instance $39 r0 *1 34.845,132.53 nmos_6p0
M$39 1 7 6 21 nmos_6p0 L=0.7U W=5U AS=1.3P AD=1.3P PS=5.52U PD=5.52U
* device instance $40 r0 *1 36.065,132.53 nmos_6p0
M$40 6 7 1 21 nmos_6p0 L=0.7U W=5U AS=1.3P AD=1.3P PS=5.52U PD=5.52U
* device instance $41 r0 *1 37.285,132.53 nmos_6p0
M$41 1 7 6 21 nmos_6p0 L=0.7U W=5U AS=1.3P AD=1.3P PS=5.52U PD=5.52U
* device instance $42 r0 *1 38.505,132.53 nmos_6p0
M$42 6 7 1 21 nmos_6p0 L=0.7U W=5U AS=1.3P AD=1.3P PS=5.52U PD=5.52U
* device instance $43 r0 *1 39.725,132.53 nmos_6p0
M$43 1 7 6 21 nmos_6p0 L=0.7U W=5U AS=1.3P AD=2.2P PS=5.52U PD=10.88U
.ENDS comp018green_esd_clamp_v5p0_DVSS

* cell M2_M1_CDNS_40661956134178
* pin
* pin
.SUBCKT M2_M1_CDNS_40661956134178 1 2
.ENDS M2_M1_CDNS_40661956134178

* cell M1_PSUB_CDNS_406619561348
* pin
* pin
.SUBCKT M1_PSUB_CDNS_406619561348 1 2
.ENDS M1_PSUB_CDNS_406619561348

* cell moscap_corner_1
* pin
* pin
* pin
* pin
.SUBCKT moscap_corner_1 1 2 3 4
* cell instance $1 r90 *1 38.74,61.09
X$1 2 1 M1_PSUB_CDNS_4066195613410
* cell instance $2 r90 *1 38.725,30.635
X$2 2 1 M1_PSUB_CDNS_4066195613410
* cell instance $3 r90 *1 38.765,0.67
X$3 2 1 M1_PSUB_CDNS_4066195613410
* cell instance $4 r0 *1 52.37,30.88
X$4 2 1 M1_PSUB_CDNS_406619561349
* cell instance $5 m0 *1 27.595,28.105
X$5 2 3 nmoscap_6p0_CDNS_406619561340
* cell instance $6 m0 *1 39.775,28.105
X$6 2 3 nmoscap_6p0_CDNS_406619561340
* cell instance $7 r0 *1 27.595,33.165
X$7 2 4 nmoscap_6p0_CDNS_406619561340
* cell instance $8 r0 *1 39.775,33.165
X$8 2 4 nmoscap_6p0_CDNS_406619561340
.ENDS moscap_corner_1

* cell moscap_corner
* pin
* pin VMINUS
* pin
* pin
.SUBCKT moscap_corner 1 2 3 4
* net 2 VMINUS
* cell instance $1 r90 *1 26.52,61.09
X$1 2 1 M1_PSUB_CDNS_4066195613411
* cell instance $2 r90 *1 26.52,30.635
X$2 2 1 M1_PSUB_CDNS_4066195613411
* cell instance $3 r90 *1 26.52,0.67
X$3 2 1 M1_PSUB_CDNS_4066195613411
* cell instance $4 r0 *1 52.37,30.88
X$4 2 1 M1_PSUB_CDNS_406619561349
* cell instance $5 m0 *1 3.235,28.105
X$5 2 3 nmoscap_6p0_CDNS_406619561340
* cell instance $6 m0 *1 15.415,28.105
X$6 2 3 nmoscap_6p0_CDNS_406619561340
* cell instance $7 m0 *1 27.595,28.105
X$7 2 3 nmoscap_6p0_CDNS_406619561340
* cell instance $8 m0 *1 39.775,28.105
X$8 2 3 nmoscap_6p0_CDNS_406619561340
* cell instance $9 r0 *1 3.235,33.165
X$9 2 4 nmoscap_6p0_CDNS_406619561340
* cell instance $10 r0 *1 15.415,33.165
X$10 2 4 nmoscap_6p0_CDNS_406619561340
* cell instance $11 r0 *1 27.595,33.165
X$11 2 4 nmoscap_6p0_CDNS_406619561340
* cell instance $12 r0 *1 39.775,33.165
X$12 2 4 nmoscap_6p0_CDNS_406619561340
.ENDS moscap_corner

* cell moscap_corner_2
* pin VMINUS
* pin
* pin
* pin
.SUBCKT moscap_corner_2 1 2 3 4
* net 1 VMINUS
* cell instance $1 r90 *1 39.14,0.67
X$1 1 2 M1_PSUB_CDNS_4066195613412
* cell instance $2 r0 *1 25.215,15.07
X$2 1 2 M1_PSUB_CDNS_4066195613413
* cell instance $3 r90 *1 26.52,61.09
X$3 1 2 M1_PSUB_CDNS_4066195613411
* cell instance $4 r90 *1 26.52,30.635
X$4 1 2 M1_PSUB_CDNS_4066195613411
* cell instance $5 r0 *1 52.37,30.88
X$5 1 2 M1_PSUB_CDNS_406619561349
* cell instance $6 m0 *1 27.595,28.105
X$6 1 3 nmoscap_6p0_CDNS_406619561340
* cell instance $7 m0 *1 39.775,28.105
X$7 1 3 nmoscap_6p0_CDNS_406619561340
* cell instance $8 r0 *1 3.235,33.165
X$8 1 4 nmoscap_6p0_CDNS_406619561340
* cell instance $9 r0 *1 15.415,33.165
X$9 1 4 nmoscap_6p0_CDNS_406619561340
* cell instance $10 r0 *1 27.595,33.165
X$10 1 4 nmoscap_6p0_CDNS_406619561340
* cell instance $11 r0 *1 39.775,33.165
X$11 1 4 nmoscap_6p0_CDNS_406619561340
.ENDS moscap_corner_2

* cell moscap_corner_3
* pin VMINUS
* pin
* pin
* pin
.SUBCKT moscap_corner_3 1 2 3 4
* net 1 VMINUS
* cell instance $1 r90 *1 32.085,61.09
X$1 1 2 M1_PSUB_CDNS_4066195613414
* cell instance $2 r90 *1 44.73,0.67
X$2 1 2 M1_PSUB_CDNS_4066195613415
* cell instance $3 r0 *1 36.835,15.07
X$3 1 2 M1_PSUB_CDNS_4066195613416
* cell instance $4 r90 *1 32.195,30.635
X$4 1 2 M1_PSUB_CDNS_4066195613417
* cell instance $5 r0 *1 52.37,30.88
X$5 1 2 M1_PSUB_CDNS_406619561349
* cell instance $6 m0 *1 39.775,28.105
X$6 1 3 nmoscap_6p0_CDNS_406619561340
* cell instance $7 r0 *1 15.415,33.165
X$7 1 4 nmoscap_6p0_CDNS_406619561340
* cell instance $8 r0 *1 27.595,33.165
X$8 1 4 nmoscap_6p0_CDNS_406619561340
* cell instance $9 r0 *1 39.775,33.165
X$9 1 4 nmoscap_6p0_CDNS_406619561340
.ENDS moscap_corner_3

* cell ESD_CLAMP_COR
* pin gf180mcu_gnd
* pin
* pin
* pin
* pin
* pin
* pin
* pin
* pin
* pin
* pin
.SUBCKT ESD_CLAMP_COR 1 2 3 4 5 6 7 8 17 18 27
* net 1 gf180mcu_gnd
* cell instance $1 m45 *1 0.255,217.825
X$1 18 17 1 16 15 14 13 12 11 10 9 comp018green_esd_clamp_v5p0_2
* cell instance $2 r0 *1 217.82,0.255
X$2 7 27 1 26 25 24 23 22 21 20 19 comp018green_esd_clamp_v5p0_1
* cell instance $3 m45 *1 2.54,212.785
X$3 10 9 18 17 10 18 10 10 18 18 10 18 10 18 10 18 9 9 9 10 10 10 10 9 9 9 9 10
+ 10 10 17 17 17 18 18 18 18 17 17 17 17 18 18 18 9 9 17 17 9 9 9 9 9 9 9 9 9
+ 17 17 17 17 17 17 17 17 17 15 14 14 14 15 14 15 15 12 15 12 10 10 10 12 12 12
+ 17 18 18 18 17 18 17 17 17 17 17 18 18 18 17 17 17 16 16 13 13 16 13 13 13 16
+ 11 11 11 9 9 9 9 11 18 18 17 17 18 17 17 17 18 18 18 18 17 17 17 17 18 12 12
+ 12 17 17 17 9 9 17 17 12 12 12 12 11 11 11 12 12 12 11 12 12 12 12 12 12 12
+ 12 12 12 12 12 12 12 12 9 11 12 12 12 12 11 12 11 12 12 12 12 11 12 12 12 12
+ 12 12 12 12 17 17 17 17 18 18 18 17 17 17 18 17 17 17 17 17 17 17 17 17 17 17
+ 17 17 17 17 17 18 17 17 17 17 18 17 18 17 17 17 17 18 17 17 17 17 17 17 17 17
+ 9 17 9 17 18 18 18 17 17 17 17 17 18 18 17 17 17 17 17 18 17 17 18 18 18 17
+ 18 16 16 11 13 13 13 13 13 16 11 9 15 15 15 15 14 15 12 14 14 10 12 10 3 2
+ power_via_cor_5
* cell instance $4 r0 *1 212.78,2.54
X$4 25 26 24 27 7 7 23 27 22 27 21 7 20 22 19 7 27 27 22 22 22 27 27 27 22 20
+ 20 20 20 19 19 19 19 19 19 19 22 22 20 20 20 22 20 20 20 22 22 22 22 20 20 20
+ 27 7 7 7 7 27 27 27 27 27 27 27 27 27 7 7 7 27 7 7 7 27 27 27 27 7 7 7 22 27
+ 22 27 7 27 7 27 7 26 23 21 25 24 5 4 power_via_cor_3
* cell instance $5 r0 *1 -6.5,283.255
X$5 8 6 27 7 top_routing_cor
.ENDS ESD_CLAMP_COR

* cell moscap_routing
* pin
* pin
* pin
* pin
* pin
* pin
* pin
* pin
* pin
* pin
* pin
* pin
* pin
* pin
* pin
* pin
* pin
* pin
* pin
* pin
* pin
* pin
* pin
* pin
* pin
* pin
* pin
* pin
* pin
* pin
* pin
* pin
* pin
* pin
* pin
* pin
* pin
* pin
* pin
* pin
* pin
* pin
* pin
* pin
* pin
* pin
* pin
* pin
* pin
* pin
* pin
* pin
* pin
* pin
* pin
* pin
* pin
* pin
* pin
* pin
* pin
* pin
* pin
* pin
* pin
* pin
* pin
* pin
* pin
* pin
* pin
* pin
* pin
* pin
.SUBCKT moscap_routing 2 4 6 7 8 11 13 14 17 18 20 21 22 23 24 25 26 28 29 31
+ 33 35 39 40 41 43 45 47 49 52 53 55 59 61 64 65 68 69 75 76 77 78 93 95 102
+ 103 104 105 167 168 175 176 177 178 179 183 184 185 187 189 207 208 209 210
+ 211 212 213 214 215 216 217 218 219 220
* cell instance $1 r0 *1 -80.03,-273.665
X$1 2 1 M1_PSUB_CDNS_4066195613434
* cell instance $2 r0 *1 -80.96,-271.805
X$2 2 1 M1_PSUB_CDNS_4066195613445
* cell instance $3 r0 *1 -80.65,-272.425
X$3 2 1 M1_PSUB_CDNS_4066195613446
* cell instance $4 r0 *1 -80.34,-273.045
X$4 2 1 M1_PSUB_CDNS_4066195613447
* cell instance $5 r0 *1 -83.13,-267.465
X$5 2 1 M1_PSUB_CDNS_4066195613438
* cell instance $6 r0 *1 -82.82,-268.085
X$6 2 1 M1_PSUB_CDNS_4066195613439
* cell instance $7 r0 *1 -82.51,-268.705
X$7 2 1 M1_PSUB_CDNS_4066195613440
* cell instance $8 r0 *1 -82.2,-269.325
X$8 2 1 M1_PSUB_CDNS_4066195613441
* cell instance $9 r0 *1 -81.89,-269.945
X$9 2 1 M1_PSUB_CDNS_4066195613442
* cell instance $10 r0 *1 -81.58,-270.565
X$10 2 1 M1_PSUB_CDNS_4066195613443
* cell instance $11 r0 *1 -81.27,-271.185
X$11 2 1 M1_PSUB_CDNS_4066195613444
* cell instance $12 r0 *1 -84.37,-264.985
X$12 2 1 M1_PSUB_CDNS_4066195613433
* cell instance $13 r0 *1 -84.06,-265.605
X$13 2 1 M1_PSUB_CDNS_4066195613435
* cell instance $14 r0 *1 -83.75,-266.225
X$14 2 1 M1_PSUB_CDNS_4066195613436
* cell instance $15 r0 *1 -83.44,-266.845
X$15 2 1 M1_PSUB_CDNS_4066195613437
* cell instance $16 r0 *1 -92.625,-259.83
X$16 2 3 M1_PSUB_CDNS_4066195613444
* cell instance $17 r0 *1 -92.935,-259.21
X$17 2 3 M1_PSUB_CDNS_4066195613443
* cell instance $18 r0 *1 -93.245,-258.59
X$18 2 3 M1_PSUB_CDNS_4066195613442
* cell instance $19 r0 *1 -93.555,-257.97
X$19 2 3 M1_PSUB_CDNS_4066195613441
* cell instance $20 r0 *1 -93.865,-257.35
X$20 2 3 M1_PSUB_CDNS_4066195613440
* cell instance $21 r0 *1 -94.175,-256.73
X$21 2 3 M1_PSUB_CDNS_4066195613439
* cell instance $22 r0 *1 -94.485,-256.11
X$22 2 3 M1_PSUB_CDNS_4066195613438
* cell instance $23 r0 *1 -91.695,-261.69
X$23 2 3 M1_PSUB_CDNS_4066195613447
* cell instance $24 r0 *1 -92.005,-261.07
X$24 2 3 M1_PSUB_CDNS_4066195613446
* cell instance $25 r0 *1 -92.315,-260.45
X$25 2 3 M1_PSUB_CDNS_4066195613445
* cell instance $26 r0 *1 -91.385,-262.31
X$26 2 3 M1_PSUB_CDNS_4066195613434
* cell instance $27 r0 *1 -95.105,-254.87
X$27 2 3 M1_PSUB_CDNS_4066195613436
* cell instance $28 r0 *1 -95.415,-254.25
X$28 2 3 M1_PSUB_CDNS_4066195613435
* cell instance $29 r0 *1 -95.725,-253.63
X$29 2 3 M1_PSUB_CDNS_4066195613433
* cell instance $30 r0 *1 -94.795,-255.49
X$30 2 3 M1_PSUB_CDNS_4066195613437
* cell instance $31 r0 *1 -45.87,-268.96
X$31 2 221 M2_M1_CDNS_40661956134110
* cell instance $32 r0 *1 -47.34,-270.46
X$32 2 M1_PSUB_CDNS_4066195613418
* cell instance $33 r0 *1 -45.87,-268.96
X$33 2 221 M3_M2_CDNS_40661956134111
* cell instance $34 r0 *1 -81.405,-260.315
X$34 4 5 M2_M1_CDNS_4066195613470
* cell instance $35 r0 *1 -92.45,-203.825
X$35 4 5 M2_M1_CDNS_4066195613467
* cell instance $36 r0 *1 -46.07,-203.825
X$36 4 5 M2_M1_CDNS_4066195613468
* cell instance $37 r0 *1 -71.495,-203.95
X$37 4 5 M3_M2_CDNS_4066195613474
* cell instance $38 r0 *1 -46.07,-260.315
X$38 4 5 M2_M1_CDNS_4066195613468
* cell instance $39 r0 *1 -94.575,-247.89
X$39 7 6 M1_PSUB_CDNS_4066195613453
* cell instance $40 r0 *1 -99.845,-237.625
X$40 8 6 M1_PSUB_CDNS_4066195613452
* cell instance $41 r0 *1 -114.53,-235.215
X$41 8 6 M1_PSUB_CDNS_4066195613437
* cell instance $42 r0 *1 -104.01,-245.42
X$42 7 6 M1_PSUB_CDNS_4066195613437
* cell instance $43 r0 *1 -114.84,-234.595
X$43 8 6 M1_PSUB_CDNS_4066195613436
* cell instance $44 r0 *1 -104.32,-244.8
X$44 7 6 M1_PSUB_CDNS_4066195613436
* cell instance $45 r0 *1 -115.15,-233.975
X$45 8 6 M1_PSUB_CDNS_4066195613435
* cell instance $46 r0 *1 -104.63,-244.18
X$46 7 6 M1_PSUB_CDNS_4066195613435
* cell instance $47 r0 *1 -104.94,-243.56
X$47 7 6 M1_PSUB_CDNS_4066195613433
* cell instance $48 r0 *1 -115.46,-233.355
X$48 105 6 M1_PSUB_CDNS_4066195613433
* cell instance $49 r0 *1 -101.84,-249.76
X$49 7 6 M1_PSUB_CDNS_4066195613444
* cell instance $50 r0 *1 -112.36,-239.555
X$50 8 6 M1_PSUB_CDNS_4066195613444
* cell instance $51 r0 *1 -112.67,-238.935
X$51 8 6 M1_PSUB_CDNS_4066195613443
* cell instance $52 r0 *1 -102.15,-249.14
X$52 7 6 M1_PSUB_CDNS_4066195613443
* cell instance $53 r0 *1 -102.46,-248.52
X$53 7 6 M1_PSUB_CDNS_4066195613442
* cell instance $54 r0 *1 -112.98,-238.315
X$54 8 6 M1_PSUB_CDNS_4066195613442
* cell instance $55 r0 *1 -113.29,-237.695
X$55 8 6 M1_PSUB_CDNS_4066195613441
* cell instance $56 r0 *1 -102.77,-247.9
X$56 7 6 M1_PSUB_CDNS_4066195613441
* cell instance $57 r0 *1 -103.08,-247.28
X$57 7 6 M1_PSUB_CDNS_4066195613440
* cell instance $58 r0 *1 -113.6,-237.075
X$58 8 6 M1_PSUB_CDNS_4066195613440
* cell instance $59 r0 *1 -103.39,-246.66
X$59 7 6 M1_PSUB_CDNS_4066195613439
* cell instance $60 r0 *1 -113.91,-236.455
X$60 8 6 M1_PSUB_CDNS_4066195613439
* cell instance $61 r0 *1 -103.7,-246.04
X$61 7 6 M1_PSUB_CDNS_4066195613438
* cell instance $62 r0 *1 -114.22,-235.835
X$62 8 6 M1_PSUB_CDNS_4066195613438
* cell instance $63 r0 *1 -100.91,-251.62
X$63 7 6 M1_PSUB_CDNS_4066195613447
* cell instance $64 r0 *1 -111.43,-241.415
X$64 8 6 M1_PSUB_CDNS_4066195613447
* cell instance $65 r0 *1 -101.22,-251
X$65 7 6 M1_PSUB_CDNS_4066195613446
* cell instance $66 r0 *1 -111.74,-240.795
X$66 8 6 M1_PSUB_CDNS_4066195613446
* cell instance $67 r0 *1 -112.05,-240.175
X$67 8 6 M1_PSUB_CDNS_4066195613445
* cell instance $68 r0 *1 -101.53,-250.38
X$68 7 6 M1_PSUB_CDNS_4066195613445
* cell instance $69 r0 *1 -100.6,-252.24
X$69 7 6 M1_PSUB_CDNS_4066195613434
* cell instance $70 r0 *1 -111.12,-242.035
X$70 8 6 M1_PSUB_CDNS_4066195613434
* cell instance $71 r0 *1 -98.635,-237.095
X$71 8 190 M2_M1_CDNS_4066195613480
* cell instance $72 r0 *1 -98.635,-237.095
X$72 8 190 M3_M2_CDNS_4066195613481
* cell instance $73 r0 *1 -117.705,-227.215
X$73 11 9 M1_PSUB_CDNS_4066195613456
* cell instance $74 r0 *1 -125.54,-224.745
X$74 11 9 M1_PSUB_CDNS_4066195613437
* cell instance $75 r0 *1 -125.85,-224.125
X$75 11 9 M1_PSUB_CDNS_4066195613436
* cell instance $76 r0 *1 -126.16,-223.505
X$76 11 9 M1_PSUB_CDNS_4066195613435
* cell instance $77 r0 *1 -126.47,-222.885
X$77 11 9 M1_PSUB_CDNS_4066195613433
* cell instance $78 r0 *1 -123.37,-229.085
X$78 11 9 M1_PSUB_CDNS_4066195613444
* cell instance $79 r0 *1 -123.68,-228.465
X$79 11 9 M1_PSUB_CDNS_4066195613443
* cell instance $80 r0 *1 -123.99,-227.845
X$80 11 9 M1_PSUB_CDNS_4066195613442
* cell instance $81 r0 *1 -124.3,-227.225
X$81 11 9 M1_PSUB_CDNS_4066195613441
* cell instance $82 r0 *1 -124.61,-226.605
X$82 11 9 M1_PSUB_CDNS_4066195613440
* cell instance $83 r0 *1 -124.92,-225.985
X$83 11 9 M1_PSUB_CDNS_4066195613439
* cell instance $84 r0 *1 -125.23,-225.365
X$84 11 9 M1_PSUB_CDNS_4066195613438
* cell instance $85 r0 *1 -122.44,-230.945
X$85 11 9 M1_PSUB_CDNS_4066195613447
* cell instance $86 r0 *1 -122.75,-230.325
X$86 11 9 M1_PSUB_CDNS_4066195613446
* cell instance $87 r0 *1 -123.06,-229.705
X$87 11 9 M1_PSUB_CDNS_4066195613445
* cell instance $88 r0 *1 -122.13,-231.565
X$88 11 9 M1_PSUB_CDNS_4066195613434
* cell instance $89 r0 *1 -134.755,-214.675
X$89 13 10 M1_PSUB_CDNS_4066195613437
* cell instance $90 r0 *1 -135.065,-214.055
X$90 13 10 M1_PSUB_CDNS_4066195613436
* cell instance $91 r0 *1 -135.375,-213.435
X$91 13 10 M1_PSUB_CDNS_4066195613435
* cell instance $92 r0 *1 -135.685,-212.815
X$92 13 10 M1_PSUB_CDNS_4066195613433
* cell instance $93 r0 *1 -132.585,-219.015
X$93 13 10 M1_PSUB_CDNS_4066195613444
* cell instance $94 r0 *1 -132.895,-218.395
X$94 13 10 M1_PSUB_CDNS_4066195613443
* cell instance $95 r0 *1 -133.205,-217.775
X$95 13 10 M1_PSUB_CDNS_4066195613442
* cell instance $96 r0 *1 -133.515,-217.155
X$96 13 10 M1_PSUB_CDNS_4066195613441
* cell instance $97 r0 *1 -133.825,-216.535
X$97 13 10 M1_PSUB_CDNS_4066195613440
* cell instance $98 r0 *1 -134.135,-215.915
X$98 13 10 M1_PSUB_CDNS_4066195613439
* cell instance $99 r0 *1 -134.445,-215.295
X$99 13 10 M1_PSUB_CDNS_4066195613438
* cell instance $100 r0 *1 -131.655,-220.875
X$100 13 10 M1_PSUB_CDNS_4066195613447
* cell instance $101 r0 *1 -131.965,-220.255
X$101 13 10 M1_PSUB_CDNS_4066195613446
* cell instance $102 r0 *1 -132.275,-219.635
X$102 13 10 M1_PSUB_CDNS_4066195613445
* cell instance $103 r0 *1 -131.345,-221.495
X$103 13 10 M1_PSUB_CDNS_4066195613434
* cell instance $104 r0 *1 -127.45,-206.88
X$104 14 12 M1_PSUB_CDNS_4066195613451
* cell instance $105 r0 *1 -145.275,-204.47
X$105 14 12 M1_PSUB_CDNS_4066195613437
* cell instance $106 r0 *1 -145.585,-203.85
X$106 14 12 M1_PSUB_CDNS_4066195613436
* cell instance $107 r0 *1 -145.895,-203.23
X$107 14 12 M1_PSUB_CDNS_4066195613435
* cell instance $108 r0 *1 -146.205,-202.61
X$108 14 12 M1_PSUB_CDNS_4066195613433
* cell instance $109 r0 *1 -143.105,-208.81
X$109 14 12 M1_PSUB_CDNS_4066195613444
* cell instance $110 r0 *1 -143.415,-208.19
X$110 14 12 M1_PSUB_CDNS_4066195613443
* cell instance $111 r0 *1 -143.725,-207.57
X$111 14 12 M1_PSUB_CDNS_4066195613442
* cell instance $112 r0 *1 -144.035,-206.95
X$112 14 12 M1_PSUB_CDNS_4066195613441
* cell instance $113 r0 *1 -144.345,-206.33
X$113 14 12 M1_PSUB_CDNS_4066195613440
* cell instance $114 r0 *1 -144.655,-205.71
X$114 14 12 M1_PSUB_CDNS_4066195613439
* cell instance $115 r0 *1 -144.965,-205.09
X$115 14 12 M1_PSUB_CDNS_4066195613438
* cell instance $116 r0 *1 -142.175,-210.67
X$116 14 12 M1_PSUB_CDNS_4066195613447
* cell instance $117 r0 *1 -142.485,-210.05
X$117 14 12 M1_PSUB_CDNS_4066195613446
* cell instance $118 r0 *1 -142.795,-209.43
X$118 14 12 M1_PSUB_CDNS_4066195613445
* cell instance $119 r0 *1 -141.865,-211.29
X$119 14 12 M1_PSUB_CDNS_4066195613434
* cell instance $120 r0 *1 -118.905,-216.825
X$120 13 192 M2_M1_CDNS_4066195613480
* cell instance $121 r0 *1 -122.18,-217.145
X$121 13 M1_PSUB_CDNS_4066195613455
* cell instance $122 r0 *1 -118.905,-216.825
X$122 13 192 M3_M2_CDNS_4066195613481
* cell instance $123 r0 *1 -129.395,-206.335
X$123 14 191 M2_M1_CDNS_4066195613480
* cell instance $124 r0 *1 -129.395,-206.335
X$124 14 191 M3_M2_CDNS_4066195613481
* cell instance $125 r0 *1 -156.185,-186.28
X$125 17 15 M1_PSUB_CDNS_4066195613453
* cell instance $126 r0 *1 -165.62,-183.81
X$126 17 15 M1_PSUB_CDNS_4066195613437
* cell instance $127 r0 *1 -165.93,-183.19
X$127 17 15 M1_PSUB_CDNS_4066195613436
* cell instance $128 r0 *1 -166.24,-182.57
X$128 17 15 M1_PSUB_CDNS_4066195613435
* cell instance $129 r0 *1 -166.55,-181.95
X$129 17 15 M1_PSUB_CDNS_4066195613433
* cell instance $130 r0 *1 -163.45,-188.15
X$130 17 15 M1_PSUB_CDNS_4066195613444
* cell instance $131 r0 *1 -163.76,-187.53
X$131 17 15 M1_PSUB_CDNS_4066195613443
* cell instance $132 r0 *1 -164.07,-186.91
X$132 17 15 M1_PSUB_CDNS_4066195613442
* cell instance $133 r0 *1 -164.38,-186.29
X$133 17 15 M1_PSUB_CDNS_4066195613441
* cell instance $134 r0 *1 -164.69,-185.67
X$134 17 15 M1_PSUB_CDNS_4066195613440
* cell instance $135 r0 *1 -165,-185.05
X$135 17 15 M1_PSUB_CDNS_4066195613439
* cell instance $136 r0 *1 -165.31,-184.43
X$136 17 15 M1_PSUB_CDNS_4066195613438
* cell instance $137 r0 *1 -162.52,-190.01
X$137 17 15 M1_PSUB_CDNS_4066195613447
* cell instance $138 r0 *1 -162.83,-189.39
X$138 17 15 M1_PSUB_CDNS_4066195613446
* cell instance $139 r0 *1 -163.14,-188.77
X$139 17 15 M1_PSUB_CDNS_4066195613445
* cell instance $140 r0 *1 -162.21,-190.63
X$140 17 15 M1_PSUB_CDNS_4066195613434
* cell instance $141 r0 *1 -156.405,-193.88
X$141 17 16 M1_PSUB_CDNS_4066195613437
* cell instance $142 r0 *1 -156.715,-193.26
X$142 17 16 M1_PSUB_CDNS_4066195613436
* cell instance $143 r0 *1 -157.025,-192.64
X$143 17 16 M1_PSUB_CDNS_4066195613435
* cell instance $144 r0 *1 -157.335,-192.02
X$144 17 16 M1_PSUB_CDNS_4066195613433
* cell instance $145 r0 *1 -154.235,-198.22
X$145 17 16 M1_PSUB_CDNS_4066195613444
* cell instance $146 r0 *1 -154.545,-197.6
X$146 17 16 M1_PSUB_CDNS_4066195613443
* cell instance $147 r0 *1 -154.855,-196.98
X$147 17 16 M1_PSUB_CDNS_4066195613442
* cell instance $148 r0 *1 -155.165,-196.36
X$148 17 16 M1_PSUB_CDNS_4066195613441
* cell instance $149 r0 *1 -155.475,-195.74
X$149 17 16 M1_PSUB_CDNS_4066195613440
* cell instance $150 r0 *1 -155.785,-195.12
X$150 17 16 M1_PSUB_CDNS_4066195613439
* cell instance $151 r0 *1 -156.095,-194.5
X$151 17 16 M1_PSUB_CDNS_4066195613438
* cell instance $152 r0 *1 -153.305,-200.08
X$152 17 16 M1_PSUB_CDNS_4066195613447
* cell instance $153 r0 *1 -153.615,-199.46
X$153 17 16 M1_PSUB_CDNS_4066195613446
* cell instance $154 r0 *1 -153.925,-198.84
X$154 17 16 M1_PSUB_CDNS_4066195613445
* cell instance $155 r0 *1 -152.995,-200.7
X$155 17 16 M1_PSUB_CDNS_4066195613434
* cell instance $156 r0 *1 -155.37,-184.955
X$156 17 169 M2_M1_CDNS_4066195613478
* cell instance $157 r0 *1 -155.37,-184.955
X$157 17 169 M3_M2_CDNS_4066195613479
* cell instance $158 r0 *1 -137.985,-198.59
X$158 18 19 M2_M1_CDNS_4066195613469
* cell instance $159 r0 *1 -52.435,-191.625
X$159 18 19 M2_M1_CDNS_40661956134109
* cell instance $160 r0 *1 -52.435,-191.625
X$160 18 19 M3_M2_CDNS_40661956134108
* cell instance $161 r0 *1 -76.87,-198.575
X$161 18 19 M3_M2_CDNS_4066195613474
* cell instance $162 r0 *1 -97.73,-198.59
X$162 18 19 M2_M1_CDNS_4066195613468
* cell instance $163 r0 *1 -46.07,-198.59
X$163 18 19 M2_M1_CDNS_4066195613468
* cell instance $164 r0 *1 -161.455,-176.015
X$164 21 20 M1_PSUB_CDNS_4066195613452
* cell instance $165 r0 *1 -176.14,-173.605
X$165 21 20 M1_PSUB_CDNS_4066195613437
* cell instance $166 r0 *1 -176.45,-172.985
X$166 21 20 M1_PSUB_CDNS_4066195613436
* cell instance $167 r0 *1 -176.76,-172.365
X$167 21 20 M1_PSUB_CDNS_4066195613435
* cell instance $168 r0 *1 -177.07,-171.745
X$168 21 20 M1_PSUB_CDNS_4066195613433
* cell instance $169 r0 *1 -173.97,-177.945
X$169 21 20 M1_PSUB_CDNS_4066195613444
* cell instance $170 r0 *1 -174.28,-177.325
X$170 21 20 M1_PSUB_CDNS_4066195613443
* cell instance $171 r0 *1 -174.59,-176.705
X$171 21 20 M1_PSUB_CDNS_4066195613442
* cell instance $172 r0 *1 -174.9,-176.085
X$172 21 20 M1_PSUB_CDNS_4066195613441
* cell instance $173 r0 *1 -175.21,-175.465
X$173 21 20 M1_PSUB_CDNS_4066195613440
* cell instance $174 r0 *1 -175.52,-174.845
X$174 21 20 M1_PSUB_CDNS_4066195613439
* cell instance $175 r0 *1 -175.83,-174.225
X$175 21 20 M1_PSUB_CDNS_4066195613438
* cell instance $176 r0 *1 -173.04,-179.805
X$176 21 20 M1_PSUB_CDNS_4066195613447
* cell instance $177 r0 *1 -173.35,-179.185
X$177 21 20 M1_PSUB_CDNS_4066195613446
* cell instance $178 r0 *1 -173.66,-178.565
X$178 21 20 M1_PSUB_CDNS_4066195613445
* cell instance $179 r0 *1 -172.73,-180.425
X$179 21 20 M1_PSUB_CDNS_4066195613434
* cell instance $180 r0 *1 -158.895,-177.595
X$180 21 106 M2_M1_CDNS_4066195613475
* cell instance $181 r0 *1 -158.895,-177.595
X$181 21 106 M3_M2_CDNS_4066195613476
* cell instance $182 r0 *1 -161.175,-175.315
X$182 21 113 M2_M1_CDNS_4066195613475
* cell instance $183 r0 *1 -161.175,-175.315
X$183 21 113 M3_M2_CDNS_4066195613476
* cell instance $184 r0 *1 -160.415,-176.075
X$184 21 114 M2_M1_CDNS_4066195613475
* cell instance $185 r0 *1 -160.415,-176.075
X$185 21 114 M3_M2_CDNS_4066195613476
* cell instance $186 r0 *1 -159.655,-176.835
X$186 21 165 M2_M1_CDNS_4066195613475
* cell instance $187 r0 *1 -159.655,-176.835
X$187 21 165 M3_M2_CDNS_4066195613476
* cell instance $188 r0 *1 -163.455,-173.035
X$188 21 154 M3_M2_CDNS_4066195613476
* cell instance $189 r0 *1 -163.455,-173.035
X$189 21 154 M2_M1_CDNS_4066195613475
* cell instance $190 r0 *1 -162.695,-173.795
X$190 21 111 M2_M1_CDNS_4066195613475
* cell instance $191 r0 *1 -162.695,-173.795
X$191 21 111 M3_M2_CDNS_4066195613476
* cell instance $192 r0 *1 -161.935,-174.555
X$192 21 112 M2_M1_CDNS_4066195613475
* cell instance $193 r0 *1 -161.935,-174.555
X$193 21 112 M3_M2_CDNS_4066195613476
* cell instance $194 r0 *1 -164.975,-171.515
X$194 21 164 M2_M1_CDNS_4066195613475
* cell instance $195 r0 *1 -164.975,-171.515
X$195 21 164 M3_M2_CDNS_4066195613476
* cell instance $196 r0 *1 -164.215,-172.275
X$196 21 155 M2_M1_CDNS_4066195613475
* cell instance $197 r0 *1 -164.215,-172.275
X$197 21 155 M3_M2_CDNS_4066195613476
* cell instance $198 r0 *1 -183.375,-169.77
X$198 24 22 M1_PSUB_CDNS_4066195613458
* cell instance $199 r0 *1 -179.21,-165.42
X$199 24 22 M1_PSUB_CDNS_4066195613456
* cell instance $200 r0 *1 -187.095,-162.95
X$200 24 22 M1_PSUB_CDNS_4066195613437
* cell instance $201 r0 *1 -187.405,-162.33
X$201 24 22 M1_PSUB_CDNS_4066195613436
* cell instance $202 r0 *1 -187.715,-161.71
X$202 24 22 M1_PSUB_CDNS_4066195613435
* cell instance $203 r0 *1 -188.025,-161.09
X$203 24 22 M1_PSUB_CDNS_4066195613433
* cell instance $204 r0 *1 -184.925,-167.29
X$204 24 22 M1_PSUB_CDNS_4066195613444
* cell instance $205 r0 *1 -185.235,-166.67
X$205 24 22 M1_PSUB_CDNS_4066195613443
* cell instance $206 r0 *1 -185.545,-166.05
X$206 24 22 M1_PSUB_CDNS_4066195613442
* cell instance $207 r0 *1 -185.855,-165.43
X$207 24 22 M1_PSUB_CDNS_4066195613441
* cell instance $208 r0 *1 -186.165,-164.81
X$208 24 22 M1_PSUB_CDNS_4066195613440
* cell instance $209 r0 *1 -186.475,-164.19
X$209 24 22 M1_PSUB_CDNS_4066195613439
* cell instance $210 r0 *1 -186.785,-163.57
X$210 24 22 M1_PSUB_CDNS_4066195613438
* cell instance $211 r0 *1 -183.995,-169.15
X$211 24 22 M1_PSUB_CDNS_4066195613447
* cell instance $212 r0 *1 -184.305,-168.53
X$212 24 22 M1_PSUB_CDNS_4066195613446
* cell instance $213 r0 *1 -184.615,-167.91
X$213 24 22 M1_PSUB_CDNS_4066195613445
* cell instance $214 r0 *1 -184.735,-154.71
X$214 25 23 M1_PSUB_CDNS_4066195613450
* cell instance $215 r0 *1 -194.36,-159.06
X$215 25 23 M1_PSUB_CDNS_4066195613458
* cell instance $216 r0 *1 -198.08,-152.24
X$216 25 23 M1_PSUB_CDNS_4066195613437
* cell instance $217 r0 *1 -198.39,-151.62
X$217 25 23 M1_PSUB_CDNS_4066195613436
* cell instance $218 r0 *1 -198.7,-151
X$218 25 23 M1_PSUB_CDNS_4066195613435
* cell instance $219 r0 *1 -199.01,-150.38
X$219 25 23 M1_PSUB_CDNS_4066195613433
* cell instance $220 r0 *1 -195.91,-156.58
X$220 25 23 M1_PSUB_CDNS_4066195613444
* cell instance $221 r0 *1 -196.22,-155.96
X$221 25 23 M1_PSUB_CDNS_4066195613443
* cell instance $222 r0 *1 -196.53,-155.34
X$222 25 23 M1_PSUB_CDNS_4066195613442
* cell instance $223 r0 *1 -196.84,-154.72
X$223 25 23 M1_PSUB_CDNS_4066195613441
* cell instance $224 r0 *1 -197.15,-154.1
X$224 25 23 M1_PSUB_CDNS_4066195613440
* cell instance $225 r0 *1 -197.46,-153.48
X$225 25 23 M1_PSUB_CDNS_4066195613439
* cell instance $226 r0 *1 -197.77,-152.86
X$226 25 23 M1_PSUB_CDNS_4066195613438
* cell instance $227 r0 *1 -194.98,-158.44
X$227 25 23 M1_PSUB_CDNS_4066195613447
* cell instance $228 r0 *1 -195.29,-157.82
X$228 25 23 M1_PSUB_CDNS_4066195613446
* cell instance $229 r0 *1 -195.6,-157.2
X$229 25 23 M1_PSUB_CDNS_4066195613445
* cell instance $230 r0 *1 -167.255,-169.235
X$230 24 97 M2_M1_CDNS_4066195613469
* cell instance $231 r0 *1 -167.255,-169.235
X$231 24 97 M3_M2_CDNS_4066195613477
* cell instance $232 r0 *1 -174.61,-160.57
X$232 25 96 M2_M1_CDNS_4066195613471
* cell instance $233 r0 *1 -174.61,-160.57
X$233 25 96 M3_M2_CDNS_4066195613472
* cell instance $234 r0 *1 -206.22,-146.15
X$234 26 27 M1_PSUB_CDNS_4066195613444
* cell instance $235 r0 *1 -206.53,-145.53
X$235 26 27 M1_PSUB_CDNS_4066195613443
* cell instance $236 r0 *1 -206.84,-144.91
X$236 26 27 M1_PSUB_CDNS_4066195613442
* cell instance $237 r0 *1 -207.15,-144.29
X$237 26 27 M1_PSUB_CDNS_4066195613441
* cell instance $238 r0 *1 -207.46,-143.67
X$238 26 27 M1_PSUB_CDNS_4066195613440
* cell instance $239 r0 *1 -207.77,-143.05
X$239 26 27 M1_PSUB_CDNS_4066195613439
* cell instance $240 r0 *1 -208.08,-142.43
X$240 26 27 M1_PSUB_CDNS_4066195613438
* cell instance $241 r0 *1 -205.29,-148.01
X$241 26 27 M1_PSUB_CDNS_4066195613447
* cell instance $242 r0 *1 -205.6,-147.39
X$242 26 27 M1_PSUB_CDNS_4066195613446
* cell instance $243 r0 *1 -205.91,-146.77
X$243 26 27 M1_PSUB_CDNS_4066195613445
* cell instance $244 r0 *1 -204.98,-148.63
X$244 26 27 M1_PSUB_CDNS_4066195613434
* cell instance $245 r0 *1 -188.77,-147.72
X$245 26 156 M2_M1_CDNS_4066195613475
* cell instance $246 r0 *1 -189.695,-144.28
X$246 26 28 M1_PSUB_CDNS_4066195613448
* cell instance $247 r0 *1 -188.77,-147.72
X$247 26 156 M3_M2_CDNS_4066195613476
* cell instance $248 r0 *1 -188.01,-148.48
X$248 26 128 M2_M1_CDNS_4066195613475
* cell instance $249 r0 *1 -188.01,-148.48
X$249 26 128 M3_M2_CDNS_4066195613476
* cell instance $250 r0 *1 -193.33,-143.16
X$250 26 157 M2_M1_CDNS_4066195613475
* cell instance $251 r0 *1 -193.33,-143.16
X$251 26 157 M3_M2_CDNS_4066195613476
* cell instance $252 r0 *1 -192.57,-143.92
X$252 26 132 M2_M1_CDNS_4066195613475
* cell instance $253 r0 *1 -192.57,-143.92
X$253 26 132 M3_M2_CDNS_4066195613476
* cell instance $254 r0 *1 -191.81,-144.68
X$254 26 161 M2_M1_CDNS_4066195613475
* cell instance $255 r0 *1 -191.81,-144.68
X$255 26 161 M3_M2_CDNS_4066195613476
* cell instance $256 r0 *1 -191.05,-145.44
X$256 26 160 M2_M1_CDNS_4066195613475
* cell instance $257 r0 *1 -191.05,-145.44
X$257 26 160 M3_M2_CDNS_4066195613476
* cell instance $258 r0 *1 -190.29,-146.2
X$258 26 159 M2_M1_CDNS_4066195613475
* cell instance $259 r0 *1 -190.29,-146.2
X$259 26 159 M3_M2_CDNS_4066195613476
* cell instance $260 r0 *1 -189.53,-146.96
X$260 26 158 M2_M1_CDNS_4066195613475
* cell instance $261 r0 *1 -189.53,-146.96
X$261 26 158 M3_M2_CDNS_4066195613476
* cell instance $262 r0 *1 -194.09,-142.4
X$262 26 116 M2_M1_CDNS_4066195613475
* cell instance $263 r0 *1 -194.09,-142.4
X$263 26 116 M3_M2_CDNS_4066195613476
* cell instance $264 r0 *1 -196.37,-140.12
X$264 26 100 M3_M2_CDNS_4066195613477
* cell instance $265 r0 *1 -196.37,-140.12
X$265 26 100 M2_M1_CDNS_4066195613469
* cell instance $266 r0 *1 -195.61,-140.88
X$266 26 138 M2_M1_CDNS_4066195613475
* cell instance $267 r0 *1 -209.01,-140.57
X$267 26 27 M1_PSUB_CDNS_4066195613435
* cell instance $268 r0 *1 -208.7,-141.19
X$268 26 27 M1_PSUB_CDNS_4066195613436
* cell instance $269 r0 *1 -195.61,-140.88
X$269 26 138 M3_M2_CDNS_4066195613476
* cell instance $270 r0 *1 -194.85,-141.64
X$270 26 133 M2_M1_CDNS_4066195613475
* cell instance $271 r0 *1 -208.39,-141.81
X$271 26 27 M1_PSUB_CDNS_4066195613437
* cell instance $272 r0 *1 -194.85,-141.64
X$272 26 133 M3_M2_CDNS_4066195613476
* cell instance $273 r0 *1 -209.32,-139.95
X$273 26 27 M1_PSUB_CDNS_4066195613433
* cell instance $274 r0 *1 -127.31,-133.88
X$274 31 28 M1_PSUB_CDNS_4066195613449
* cell instance $275 r0 *1 -229.615,-89.65
X$275 31 28 M1_PSUB_CDNS_4066195613431
* cell instance $276 r0 *1 -132.125,-63.61
X$276 31 28 M1_PSUB_CDNS_4066195613429
* cell instance $277 r0 *1 -228.685,-121.42
X$277 31 28 M1_PSUB_CDNS_4066195613437
* cell instance $278 r0 *1 -218.99,-131.1
X$278 31 28 M1_PSUB_CDNS_4066195613437
* cell instance $279 r0 *1 -228.995,-120.8
X$279 31 28 M1_PSUB_CDNS_4066195613436
* cell instance $280 r0 *1 -219.3,-130.48
X$280 31 28 M1_PSUB_CDNS_4066195613436
* cell instance $281 r0 *1 -229.305,-120.18
X$281 31 28 M1_PSUB_CDNS_4066195613435
* cell instance $282 r0 *1 -219.61,-129.86
X$282 31 28 M1_PSUB_CDNS_4066195613435
* cell instance $283 r0 *1 -219.92,-129.24
X$283 31 28 M1_PSUB_CDNS_4066195613433
* cell instance $284 r0 *1 -229.615,-119.56
X$284 31 28 M1_PSUB_CDNS_4066195613433
* cell instance $285 r0 *1 -226.515,-125.76
X$285 31 28 M1_PSUB_CDNS_4066195613444
* cell instance $286 r0 *1 -216.82,-135.44
X$286 31 28 M1_PSUB_CDNS_4066195613444
* cell instance $287 r0 *1 -226.825,-125.14
X$287 31 28 M1_PSUB_CDNS_4066195613443
* cell instance $288 r0 *1 -217.13,-134.82
X$288 31 28 M1_PSUB_CDNS_4066195613443
* cell instance $289 r0 *1 -227.135,-124.52
X$289 31 28 M1_PSUB_CDNS_4066195613442
* cell instance $290 r0 *1 -217.44,-134.2
X$290 31 28 M1_PSUB_CDNS_4066195613442
* cell instance $291 r0 *1 -227.445,-123.9
X$291 31 28 M1_PSUB_CDNS_4066195613441
* cell instance $292 r0 *1 -217.75,-133.58
X$292 31 28 M1_PSUB_CDNS_4066195613441
* cell instance $293 r0 *1 -218.06,-132.96
X$293 31 28 M1_PSUB_CDNS_4066195613440
* cell instance $294 r0 *1 -227.755,-123.28
X$294 31 28 M1_PSUB_CDNS_4066195613440
* cell instance $295 r0 *1 -228.065,-122.66
X$295 31 28 M1_PSUB_CDNS_4066195613439
* cell instance $296 r0 *1 -218.37,-132.34
X$296 31 28 M1_PSUB_CDNS_4066195613439
* cell instance $297 r0 *1 -228.375,-122.04
X$297 31 28 M1_PSUB_CDNS_4066195613438
* cell instance $298 r0 *1 -218.68,-131.72
X$298 31 28 M1_PSUB_CDNS_4066195613438
* cell instance $299 r0 *1 -225.585,-127.62
X$299 31 28 M1_PSUB_CDNS_4066195613447
* cell instance $300 r0 *1 -215.89,-137.3
X$300 31 28 M1_PSUB_CDNS_4066195613447
* cell instance $301 r0 *1 -225.895,-127
X$301 31 28 M1_PSUB_CDNS_4066195613446
* cell instance $302 r0 *1 -216.2,-136.68
X$302 31 28 M1_PSUB_CDNS_4066195613446
* cell instance $303 r0 *1 -216.51,-136.06
X$303 31 28 M1_PSUB_CDNS_4066195613445
* cell instance $304 r0 *1 -226.205,-126.38
X$304 31 28 M1_PSUB_CDNS_4066195613445
* cell instance $305 r0 *1 -225.275,-128.24
X$305 31 28 M1_PSUB_CDNS_4066195613434
* cell instance $306 r0 *1 -215.58,-137.92
X$306 31 28 M1_PSUB_CDNS_4066195613434
* cell instance $307 r0 *1 -104.16,-146.01
X$307 29 30 M3_M2_CDNS_4066195613488
* cell instance $308 r0 *1 -104.16,-146.01
X$308 29 30 M2_M1_CDNS_4066195613486
* cell instance $309 r0 *1 -79.795,-146.01
X$309 29 30 M3_M2_CDNS_4066195613488
* cell instance $310 r0 *1 -79.795,-146.01
X$310 29 30 M2_M1_CDNS_4066195613486
* cell instance $311 r0 *1 -46.07,-142.125
X$311 29 30 M2_M1_CDNS_4066195613468
* cell instance $312 r0 *1 -97.73,-142.125
X$312 29 30 M2_M1_CDNS_4066195613468
* cell instance $313 r0 *1 -149.98,-142.125
X$313 29 30 M2_M1_CDNS_4066195613468
* cell instance $314 r0 *1 -131.605,-142.165
X$314 29 30 M3_M2_CDNS_4066195613473
* cell instance $315 r0 *1 -227.01,-87.255
X$315 31 70 M2_M1_CDNS_4066195613459
* cell instance $316 r0 *1 -227.01,-87.255
X$316 31 70 M3_M2_CDNS_4066195613454
* cell instance $317 r0 *1 -209.265,-64.285
X$317 31 56 M2_M1_CDNS_4066195613421
* cell instance $318 r0 *1 -209.265,-64.285
X$318 31 56 M3_M2_CDNS_4066195613482
* cell instance $319 r0 *1 -193.41,-64.285
X$319 31 57 M2_M1_CDNS_4066195613421
* cell instance $320 r0 *1 -193.41,-64.285
X$320 31 57 M3_M2_CDNS_4066195613482
* cell instance $321 r0 *1 -173.345,-64.285
X$321 31 M2_M1_CDNS_4066195613483
* cell instance $322 r0 *1 -198.45,-138.04
X$322 31 117 M2_M1_CDNS_4066195613475
* cell instance $323 r0 *1 -198.45,-138.04
X$323 31 117 M3_M2_CDNS_4066195613476
* cell instance $324 r0 *1 -175.33,-138.04
X$324 31 147 M2_M1_CDNS_4066195613475
* cell instance $325 r0 *1 -175.33,-138.04
X$325 31 147 M3_M2_CDNS_4066195613476
* cell instance $326 r0 *1 -152.835,-138.04
X$326 31 163 M2_M1_CDNS_4066195613475
* cell instance $327 r0 *1 -152.835,-138.04
X$327 31 163 M3_M2_CDNS_4066195613476
* cell instance $328 r0 *1 -124.59,-138.04
X$328 31 79 M2_M1_CDNS_4066195613487
* cell instance $329 r0 *1 -124.59,-138.04
X$329 31 79 M3_M2_CDNS_40661956134101
* cell instance $330 r0 *1 -199.21,-137.28
X$330 31 127 M2_M1_CDNS_4066195613475
* cell instance $331 r0 *1 -199.21,-137.28
X$331 31 127 M3_M2_CDNS_4066195613476
* cell instance $332 r0 *1 -176.09,-137.28
X$332 31 134 M2_M1_CDNS_4066195613475
* cell instance $333 r0 *1 -176.09,-137.28
X$333 31 134 M3_M2_CDNS_4066195613476
* cell instance $334 r0 *1 -153.595,-137.28
X$334 31 162 M2_M1_CDNS_4066195613475
* cell instance $335 r0 *1 -153.595,-137.28
X$335 31 162 M3_M2_CDNS_4066195613476
* cell instance $336 r0 *1 -125.35,-137.28
X$336 31 86 M2_M1_CDNS_4066195613487
* cell instance $337 r0 *1 -125.35,-137.28
X$337 31 86 M3_M2_CDNS_40661956134101
* cell instance $338 r0 *1 -199.97,-136.52
X$338 31 126 M2_M1_CDNS_4066195613475
* cell instance $339 r0 *1 -199.97,-136.52
X$339 31 126 M3_M2_CDNS_4066195613476
* cell instance $340 r0 *1 -176.85,-136.52
X$340 31 118 M2_M1_CDNS_4066195613475
* cell instance $341 r0 *1 -176.85,-136.52
X$341 31 118 M3_M2_CDNS_4066195613476
* cell instance $342 r0 *1 -154.355,-136.52
X$342 31 140 M2_M1_CDNS_4066195613475
* cell instance $343 r0 *1 -154.355,-136.52
X$343 31 140 M3_M2_CDNS_4066195613476
* cell instance $344 r0 *1 -126.11,-136.52
X$344 31 92 M2_M1_CDNS_4066195613487
* cell instance $345 r0 *1 -126.11,-136.52
X$345 31 92 M3_M2_CDNS_40661956134101
* cell instance $346 r0 *1 -200.73,-135.76
X$346 31 125 M2_M1_CDNS_4066195613475
* cell instance $347 r0 *1 -200.73,-135.76
X$347 31 125 M3_M2_CDNS_4066195613476
* cell instance $348 r0 *1 -177.61,-135.76
X$348 31 139 M2_M1_CDNS_4066195613475
* cell instance $349 r0 *1 -177.61,-135.76
X$349 31 139 M3_M2_CDNS_4066195613476
* cell instance $350 r0 *1 -155.115,-135.76
X$350 31 131 M2_M1_CDNS_4066195613475
* cell instance $351 r0 *1 -155.115,-135.76
X$351 31 131 M3_M2_CDNS_4066195613476
* cell instance $352 r0 *1 -126.87,-135.76
X$352 31 83 M2_M1_CDNS_4066195613487
* cell instance $353 r0 *1 -126.87,-135.76
X$353 31 83 M3_M2_CDNS_40661956134101
* cell instance $354 r0 *1 -201.49,-135
X$354 31 124 M2_M1_CDNS_4066195613475
* cell instance $355 r0 *1 -201.49,-135
X$355 31 124 M3_M2_CDNS_4066195613476
* cell instance $356 r0 *1 -178.37,-135
X$356 31 137 M2_M1_CDNS_4066195613475
* cell instance $357 r0 *1 -178.37,-135
X$357 31 137 M3_M2_CDNS_4066195613476
* cell instance $358 r0 *1 -155.875,-135
X$358 31 130 M2_M1_CDNS_4066195613475
* cell instance $359 r0 *1 -155.875,-135
X$359 31 130 M3_M2_CDNS_4066195613476
* cell instance $360 r0 *1 -127.63,-135
X$360 31 82 M2_M1_CDNS_4066195613487
* cell instance $361 r0 *1 -127.63,-135
X$361 31 82 M3_M2_CDNS_40661956134101
* cell instance $362 r0 *1 -202.25,-134.24
X$362 31 152 M2_M1_CDNS_4066195613475
* cell instance $363 r0 *1 -202.25,-134.24
X$363 31 152 M3_M2_CDNS_4066195613476
* cell instance $364 r0 *1 -179.13,-134.24
X$364 31 146 M2_M1_CDNS_4066195613475
* cell instance $365 r0 *1 -179.13,-134.24
X$365 31 146 M3_M2_CDNS_4066195613476
* cell instance $366 r0 *1 -156.635,-134.24
X$366 31 145 M2_M1_CDNS_4066195613475
* cell instance $367 r0 *1 -156.635,-134.24
X$367 31 145 M3_M2_CDNS_4066195613476
* cell instance $368 r0 *1 -128.39,-134.24
X$368 31 88 M2_M1_CDNS_4066195613487
* cell instance $369 r0 *1 -128.39,-134.24
X$369 31 88 M3_M2_CDNS_40661956134101
* cell instance $370 r0 *1 -203.01,-133.48
X$370 31 123 M2_M1_CDNS_4066195613475
* cell instance $371 r0 *1 -203.01,-133.48
X$371 31 123 M3_M2_CDNS_4066195613476
* cell instance $372 r0 *1 -179.89,-133.48
X$372 31 135 M2_M1_CDNS_4066195613475
* cell instance $373 r0 *1 -179.89,-133.48
X$373 31 135 M3_M2_CDNS_4066195613476
* cell instance $374 r0 *1 -157.395,-133.48
X$374 31 107 M2_M1_CDNS_4066195613475
* cell instance $375 r0 *1 -157.395,-133.48
X$375 31 107 M3_M2_CDNS_4066195613476
* cell instance $376 r0 *1 -129.15,-133.48
X$376 31 89 M2_M1_CDNS_4066195613487
* cell instance $377 r0 *1 -129.15,-133.48
X$377 31 89 M3_M2_CDNS_40661956134101
* cell instance $378 r0 *1 -203.77,-132.72
X$378 31 122 M2_M1_CDNS_4066195613475
* cell instance $379 r0 *1 -203.77,-132.72
X$379 31 122 M3_M2_CDNS_4066195613476
* cell instance $380 r0 *1 -180.65,-132.72
X$380 31 141 M2_M1_CDNS_4066195613475
* cell instance $381 r0 *1 -180.65,-132.72
X$381 31 141 M3_M2_CDNS_4066195613476
* cell instance $382 r0 *1 -158.155,-132.72
X$382 31 108 M2_M1_CDNS_4066195613475
* cell instance $383 r0 *1 -158.155,-132.72
X$383 31 108 M3_M2_CDNS_4066195613476
* cell instance $384 r0 *1 -129.91,-132.72
X$384 31 87 M2_M1_CDNS_4066195613487
* cell instance $385 r0 *1 -129.91,-132.72
X$385 31 87 M3_M2_CDNS_40661956134101
* cell instance $386 r0 *1 -205.29,-131.2
X$386 31 151 M3_M2_CDNS_4066195613476
* cell instance $387 r0 *1 -205.29,-131.2
X$387 31 151 M2_M1_CDNS_4066195613475
* cell instance $388 r0 *1 -204.53,-131.96
X$388 31 150 M2_M1_CDNS_4066195613475
* cell instance $389 r0 *1 -204.53,-131.96
X$389 31 150 M3_M2_CDNS_4066195613476
* cell instance $390 r0 *1 -182.17,-131.2
X$390 31 148 M2_M1_CDNS_4066195613475
* cell instance $391 r0 *1 -182.17,-131.2
X$391 31 148 M3_M2_CDNS_4066195613476
* cell instance $392 r0 *1 -181.41,-131.96
X$392 31 121 M2_M1_CDNS_4066195613475
* cell instance $393 r0 *1 -181.41,-131.96
X$393 31 121 M3_M2_CDNS_4066195613476
* cell instance $394 r0 *1 -159.675,-131.2
X$394 31 109 M2_M1_CDNS_4066195613475
* cell instance $395 r0 *1 -159.675,-131.2
X$395 31 109 M3_M2_CDNS_4066195613476
* cell instance $396 r0 *1 -158.915,-131.96
X$396 31 143 M2_M1_CDNS_4066195613475
* cell instance $397 r0 *1 -158.915,-131.96
X$397 31 143 M3_M2_CDNS_4066195613476
* cell instance $398 r0 *1 -131.43,-131.2
X$398 31 85 M2_M1_CDNS_4066195613487
* cell instance $399 r0 *1 -131.43,-131.2
X$399 31 85 M3_M2_CDNS_40661956134101
* cell instance $400 r0 *1 -130.67,-131.96
X$400 31 84 M2_M1_CDNS_4066195613487
* cell instance $401 r0 *1 -130.67,-131.96
X$401 31 84 M3_M2_CDNS_40661956134101
* cell instance $402 r0 *1 -206.05,-130.44
X$402 31 153 M2_M1_CDNS_4066195613475
* cell instance $403 r0 *1 -206.05,-130.44
X$403 31 153 M3_M2_CDNS_4066195613476
* cell instance $404 r0 *1 -182.93,-130.44
X$404 31 136 M2_M1_CDNS_4066195613475
* cell instance $405 r0 *1 -182.93,-130.44
X$405 31 136 M3_M2_CDNS_4066195613476
* cell instance $406 r0 *1 -160.435,-130.44
X$406 31 110 M2_M1_CDNS_4066195613475
* cell instance $407 r0 *1 -160.435,-130.44
X$407 31 110 M3_M2_CDNS_4066195613476
* cell instance $408 r0 *1 -132.19,-130.44
X$408 31 91 M2_M1_CDNS_4066195613487
* cell instance $409 r0 *1 -132.19,-130.44
X$409 31 91 M3_M2_CDNS_40661956134101
* cell instance $410 r0 *1 -206.81,-129.68
X$410 31 149 M2_M1_CDNS_4066195613475
* cell instance $411 r0 *1 -206.81,-129.68
X$411 31 149 M3_M2_CDNS_4066195613476
* cell instance $412 r0 *1 -183.69,-129.68
X$412 31 119 M2_M1_CDNS_4066195613475
* cell instance $413 r0 *1 -183.69,-129.68
X$413 31 119 M3_M2_CDNS_4066195613476
* cell instance $414 r0 *1 -161.195,-129.68
X$414 31 144 M2_M1_CDNS_4066195613475
* cell instance $415 r0 *1 -161.195,-129.68
X$415 31 144 M3_M2_CDNS_4066195613476
* cell instance $416 r0 *1 -132.95,-129.68
X$416 31 90 M2_M1_CDNS_4066195613487
* cell instance $417 r0 *1 -132.95,-129.68
X$417 31 90 M3_M2_CDNS_40661956134101
* cell instance $418 r0 *1 -207.57,-128.92
X$418 31 129 M2_M1_CDNS_4066195613475
* cell instance $419 r0 *1 -207.57,-128.92
X$419 31 129 M3_M2_CDNS_4066195613476
* cell instance $420 r0 *1 -184.45,-128.92
X$420 31 120 M2_M1_CDNS_4066195613475
* cell instance $421 r0 *1 -184.45,-128.92
X$421 31 120 M3_M2_CDNS_4066195613476
* cell instance $422 r0 *1 -161.955,-128.92
X$422 31 142 M2_M1_CDNS_4066195613475
* cell instance $423 r0 *1 -161.955,-128.92
X$423 31 142 M3_M2_CDNS_4066195613476
* cell instance $424 r0 *1 -133.71,-128.92
X$424 31 80 M2_M1_CDNS_4066195613487
* cell instance $425 r0 *1 -133.71,-128.92
X$425 31 80 M3_M2_CDNS_40661956134101
* cell instance $426 r0 *1 -209.845,-126.405
X$426 33 32 M2_M1_CDNS_4066195613466
* cell instance $427 r0 *1 -118.29,-126.405
X$427 33 32 M2_M1_CDNS_4066195613468
* cell instance $428 r0 *1 -170.2,-126.405
X$428 33 32 M2_M1_CDNS_4066195613468
* cell instance $429 r0 *1 -66.63,-126.405
X$429 33 32 M2_M1_CDNS_4066195613468
* cell instance $430 r0 *1 -209.845,-69.925
X$430 35 34 M2_M1_CDNS_4066195613466
* cell instance $431 r0 *1 -164.12,-80.095
X$431 35 34 M3_M2_CDNS_4066195613485
* cell instance $432 r0 *1 -164.12,-80.095
X$432 35 34 M2_M1_CDNS_4066195613484
* cell instance $433 r0 *1 -181.22,-69.925
X$433 35 34 M3_M2_CDNS_4066195613474
* cell instance $434 r0 *1 -170.2,-69.925
X$434 35 34 M2_M1_CDNS_4066195613468
* cell instance $435 r0 *1 -164.705,-69.925
X$435 35 34 M3_M2_CDNS_4066195613474
* cell instance $436 r0 *1 -118.29,-69.925
X$436 35 34 M2_M1_CDNS_4066195613468
* cell instance $437 r0 *1 -66.63,-69.925
X$437 35 34 M2_M1_CDNS_4066195613468
* cell instance $438 r0 *1 48.175,-38.98
X$438 39 36 M3_M2_CDNS_4066195613427
* cell instance $439 r0 *1 48.175,-38.98
X$439 39 36 M2_M1_CDNS_4066195613432
* cell instance $440 r0 *1 48.275,-14.96
X$440 40 37 M2_M1_CDNS_4066195613432
* cell instance $441 r0 *1 48.275,-14.96
X$441 40 37 M3_M2_CDNS_4066195613427
* cell instance $442 r0 *1 48.215,-54.725
X$442 41 38 M3_M2_CDNS_4066195613427
* cell instance $443 r0 *1 48.215,-54.725
X$443 41 38 M2_M1_CDNS_4066195613432
* cell instance $444 r0 *1 41.385,-7.02
X$444 43 42 M2_M1_CDNS_4066195613457
* cell instance $445 r0 *1 41.385,-7.02
X$445 43 42 M3_M2_CDNS_4066195613422
* cell instance $446 r0 *1 44.345,0.19
X$446 45 44 M2_M1_CDNS_4066195613419
* cell instance $447 r0 *1 44.345,0.19
X$447 45 44 M3_M2_CDNS_4066195613424
* cell instance $448 r0 *1 34.75,-1.885
X$448 47 46 M2_M1_CDNS_4066195613420
* cell instance $449 r0 *1 34.75,-1.885
X$449 47 46 M3_M2_CDNS_4066195613423
* cell instance $450 r0 *1 29.12,-47.045
X$450 49 48 M2_M1_CDNS_4066195613425
* cell instance $451 r0 *1 29.12,-47.045
X$451 49 48 M3_M2_CDNS_4066195613426
* cell instance $452 r0 *1 2.71,0.19
X$452 52 50 M2_M1_CDNS_4066195613428
* cell instance $453 r0 *1 2.71,0.19
X$453 52 50 M3_M2_CDNS_4066195613430
* cell instance $454 r0 *1 26.585,0.19
X$454 53 51 M2_M1_CDNS_4066195613428
* cell instance $455 r0 *1 26.585,0.19
X$455 53 51 M3_M2_CDNS_4066195613430
* cell instance $456 r0 *1 -124.635,-77.375
X$456 55 54 M3_M2_CDNS_4066195613495
* cell instance $457 r0 *1 -124.635,-77.375
X$457 55 54 M2_M1_CDNS_4066195613496
* cell instance $458 r0 *1 -85.075,-90.39
X$458 59 58 M3_M2_CDNS_4066195613499
* cell instance $459 r0 *1 -85.075,-90.39
X$459 59 58 M2_M1_CDNS_40661956134100
* cell instance $460 r0 *1 -100.23,-78.34
X$460 61 60 M3_M2_CDNS_4066195613497
* cell instance $461 r0 *1 -100.23,-78.34
X$461 61 60 M2_M1_CDNS_4066195613498
* cell instance $462 r0 *1 -164.59,-98.275
X$462 64 62 M3_M2_CDNS_4066195613465
* cell instance $463 r0 *1 -164.59,-98.275
X$463 64 62 M2_M1_CDNS_4066195613464
* cell instance $464 r0 *1 -164.135,-109.68
X$464 65 63 M3_M2_CDNS_4066195613465
* cell instance $465 r0 *1 -164.135,-109.68
X$465 65 63 M2_M1_CDNS_4066195613464
* cell instance $466 r0 *1 -209.265,-98.275
X$466 68 66 M3_M2_CDNS_4066195613461
* cell instance $467 r0 *1 -209.265,-98.275
X$467 68 66 M2_M1_CDNS_4066195613460
* cell instance $468 r0 *1 -192.165,-98.275
X$468 69 67 M3_M2_CDNS_4066195613461
* cell instance $469 r0 *1 -192.165,-98.275
X$469 69 67 M2_M1_CDNS_4066195613460
* cell instance $470 r0 *1 -112.415,-110.555
X$470 75 71 M3_M2_CDNS_4066195613462
* cell instance $471 r0 *1 -112.415,-110.555
X$471 75 71 M2_M1_CDNS_4066195613463
* cell instance $472 r0 *1 -136.77,-86.675
X$472 76 72 M3_M2_CDNS_4066195613462
* cell instance $473 r0 *1 -136.77,-86.675
X$473 76 72 M2_M1_CDNS_4066195613463
* cell instance $474 r0 *1 -112.415,-87.825
X$474 77 73 M3_M2_CDNS_4066195613462
* cell instance $475 r0 *1 -112.415,-87.825
X$475 77 73 M2_M1_CDNS_4066195613463
* cell instance $476 r0 *1 -136.83,-109.09
X$476 78 74 M3_M2_CDNS_4066195613462
* cell instance $477 r0 *1 -136.83,-109.09
X$477 78 74 M2_M1_CDNS_4066195613463
* cell instance $478 r0 *1 -134.47,-128.16
X$478 93 81 M2_M1_CDNS_4066195613487
* cell instance $479 r0 *1 -134.47,-128.16
X$479 93 81 M3_M2_CDNS_40661956134101
* cell instance $480 r0 *1 -52.49,-165.09
X$480 95 94 M3_M2_CDNS_4066195613491
* cell instance $481 r0 *1 -52.49,-165.09
X$481 95 94 M2_M1_CDNS_4066195613492
* cell instance $482 r0 *1 -162.715,-128.16
X$482 102 98 M3_M2_CDNS_4066195613477
* cell instance $483 r0 *1 -162.715,-128.16
X$483 102 98 M2_M1_CDNS_4066195613469
* cell instance $484 r0 *1 -185.21,-128.16
X$484 103 99 M3_M2_CDNS_4066195613477
* cell instance $485 r0 *1 -185.21,-128.16
X$485 103 99 M2_M1_CDNS_4066195613469
* cell instance $486 r0 *1 -208.33,-128.16
X$486 104 101 M2_M1_CDNS_4066195613469
* cell instance $487 r0 *1 -208.33,-128.16
X$487 104 101 M3_M2_CDNS_4066195613477
* cell instance $488 r0 *1 -165.735,-170.755
X$488 168 115 M2_M1_CDNS_4066195613475
* cell instance $489 r0 *1 -165.735,-170.755
X$489 168 115 M3_M2_CDNS_4066195613476
* cell instance $490 r0 *1 -166.495,-169.995
X$490 167 166 M3_M2_CDNS_4066195613476
* cell instance $491 r0 *1 -166.495,-169.995
X$491 167 166 M2_M1_CDNS_4066195613475
* cell instance $492 r0 *1 -64.605,-180.695
X$492 175 170 M3_M2_CDNS_4066195613489
* cell instance $493 r0 *1 -64.605,-180.695
X$493 175 170 M2_M1_CDNS_4066195613490
* cell instance $494 r0 *1 -64.605,-158.325
X$494 176 171 M2_M1_CDNS_4066195613490
* cell instance $495 r0 *1 -64.605,-158.325
X$495 176 171 M3_M2_CDNS_4066195613489
* cell instance $496 r0 *1 -40.205,-159.985
X$496 177 172 M2_M1_CDNS_4066195613490
* cell instance $497 r0 *1 -40.205,-159.985
X$497 177 172 M3_M2_CDNS_4066195613489
* cell instance $498 r0 *1 -92.095,-153.39
X$498 178 173 M2_M1_CDNS_4066195613490
* cell instance $499 r0 *1 -92.095,-153.39
X$499 178 173 M3_M2_CDNS_4066195613489
* cell instance $500 r0 *1 -40.39,-182.515
X$500 179 174 M3_M2_CDNS_4066195613489
* cell instance $501 r0 *1 -40.39,-182.515
X$501 179 174 M2_M1_CDNS_4066195613490
* cell instance $502 r0 *1 -27.95,-187.26
X$502 183 180 M2_M1_CDNS_4066195613494
* cell instance $503 r0 *1 -27.95,-187.26
X$503 183 180 M3_M2_CDNS_4066195613493
* cell instance $504 r0 *1 -52.49,-149.245
X$504 184 181 M2_M1_CDNS_4066195613494
* cell instance $505 r0 *1 -52.49,-149.245
X$505 184 181 M3_M2_CDNS_4066195613493
* cell instance $506 r0 *1 -27.95,-149.245
X$506 185 182 M2_M1_CDNS_4066195613494
* cell instance $507 r0 *1 -27.95,-149.245
X$507 185 182 M3_M2_CDNS_4066195613493
* cell instance $508 r0 *1 -40.55,-232.115
X$508 187 186 M3_M2_CDNS_40661956134105
* cell instance $509 r0 *1 -40.55,-232.115
X$509 187 186 M2_M1_CDNS_40661956134104
* cell instance $510 r0 *1 -82.115,-232.115
X$510 189 188 M3_M2_CDNS_40661956134106
* cell instance $511 r0 *1 -82.115,-232.115
X$511 189 188 M2_M1_CDNS_40661956134107
* cell instance $512 r0 *1 -58.54,-250.875
X$512 207 193 M3_M2_CDNS_40661956134103
* cell instance $513 r0 *1 -58.54,-250.875
X$513 207 193 M2_M1_CDNS_40661956134102
* cell instance $514 r0 *1 -149.81,-161.15
X$514 208 194 M2_M1_CDNS_40661956134102
* cell instance $515 r0 *1 -149.81,-161.15
X$515 208 194 M3_M2_CDNS_40661956134103
* cell instance $516 r0 *1 -99.44,-215.98
X$516 209 195 M2_M1_CDNS_40661956134102
* cell instance $517 r0 *1 -99.44,-215.98
X$517 209 195 M3_M2_CDNS_40661956134103
* cell instance $518 r0 *1 -123.75,-188.905
X$518 210 196 M2_M1_CDNS_40661956134102
* cell instance $519 r0 *1 -123.75,-188.905
X$519 210 196 M3_M2_CDNS_40661956134103
* cell instance $520 r0 *1 -110.245,-178.38
X$520 211 197 M2_M1_CDNS_40661956134102
* cell instance $521 r0 *1 -110.245,-178.38
X$521 211 197 M3_M2_CDNS_40661956134103
* cell instance $522 r0 *1 -58.54,-231.875
X$522 212 198 M2_M1_CDNS_40661956134102
* cell instance $523 r0 *1 -58.54,-231.875
X$523 212 198 M3_M2_CDNS_40661956134103
* cell instance $524 r0 *1 -73.37,-241.005
X$524 213 199 M2_M1_CDNS_40661956134102
* cell instance $525 r0 *1 -73.37,-241.005
X$525 213 199 M3_M2_CDNS_40661956134103
* cell instance $526 r0 *1 -87.25,-223.4
X$526 214 200 M2_M1_CDNS_40661956134102
* cell instance $527 r0 *1 -87.25,-223.4
X$527 214 200 M3_M2_CDNS_40661956134103
* cell instance $528 r0 *1 -162.005,-152.5
X$528 215 201 M3_M2_CDNS_40661956134103
* cell instance $529 r0 *1 -162.005,-152.5
X$529 215 201 M2_M1_CDNS_40661956134102
* cell instance $530 r0 *1 -137.585,-178.38
X$530 216 202 M3_M2_CDNS_40661956134103
* cell instance $531 r0 *1 -137.585,-178.38
X$531 216 202 M2_M1_CDNS_40661956134102
* cell instance $532 r0 *1 -137.585,-152.5
X$532 217 203 M3_M2_CDNS_40661956134103
* cell instance $533 r0 *1 -137.585,-152.5
X$533 217 203 M2_M1_CDNS_40661956134102
* cell instance $534 r0 *1 -46.41,-250.875
X$534 218 204 M3_M2_CDNS_40661956134103
* cell instance $535 r0 *1 -46.41,-250.875
X$535 218 204 M2_M1_CDNS_40661956134102
* cell instance $536 r0 *1 -34.23,-250.875
X$536 219 205 M3_M2_CDNS_40661956134103
* cell instance $537 r0 *1 -34.23,-250.875
X$537 219 205 M2_M1_CDNS_40661956134102
* cell instance $538 r0 *1 -72.645,-215.98
X$538 220 206 M3_M2_CDNS_40661956134103
* cell instance $539 r0 *1 -72.645,-215.98
X$539 220 206 M2_M1_CDNS_40661956134102
.ENDS moscap_routing

* cell M1_PSUB_CDNS_406619561340
* pin
* pin
.SUBCKT M1_PSUB_CDNS_406619561340 1 2
.ENDS M1_PSUB_CDNS_406619561340

* cell M1_PSUB_CDNS_406619561344
* pin
* pin
.SUBCKT M1_PSUB_CDNS_406619561344 1 2
.ENDS M1_PSUB_CDNS_406619561344

* cell M1_PSUB_CDNS_406619561341
* pin
* pin
.SUBCKT M1_PSUB_CDNS_406619561341 1 2
.ENDS M1_PSUB_CDNS_406619561341

* cell M1_PSUB_CDNS_406619561342
* pin
* pin
.SUBCKT M1_PSUB_CDNS_406619561342 1 2
.ENDS M1_PSUB_CDNS_406619561342

* cell M3_M2_CDNS_406619561347
* pin
* pin
.SUBCKT M3_M2_CDNS_406619561347 1 2
.ENDS M3_M2_CDNS_406619561347

* cell M1_PSUB_CDNS_406619561343
* pin
* pin
.SUBCKT M1_PSUB_CDNS_406619561343 1 2
.ENDS M1_PSUB_CDNS_406619561343

* cell M1_PSUB_CDNS_406619561345
* pin
* pin
.SUBCKT M1_PSUB_CDNS_406619561345 1 2
.ENDS M1_PSUB_CDNS_406619561345

* cell M3_M2_CDNS_406619561346
* pin
* pin
.SUBCKT M3_M2_CDNS_406619561346 1 2
.ENDS M3_M2_CDNS_406619561346

* cell M2_M1_CDNS_40661956134437
* pin
* pin
.SUBCKT M2_M1_CDNS_40661956134437 1 2
.ENDS M2_M1_CDNS_40661956134437

* cell M3_M2_CDNS_40661956134438
* pin
* pin
.SUBCKT M3_M2_CDNS_40661956134438 1 2
.ENDS M3_M2_CDNS_40661956134438

* cell M1_PACTIVE_CDNS_40661956134440
* pin
* pin
.SUBCKT M1_PACTIVE_CDNS_40661956134440 1 2
.ENDS M1_PACTIVE_CDNS_40661956134440

* cell M1_PACTIVE_CDNS_40661956134439
* pin
* pin
.SUBCKT M1_PACTIVE_CDNS_40661956134439 1 2
.ENDS M1_PACTIVE_CDNS_40661956134439

* cell M3_M2_CDNS_40661956134180
* pin
* pin
.SUBCKT M3_M2_CDNS_40661956134180 1 2
.ENDS M3_M2_CDNS_40661956134180

* cell M1_PSUB_CDNS_40661956134442
* pin
.SUBCKT M1_PSUB_CDNS_40661956134442 1
.ENDS M1_PSUB_CDNS_40661956134442

* cell M3_M2_CDNS_40661956134304
* pin
* pin
.SUBCKT M3_M2_CDNS_40661956134304 1 2
.ENDS M3_M2_CDNS_40661956134304

* cell M3_M2_CDNS_40661956134292
* pin
* pin
.SUBCKT M3_M2_CDNS_40661956134292 1 2
.ENDS M3_M2_CDNS_40661956134292

* cell M2_M1_CDNS_40661956134269
* pin
* pin
.SUBCKT M2_M1_CDNS_40661956134269 1 2
.ENDS M2_M1_CDNS_40661956134269

* cell M2_M1_CDNS_40661956134289
* pin
* pin
.SUBCKT M2_M1_CDNS_40661956134289 1 2
.ENDS M2_M1_CDNS_40661956134289

* cell ppolyf_u_CDNS_4066195613451
* pin
* pin
* pin gf180mcu_gnd
.SUBCKT ppolyf_u_CDNS_4066195613451 1 2 3
* net 3 gf180mcu_gnd
* device instance $1 r0 *1 2.46,0.4 ppolyf_u
R$1 2 1 3 1706.25 ppolyf_u L=3.9U W=0.8U
.ENDS ppolyf_u_CDNS_4066195613451

* cell M1_NWELL_CDNS_40661956134480
* pin
* pin
* pin
* pin
.SUBCKT M1_NWELL_CDNS_40661956134480 1 2 3 4
.ENDS M1_NWELL_CDNS_40661956134480

* cell M3_M2_CDNS_40661956134314
* pin
* pin
.SUBCKT M3_M2_CDNS_40661956134314 1 2
.ENDS M3_M2_CDNS_40661956134314

* cell M2_M1_CDNS_40661956134283
* pin
* pin
.SUBCKT M2_M1_CDNS_40661956134283 1 2
.ENDS M2_M1_CDNS_40661956134283

* cell M2_M1_CDNS_40661956134432
* pin
* pin
.SUBCKT M2_M1_CDNS_40661956134432 1 2
.ENDS M2_M1_CDNS_40661956134432

* cell M3_M2_CDNS_40661956134435
* pin
* pin
.SUBCKT M3_M2_CDNS_40661956134435 1 2
.ENDS M3_M2_CDNS_40661956134435

* cell M2_M1_CDNS_40661956134481
* pin
* pin
.SUBCKT M2_M1_CDNS_40661956134481 1 2
.ENDS M2_M1_CDNS_40661956134481

* cell M2_M1_CDNS_40661956134318
* pin
* pin
.SUBCKT M2_M1_CDNS_40661956134318 1 2
.ENDS M2_M1_CDNS_40661956134318

* cell M3_M2_CDNS_40661956134317
* pin
* pin
.SUBCKT M3_M2_CDNS_40661956134317 1 2
.ENDS M3_M2_CDNS_40661956134317

* cell M3_M2_CDNS_40661956134311
* pin
* pin
.SUBCKT M3_M2_CDNS_40661956134311 1 2
.ENDS M3_M2_CDNS_40661956134311

* cell M3_M2_CDNS_40661956134310
* pin
* pin
.SUBCKT M3_M2_CDNS_40661956134310 1 2
.ENDS M3_M2_CDNS_40661956134310

* cell M2_M1_CDNS_40661956134309
* pin
* pin
.SUBCKT M2_M1_CDNS_40661956134309 1 2
.ENDS M2_M1_CDNS_40661956134309

* cell M2_M1_CDNS_40661956134299
* pin
* pin
.SUBCKT M2_M1_CDNS_40661956134299 1 2
.ENDS M2_M1_CDNS_40661956134299

* cell M3_M2_CDNS_40661956134297
* pin
* pin
.SUBCKT M3_M2_CDNS_40661956134297 1 2
.ENDS M3_M2_CDNS_40661956134297

* cell M3_M2_CDNS_40661956134306
* pin
* pin
.SUBCKT M3_M2_CDNS_40661956134306 1 2
.ENDS M3_M2_CDNS_40661956134306

* cell M3_M2_CDNS_40661956134303
* pin
* pin
.SUBCKT M3_M2_CDNS_40661956134303 1 2
.ENDS M3_M2_CDNS_40661956134303

* cell M3_M2_CDNS_40661956134301
* pin
* pin
.SUBCKT M3_M2_CDNS_40661956134301 1 2
.ENDS M3_M2_CDNS_40661956134301

* cell M3_M2_CDNS_40661956134300
* pin
* pin
.SUBCKT M3_M2_CDNS_40661956134300 1 2
.ENDS M3_M2_CDNS_40661956134300

* cell M2_M1_CDNS_40661956134293
* pin
* pin
.SUBCKT M2_M1_CDNS_40661956134293 1 2
.ENDS M2_M1_CDNS_40661956134293

* cell M2_M1_CDNS_40661956134302
* pin
* pin
.SUBCKT M2_M1_CDNS_40661956134302 1 2
.ENDS M2_M1_CDNS_40661956134302

* cell M2_M1_CDNS_40661956134291
* pin
* pin
.SUBCKT M2_M1_CDNS_40661956134291 1 2
.ENDS M2_M1_CDNS_40661956134291

* cell M3_M2_CDNS_40661956134433
* pin
* pin
.SUBCKT M3_M2_CDNS_40661956134433 1 2
.ENDS M3_M2_CDNS_40661956134433

* cell M3_M2_CDNS_40661956134294
* pin
* pin
.SUBCKT M3_M2_CDNS_40661956134294 1 2
.ENDS M3_M2_CDNS_40661956134294

* cell M2_M1_CDNS_40661956134277
* pin
* pin
.SUBCKT M2_M1_CDNS_40661956134277 1 2
.ENDS M2_M1_CDNS_40661956134277

* cell M2_M1_CDNS_40661956134434
* pin
.SUBCKT M2_M1_CDNS_40661956134434 1
.ENDS M2_M1_CDNS_40661956134434

* cell M2_M1_CDNS_40661956134436
* pin
* pin
.SUBCKT M2_M1_CDNS_40661956134436 1 2
.ENDS M2_M1_CDNS_40661956134436

* cell M3_M2_CDNS_40661956134284
* pin
* pin
.SUBCKT M3_M2_CDNS_40661956134284 1 2
.ENDS M3_M2_CDNS_40661956134284

* cell M3_M2_CDNS_40661956134280
* pin
* pin
.SUBCKT M3_M2_CDNS_40661956134280 1 2
.ENDS M3_M2_CDNS_40661956134280

* cell M3_M2_CDNS_40661956134278
* pin
* pin
.SUBCKT M3_M2_CDNS_40661956134278 1 2
.ENDS M3_M2_CDNS_40661956134278

* cell M3_M2_CDNS_40661956134276
* pin
* pin
.SUBCKT M3_M2_CDNS_40661956134276 1 2
.ENDS M3_M2_CDNS_40661956134276

* cell M1_PACTIVE_CDNS_40661956134273
* pin
* pin
.SUBCKT M1_PACTIVE_CDNS_40661956134273 1 2
.ENDS M1_PACTIVE_CDNS_40661956134273

* cell M1_PACTIVE_CDNS_40661956134272
* pin
* pin
.SUBCKT M1_PACTIVE_CDNS_40661956134272 1 2
.ENDS M1_PACTIVE_CDNS_40661956134272

* cell M2_M1_CDNS_40661956134275
* pin
* pin
.SUBCKT M2_M1_CDNS_40661956134275 1 2
.ENDS M2_M1_CDNS_40661956134275

* cell M2_M1_CDNS_40661956134279
* pin
* pin
.SUBCKT M2_M1_CDNS_40661956134279 1 2
.ENDS M2_M1_CDNS_40661956134279

* cell M1_PSUB_CDNS_40661956134319
* pin
.SUBCKT M1_PSUB_CDNS_40661956134319 1
.ENDS M1_PSUB_CDNS_40661956134319

* cell comp018green_out_sigbuf_a
* pin VSS
* pin AB
* pin VDD
* pin
* pin
* pin
* pin
* pin
* pin
* pin A
* pin DVSS
* pin DVDD
* pin OE
* pin
* pin
* pin gf180mcu_gnd
.SUBCKT comp018green_out_sigbuf_a 1 2 3 6 7 8 9 10 11 12 13 14 15 17 18 19
* net 1 VSS
* net 2 AB
* net 3 VDD
* net 12 A
* net 13 DVSS
* net 14 DVDD
* net 15 OE
* net 19 gf180mcu_gnd
* cell instance $1 m0 *1 2.405,0.225
X$1 1 6 M1_PSUB_CDNS_40661956134375
* cell instance $2 m0 *1 4.585,2.34
X$2 1 6 M1_PSUB_CDNS_40661956134332
* cell instance $3 m0 *1 0.225,2.575
X$3 1 6 M1_PSUB_CDNS_40661956134330
* cell instance $4 r0 *1 1.43,1.35
X$4 23 1 16 15 nmos_6p0_CDNS_4066195613411
* cell instance $5 r0 *1 10.785,6.79
X$5 20 14 2 5 10 17 pmos_6p0_CDNS_4066195613413
* cell instance $6 r0 *1 10.785,1.35
X$6 22 13 2 5 nmos_6p0_CDNS_4066195613411
* cell instance $7 r0 *1 2.405,13.915
X$7 3 9 11 18 M1_NWELL_CDNS_40661956134376
* cell instance $8 r0 *1 0.225,10.39
X$8 3 9 11 18 M1_NWELL_CDNS_40661956134327
* cell instance $9 r0 *1 4.585,10.39
X$9 3 9 11 18 M1_NWELL_CDNS_40661956134327
* cell instance $10 m90 *1 3.35,9.79
X$10 21 3 4 12 11 18 pmos_6p0_CDNS_4066195613412
* cell instance $11 r0 *1 1.43,9.79
X$11 21 3 4 15 11 18 pmos_6p0_CDNS_4066195613412
* cell instance $12 r0 *1 9.565,6.79
X$12 20 5 14 4 10 17 pmos_6p0_CDNS_4066195613413
* cell instance $13 r0 *1 8.695,5.54
X$13 4 M1_POLY2_CDNS_40661956134326
* cell instance $14 r0 *1 9.565,1.35
X$14 22 5 13 4 nmos_6p0_CDNS_4066195613411
* cell instance $15 r0 *1 2.65,1.35
X$15 23 16 4 12 nmos_6p0_CDNS_4066195613411
* cell instance $16 r0 *1 11.095,5.54
X$16 5 M1_POLY2_CDNS_40661956134326
* cell instance $17 m0 *1 7.565,2.34
X$17 13 7 M1_PSUB_CDNS_40661956134332
* cell instance $18 m0 *1 10.215,0.225
X$18 13 7 M1_PSUB_CDNS_40661956134325
* cell instance $19 m0 *1 12.865,2.575
X$19 13 7 M1_PSUB_CDNS_40661956134330
* cell instance $20 r0 *1 10.215,13.915
X$20 14 8 10 17 M1_NWELL_CDNS_40661956134329
* cell instance $21 r0 *1 12.865,10.39
X$21 14 8 10 17 M1_NWELL_CDNS_40661956134327
* cell instance $22 r0 *1 7.565,10.39
X$22 14 8 10 17 M1_NWELL_CDNS_40661956134327
* cell instance $23 m90 *1 3,7.335
X$23 12 M1_POLY2_CDNS_40661956134326
* cell instance $24 m90 *1 1.78,7.335
X$24 15 M1_POLY2_CDNS_40661956134326
* device instance $1 r0 *1 9.915,9.79 pmos_6p0
M$1 14 4 5 17 pmos_6p0 L=0.7U W=6U AS=2.64P AD=1.56P PS=12.88U PD=6.52U
* device instance $2 r0 *1 11.135,9.79 pmos_6p0
M$2 2 5 14 17 pmos_6p0 L=0.7U W=6U AS=1.56P AD=2.64P PS=6.52U PD=12.88U
* device instance $3 r0 *1 1.78,11.29 pmos_6p0
M$3 4 15 3 18 pmos_6p0 L=0.7U W=3U AS=1.32P AD=0.78P PS=6.88U PD=3.52U
* device instance $4 r0 *1 3,11.29 pmos_6p0
M$4 3 12 4 18 pmos_6p0 L=0.7U W=3U AS=0.78P AD=1.32P PS=3.52U PD=6.88U
* device instance $5 r0 *1 9.915,2.85 nmos_6p0
M$5 13 4 5 19 nmos_6p0 L=0.7U W=3U AS=1.32P AD=0.78P PS=6.88U PD=3.52U
* device instance $6 r0 *1 11.135,2.85 nmos_6p0
M$6 2 5 13 19 nmos_6p0 L=0.7U W=3U AS=0.78P AD=1.32P PS=3.52U PD=6.88U
* device instance $7 r0 *1 1.78,2.85 nmos_6p0
M$7 16 15 1 19 nmos_6p0 L=0.7U W=3U AS=1.32P AD=0.78P PS=6.88U PD=3.52U
* device instance $8 r0 *1 3,2.85 nmos_6p0
M$8 4 12 16 19 nmos_6p0 L=0.7U W=3U AS=0.78P AD=1.32P PS=3.52U PD=6.88U
.ENDS comp018green_out_sigbuf_a

* cell comp018green_sigbuf_1
* pin Z
* pin VSS
* pin ZB
* pin DVDD
* pin
* pin
* pin
* pin DVSS
* pin A
* pin VDD
* pin
* pin gf180mcu_gnd
.SUBCKT comp018green_sigbuf_1 1 2 3 5 6 9 10 12 13 14 15 16
* net 1 Z
* net 2 VSS
* net 3 ZB
* net 5 DVDD
* net 12 DVSS
* net 13 A
* net 14 VDD
* net 16 gf180mcu_gnd
* cell instance $1 r0 *1 10.465,8.11
X$1 17 3 5 5 1 1 11 5 pmos_6p0_CDNS_4066195613429
* cell instance $2 r0 *1 8.025,8.11
X$2 17 1 5 5 4 4 11 5 pmos_6p0_CDNS_4066195613429
* cell instance $3 r0 *1 10.465,1.77
X$3 18 3 12 12 1 1 nmos_6p0_CDNS_4066195613431
* cell instance $4 r0 *1 8.025,1.77
X$4 18 1 12 12 4 4 nmos_6p0_CDNS_4066195613431
* cell instance $5 r0 *1 10.765,5.485
X$5 1 M1_POLY2_CDNS_40661956134326
* cell instance $6 m0 *1 3.645,2.34
X$6 2 6 M1_PSUB_CDNS_40661956134332
* cell instance $7 m0 *1 1.935,0.225
X$7 2 6 M1_PSUB_CDNS_40661956134341
* cell instance $8 r0 *1 1.585,1.77
X$8 2 4 13 nmos_6p0_CDNS_4066195613430
* cell instance $9 m0 *1 0.225,2.575
X$9 2 6 M1_PSUB_CDNS_40661956134330
* cell instance $10 r0 *1 8.325,5.485
X$10 4 M1_POLY2_CDNS_40661956134326
* cell instance $11 r0 *1 1.585,8.11
X$11 19 14 4 13 10 15 pmos_6p0_CDNS_4066195613412
* cell instance $12 r0 *1 10.215,13.915
X$12 5 8 11 5 M1_NWELL_CDNS_40661956134378
* cell instance $13 r0 *1 13.805,10.39
X$13 5 8 11 5 M1_NWELL_CDNS_40661956134327
* cell instance $14 r0 *1 6.625,10.39
X$14 5 8 11 5 M1_NWELL_CDNS_40661956134327
* cell instance $15 m0 *1 10.215,0.225
X$15 12 7 M1_PSUB_CDNS_40661956134379
* cell instance $16 m0 *1 6.625,2.34
X$16 12 7 M1_PSUB_CDNS_40661956134332
* cell instance $17 m0 *1 13.805,2.575
X$17 12 7 M1_PSUB_CDNS_40661956134330
* cell instance $18 r0 *1 3.645,10.39
X$18 14 9 10 15 M1_NWELL_CDNS_40661956134327
* cell instance $19 r0 *1 0.225,10.39
X$19 14 9 10 15 M1_NWELL_CDNS_40661956134327
* cell instance $20 r0 *1 1.935,13.915
X$20 14 9 10 15 M1_NWELL_CDNS_40661956134377
* cell instance $21 r0 *1 1.885,5.485
X$21 13 M1_POLY2_CDNS_40661956134326
* device instance $1 r0 *1 8.375,9.61 pmos_6p0
M$1 1 4 5 5 pmos_6p0 L=0.7U W=3U AS=1.32P AD=0.78P PS=6.88U PD=3.52U
* device instance $2 r0 *1 9.595,9.61 pmos_6p0
M$2 5 4 1 5 pmos_6p0 L=0.7U W=3U AS=0.78P AD=0.78P PS=3.52U PD=3.52U
* device instance $3 r0 *1 10.815,9.61 pmos_6p0
M$3 3 1 5 5 pmos_6p0 L=0.7U W=3U AS=0.78P AD=0.78P PS=3.52U PD=3.52U
* device instance $4 r0 *1 12.035,9.61 pmos_6p0
M$4 5 1 3 5 pmos_6p0 L=0.7U W=3U AS=0.78P AD=1.32P PS=3.52U PD=6.88U
* device instance $5 r0 *1 1.935,9.61 pmos_6p0
M$5 4 13 14 15 pmos_6p0 L=0.7U W=3U AS=1.32P AD=1.32P PS=6.88U PD=6.88U
* device instance $6 r0 *1 8.375,2.52 nmos_6p0
M$6 1 4 12 16 nmos_6p0 L=0.7U W=1.5U AS=0.66P AD=0.39P PS=3.88U PD=2.02U
* device instance $7 r0 *1 9.595,2.52 nmos_6p0
M$7 12 4 1 16 nmos_6p0 L=0.7U W=1.5U AS=0.39P AD=0.39P PS=2.02U PD=2.02U
* device instance $8 r0 *1 10.815,2.52 nmos_6p0
M$8 3 1 12 16 nmos_6p0 L=0.7U W=1.5U AS=0.39P AD=0.39P PS=2.02U PD=2.02U
* device instance $9 r0 *1 12.035,2.52 nmos_6p0
M$9 12 1 3 16 nmos_6p0 L=0.7U W=1.5U AS=0.39P AD=0.66P PS=2.02U PD=3.88U
* device instance $10 r0 *1 1.935,2.52 nmos_6p0
M$10 4 13 2 16 nmos_6p0 L=0.7U W=1.5U AS=0.66P AD=0.66P PS=3.88U PD=3.88U
.ENDS comp018green_sigbuf_1

* cell M3_M2_CDNS_40661956134308
* pin
* pin
.SUBCKT M3_M2_CDNS_40661956134308 1 2
.ENDS M3_M2_CDNS_40661956134308

* cell M3_M2_CDNS_40661956134298
* pin
* pin
.SUBCKT M3_M2_CDNS_40661956134298 1 2
.ENDS M3_M2_CDNS_40661956134298

* cell M3_M2_CDNS_40661956134290
* pin
* pin
.SUBCKT M3_M2_CDNS_40661956134290 1 2
.ENDS M3_M2_CDNS_40661956134290

* cell M1_PACTIVE_CDNS_40661956134271
* pin
* pin
.SUBCKT M1_PACTIVE_CDNS_40661956134271 1 2
.ENDS M1_PACTIVE_CDNS_40661956134271

* cell M2_M1_CDNS_40661956134307
* pin
* pin
.SUBCKT M2_M1_CDNS_40661956134307 1 2
.ENDS M2_M1_CDNS_40661956134307

* cell nmoscap_6p0_CDNS_4066195613422
* pin
* pin
.SUBCKT nmoscap_6p0_CDNS_4066195613422 1 2
* device instance $1 r0 *1 1.5,1.5 nmoscap_6p0
C$1 1 2 2.07e-14 nmoscap_6p0 A=9P P=12U
.ENDS nmoscap_6p0_CDNS_4066195613422

* cell M2_M1_CDNS_40661956134281
* pin
* pin
.SUBCKT M2_M1_CDNS_40661956134281 1 2
.ENDS M2_M1_CDNS_40661956134281

* cell comp018green_out_sigbuf_oe
* pin
* pin ENB
* pin EN
* pin OE
* pin
* pin
* pin
* pin
* pin
* pin
* pin
* pin PDRV
* pin VDD
* pin VSS
* pin DVDD
* pin DVSS
* pin
* pin
* pin gf180mcu_gnd
.SUBCKT comp018green_out_sigbuf_oe 1 2 3 5 6 7 8 9 10 11 14 15 16 17 18 19 21
+ 22 23
* net 2 ENB
* net 3 EN
* net 5 OE
* net 15 PDRV
* net 16 VDD
* net 17 VSS
* net 18 DVDD
* net 19 DVSS
* net 23 gf180mcu_gnd
* cell instance $1 r90 *1 5.765,0.505
X$1 5 1 M2_M1_CDNS_40661956134237
* cell instance $2 r0 *1 3.34,7.33
X$2 5 1 M2_M1_CDNS_40661956134270
* cell instance $3 m90 *1 11.915,6.79
X$3 24 2 18 3 11 22 pmos_6p0_CDNS_4066195613413
* cell instance $4 r0 *1 11.215,1.35
X$4 27 19 2 3 nmos_6p0_CDNS_4066195613411
* cell instance $5 m90 *1 10.695,6.79
X$5 24 18 3 4 11 22 pmos_6p0_CDNS_4066195613413
* cell instance $6 r0 *1 11.525,5.54
X$6 3 M1_POLY2_CDNS_40661956134326
* cell instance $7 r0 *1 9.995,1.35
X$7 27 3 19 4 nmos_6p0_CDNS_4066195613411
* cell instance $8 r0 *1 9.125,5.54
X$8 4 M1_POLY2_CDNS_40661956134326
* cell instance $9 r0 *1 2.99,9.79
X$9 25 4 16 5 10 21 pmos_6p0_CDNS_4066195613412
* cell instance $10 r0 *1 1.77,9.79
X$10 25 16 4 15 10 21 pmos_6p0_CDNS_4066195613412
* cell instance $11 m90 *1 3.69,1.35
X$11 26 4 20 5 nmos_6p0_CDNS_4066195613411
* cell instance $12 r180 *1 9.295,-1.995
X$12 17 5 pn_6p0_CDNS_4066195613410
* cell instance $13 m90 *1 3.34,7.335
X$13 5 M1_POLY2_CDNS_40661956134326
* cell instance $14 m0 *1 8.035,2.34
X$14 19 6 M1_PSUB_CDNS_40661956134332
* cell instance $15 m0 *1 10.685,0.225
X$15 19 6 M1_PSUB_CDNS_40661956134325
* cell instance $16 m0 *1 13.335,2.575
X$16 19 6 M1_PSUB_CDNS_40661956134330
* cell instance $17 r0 *1 8.035,10.39
X$17 18 7 11 22 M1_NWELL_CDNS_40661956134327
* cell instance $18 r0 *1 13.335,10.39
X$18 18 7 11 22 M1_NWELL_CDNS_40661956134327
* cell instance $19 r0 *1 10.685,13.915
X$19 18 7 11 22 M1_NWELL_CDNS_40661956134329
* cell instance $20 r0 *1 0.225,10.39
X$20 16 8 10 21 M1_NWELL_CDNS_40661956134327
* cell instance $21 r0 *1 5.055,10.39
X$21 16 8 10 21 M1_NWELL_CDNS_40661956134327
* cell instance $22 r0 *1 2.64,13.915
X$22 16 8 10 21 M1_NWELL_CDNS_40661956134322
* cell instance $23 m0 *1 5.055,2.34
X$23 17 9 M1_PSUB_CDNS_40661956134332
* cell instance $24 m0 *1 2.64,0.225
X$24 17 9 M1_PSUB_CDNS_40661956134328
* cell instance $25 m0 *1 0.225,2.575
X$25 17 9 M1_PSUB_CDNS_40661956134330
* cell instance $26 r0 *1 4.665,-2.235
X$26 17 12 M2_M1_CDNS_40661956134331
* cell instance $27 r0 *1 4.775,0.245
X$27 17 12 M2_M1_CDNS_40661956134237
* cell instance $28 r0 *1 4.925,-3.825
X$28 17 12 M2_M1_CDNS_40661956134237
* cell instance $29 r0 *1 9.055,-2.235
X$29 17 13 M2_M1_CDNS_40661956134331
* cell instance $30 r0 *1 9.315,-3.825
X$30 17 13 M2_M1_CDNS_40661956134237
* cell instance $31 r0 *1 2.12,7.33
X$31 15 14 M2_M1_CDNS_40661956134270
* cell instance $32 r0 *1 2.12,-1.605
X$32 15 14 M2_M1_CDNS_40661956134270
* cell instance $33 r180 *1 4.905,-1.995
X$33 17 15 pn_6p0_CDNS_4066195613410
* cell instance $34 m90 *1 2.12,7.335
X$34 15 M1_POLY2_CDNS_40661956134326
* cell instance $35 m90 *1 2.47,1.35
X$35 26 20 17 15 nmos_6p0_CDNS_4066195613411
* device instance $1 r0 *1 10.345,9.79 pmos_6p0
M$1 18 4 3 22 pmos_6p0 L=0.7U W=6U AS=2.64P AD=1.56P PS=12.88U PD=6.52U
* device instance $2 r0 *1 11.565,9.79 pmos_6p0
M$2 2 3 18 22 pmos_6p0 L=0.7U W=6U AS=1.56P AD=2.64P PS=6.52U PD=12.88U
* device instance $3 r0 *1 2.12,11.29 pmos_6p0
M$3 4 15 16 21 pmos_6p0 L=0.7U W=3U AS=1.32P AD=0.78P PS=6.88U PD=3.52U
* device instance $4 r0 *1 3.34,11.29 pmos_6p0
M$4 16 5 4 21 pmos_6p0 L=0.7U W=3U AS=0.78P AD=1.32P PS=3.52U PD=6.88U
* device instance $5 r0 *1 10.345,2.85 nmos_6p0
M$5 19 4 3 23 nmos_6p0 L=0.7U W=3U AS=1.32P AD=0.78P PS=6.88U PD=3.52U
* device instance $6 r0 *1 11.565,2.85 nmos_6p0
M$6 2 3 19 23 nmos_6p0 L=0.7U W=3U AS=0.78P AD=1.32P PS=3.52U PD=6.88U
* device instance $7 r0 *1 2.12,2.85 nmos_6p0
M$7 20 15 17 23 nmos_6p0 L=0.7U W=3U AS=1.32P AD=0.78P PS=6.88U PD=3.52U
* device instance $8 r0 *1 3.34,2.85 nmos_6p0
M$8 4 5 20 23 nmos_6p0 L=0.7U W=3U AS=0.78P AD=1.32P PS=3.52U PD=6.88U
.ENDS comp018green_out_sigbuf_oe

* cell comp018green_out_predrv
* pin DVSS
* pin PDRIVE_X
* pin
* pin ENB
* pin EN
* pin A
* pin
* pin PDRIVE_Y
* pin SLB
* pin NDRIVE_X
* pin NDRIVE_Y
* pin
* pin DVDD
* pin
* pin SL
* pin
* pin
* pin
* pin gf180mcu_gnd
* pin
* pin
.SUBCKT comp018green_out_predrv 1 3 4 6 7 8 9 10 11 12 13 14 15 17 18 20 21 22
+ 25 31 32
* net 1 DVSS
* net 3 PDRIVE_X
* net 6 ENB
* net 7 EN
* net 8 A
* net 10 PDRIVE_Y
* net 11 SLB
* net 12 NDRIVE_X
* net 13 NDRIVE_Y
* net 15 DVDD
* net 18 SL
* net 25 gf180mcu_gnd
* cell instance $1 r0 *1 0.225,4.69
X$1 1 4 M1_PSUB_CDNS_40661956134342
* cell instance $2 r0 *1 8.985,0.225
X$2 1 4 M1_PSUB_CDNS_40661956134336
* cell instance $3 r0 *1 17.745,6.57
X$3 1 4 M1_PSUB_CDNS_40661956134338
* cell instance $4 m90 *1 4.815,11.44
X$4 13 12 1 20 21 pmos_6p0_CDNS_4066195613417
* cell instance $5 r0 *1 3.855,9.575
X$5 1 4 M1_PSUB_CDNS_40661956134339
* cell instance $6 m90 *1 3.595,1.35
X$6 30 12 1 1 5 5 nmos_6p0_CDNS_4066195613420
* cell instance $7 m90 *1 12.995,1.35
X$7 29 10 1 9 2 2 nmos_6p0_CDNS_4066195613418
* cell instance $8 m90 *1 6.035,1.35
X$8 30 13 1 1 5 5 nmos_6p0_CDNS_4066195613418
* cell instance $9 m90 *1 7.255,1.35
X$9 30 2 1 6 nmos_6p0_CDNS_4066195613419
* cell instance $10 r0 *1 4.23,10.93
X$10 1 M1_POLY2_CDNS_40661956134128
* cell instance $11 r0 *1 11.935,16.335
X$11 26 10 15 15 2 2 20 21 pmos_6p0_CDNS_4066195613416
* cell instance $12 r0 *1 14.375,16.335
X$12 26 3 15 15 2 2 20 21 pmos_6p0_CDNS_4066195613416
* cell instance $13 m90 *1 8.115,16.335
X$13 27 5 2 6 20 21 pmos_6p0_CDNS_4066195613415
* cell instance $14 m90 *1 10.555,1.35
X$14 29 9 2 8 nmos_6p0_CDNS_4066195613419
* cell instance $15 m90 *1 8.475,1.35
X$15 30 5 2 7 nmos_6p0_CDNS_4066195613419
* cell instance $16 r180 *1 14.115,15.825
X$16 2 M1_POLY2_CDNS_40661956134333
* cell instance $17 r90 *1 11.425,8.015
X$17 2 M1_POLY2_CDNS_40661956134128
* cell instance $18 r90 *1 14.115,15.215
X$18 2 19 M2_M1_CDNS_40661956134270
* cell instance $19 r0 *1 8.375,14.955
X$19 2 19 M2_M1_CDNS_40661956134270
* cell instance $20 r0 *1 7.155,15.475
X$20 2 19 M2_M1_CDNS_40661956134270
* cell instance $21 r0 *1 15.595,9.94
X$21 10 3 15 25 nmos_6p0_CDNS_4066195613414
* cell instance $22 r180 *1 16.295,7.35
X$22 28 10 3 3 11 11 nmos_6p0_CDNS_4066195613420
* cell instance $23 r0 *1 13.11,11.485
X$23 9 4 M1_PSUB_CDNS_40661956134199
* cell instance $24 r0 *1 13.815,13.375
X$24 9 4 M1_PSUB_CDNS_40661956134337
* cell instance $25 r0 *1 12.17,9.575
X$25 9 4 M1_PSUB_CDNS_40661956134341
* cell instance $26 r0 *1 1.675,16.335
X$26 23 15 13 13 5 5 20 21 pmos_6p0_CDNS_4066195613416
* cell instance $27 m90 *1 9.335,16.335
X$27 27 15 5 7 20 21 pmos_6p0_CDNS_4066195613415
* cell instance $28 m90 *1 10.555,16.335
X$28 27 5 15 8 20 21 pmos_6p0_CDNS_4066195613415
* cell instance $29 m0 *1 2.665,15.235
X$29 5 M1_POLY2_CDNS_40661956134333
* cell instance $30 r90 *1 2.025,8.015
X$30 5 M1_POLY2_CDNS_40661956134128
* cell instance $31 r90 *1 5.685,8.015
X$31 5 M1_POLY2_CDNS_40661956134128
* cell instance $32 r90 *1 9.165,10.36
X$32 5 16 M2_M1_CDNS_40661956134270
* cell instance $33 r0 *1 5.685,10.62
X$33 5 16 M2_M1_CDNS_40661956134270
* cell instance $34 m135 *1 7.765,15
X$34 6 M1_POLY2_CDNS_40661956134128
* cell instance $35 r90 *1 6.905,8.015
X$35 6 M1_POLY2_CDNS_40661956134128
* cell instance $36 m135 *1 8.985,15
X$36 7 M1_POLY2_CDNS_40661956134128
* cell instance $37 r90 *1 8.125,8.015
X$37 7 M1_POLY2_CDNS_40661956134128
* cell instance $38 m135 *1 10.205,15
X$38 8 M1_POLY2_CDNS_40661956134128
* cell instance $39 r90 *1 10.205,8.015
X$39 8 M1_POLY2_CDNS_40661956134128
* cell instance $40 r0 *1 12.31,9.575
X$40 9 17 M2_M1_CDNS_40661956134286
* cell instance $41 r0 *1 14.725,8.06
X$41 11 31 M2_M1_CDNS_40661956134270
* cell instance $42 r90 *1 14.725,8.015
X$42 11 M1_POLY2_CDNS_40661956134128
* cell instance $43 r0 *1 5.075,14.015
X$43 12 24 M2_M1_CDNS_40661956134270
* cell instance $44 r0 *1 5.075,16.785
X$44 12 24 M2_M1_CDNS_40661956134270
* cell instance $45 r180 *1 6.035,28.335
X$45 23 12 13 18 18 20 21 pmos_6p0_CDNS_4066195613421
* cell instance $46 r0 *1 16.555,17.035
X$46 15 14 M2_M1_CDNS_40661956134270
* cell instance $47 r0 *1 15.945,11.85
X$47 15 14 M2_M1_CDNS_40661956134270
* cell instance $48 r0 *1 0.225,20.295
X$48 15 22 20 21 M1_NWELL_CDNS_40661956134340
* cell instance $49 r0 *1 8.985,29.46
X$49 15 22 20 21 M1_NWELL_CDNS_40661956134334
* cell instance $50 r0 *1 17.745,22.645
X$50 15 22 20 21 M1_NWELL_CDNS_40661956134335
* cell instance $51 r90 *1 15.945,11.805
X$51 15 M1_POLY2_CDNS_40661956134128
* cell instance $52 r0 *1 4.345,14.955
X$52 18 32 M2_M1_CDNS_40661956134270
* cell instance $53 m0 *1 5.115,15.235
X$53 18 M1_POLY2_CDNS_40661956134333
* device instance $1 r0 *1 7.765,22.335 pmos_6p0
M$1 5 6 2 21 pmos_6p0 L=0.7U W=12U AS=5.28P AD=3.12P PS=24.88U PD=12.52U
* device instance $2 r0 *1 8.985,22.335 pmos_6p0
M$2 15 7 5 21 pmos_6p0 L=0.7U W=12U AS=3.12P AD=3.12P PS=12.52U PD=12.52U
* device instance $3 r0 *1 10.205,22.335 pmos_6p0
M$3 5 8 15 21 pmos_6p0 L=0.7U W=12U AS=3.12P AD=5.28P PS=12.52U PD=24.88U
* device instance $4 r0 *1 2.025,22.335 pmos_6p0
M$4 15 5 13 21 pmos_6p0 L=0.7U W=12U AS=5.28P AD=3.12P PS=24.88U PD=12.52U
* device instance $5 r0 *1 3.245,22.335 pmos_6p0
M$5 13 5 15 21 pmos_6p0 L=0.7U W=12U AS=3.12P AD=3.12P PS=12.52U PD=12.52U
* device instance $6 r0 *1 4.465,22.335 pmos_6p0
M$6 12 18 13 21 pmos_6p0 L=0.7U W=12U AS=3.12P AD=3.12P PS=12.52U PD=12.52U
* device instance $7 r0 *1 5.685,22.335 pmos_6p0
M$7 13 18 12 21 pmos_6p0 L=0.7U W=12U AS=3.12P AD=5.28P PS=12.52U PD=24.88U
* device instance $8 r0 *1 12.285,22.335 pmos_6p0
M$8 10 2 15 21 pmos_6p0 L=0.7U W=12U AS=5.28P AD=3.12P PS=24.88U PD=12.52U
* device instance $9 r0 *1 13.505,22.335 pmos_6p0
M$9 15 2 10 21 pmos_6p0 L=0.7U W=12U AS=3.12P AD=3.12P PS=12.52U PD=12.52U
* device instance $10 r0 *1 14.725,22.335 pmos_6p0
M$10 3 2 15 21 pmos_6p0 L=0.7U W=12U AS=3.12P AD=3.12P PS=12.52U PD=12.52U
* device instance $11 r0 *1 15.945,22.335 pmos_6p0
M$11 15 2 3 21 pmos_6p0 L=0.7U W=12U AS=3.12P AD=5.28P PS=12.52U PD=24.88U
* device instance $12 r0 *1 14.725,4.35 nmos_6p0
M$12 10 11 3 25 nmos_6p0 L=0.7U W=6U AS=2.64P AD=1.56P PS=12.88U PD=6.52U
* device instance $13 r0 *1 15.945,4.35 nmos_6p0
M$13 3 11 10 25 nmos_6p0 L=0.7U W=6U AS=1.56P AD=2.64P PS=6.52U PD=12.88U
* device instance $14 r0 *1 2.025,4.35 nmos_6p0
M$14 12 5 1 25 nmos_6p0 L=0.7U W=6U AS=2.64P AD=1.56P PS=12.88U PD=6.52U
* device instance $15 r0 *1 3.245,4.35 nmos_6p0
M$15 1 5 12 25 nmos_6p0 L=0.7U W=6U AS=1.56P AD=1.56P PS=6.52U PD=6.52U
* device instance $16 r0 *1 4.465,4.35 nmos_6p0
M$16 13 5 1 25 nmos_6p0 L=0.7U W=6U AS=1.56P AD=1.56P PS=6.52U PD=6.52U
* device instance $17 r0 *1 5.685,4.35 nmos_6p0
M$17 1 5 13 25 nmos_6p0 L=0.7U W=6U AS=1.56P AD=1.56P PS=6.52U PD=6.52U
* device instance $18 r0 *1 6.905,4.35 nmos_6p0
M$18 2 6 1 25 nmos_6p0 L=0.7U W=6U AS=1.56P AD=1.56P PS=6.52U PD=6.52U
* device instance $19 r0 *1 8.125,4.35 nmos_6p0
M$19 5 7 2 25 nmos_6p0 L=0.7U W=6U AS=1.56P AD=2.64P PS=6.52U PD=12.88U
* device instance $20 r0 *1 10.205,4.35 nmos_6p0
M$20 9 8 2 25 nmos_6p0 L=0.7U W=6U AS=2.64P AD=1.56P PS=12.88U PD=6.52U
* device instance $21 r0 *1 11.425,4.35 nmos_6p0
M$21 10 2 9 25 nmos_6p0 L=0.7U W=6U AS=1.56P AD=1.56P PS=6.52U PD=6.52U
* device instance $22 r0 *1 12.645,4.35 nmos_6p0
M$22 1 2 10 25 nmos_6p0 L=0.7U W=6U AS=1.56P AD=2.64P PS=6.52U PD=12.88U
.ENDS comp018green_out_predrv

* cell comp018green_inpath_cms_smt
* pin PU
* pin CS
* pin
* pin
* pin
* pin
* pin
* pin
* pin IE
* pin
* pin
* pin PD
* pin
* pin
* pin
* pin
* pin
* pin PAD
* pin
* pin
* pin VDD
* pin
* pin
* pin
* pin
* pin
* pin gf180mcu_gnd
* pin
* pin
* pin
* pin
* pin
* pin
* pin
* pin
* pin
* pin
* pin
* pin
* pin
* pin
* pin
.SUBCKT comp018green_inpath_cms_smt 1 2 3 4 5 6 7 8 9 12 13 14 18 19 24 27 29
+ 33 34 35 36 37 38 42 46 50 51 52 53 54 55 56 57 58 59 60 61 62 67 68 69 92
* net 1 PU
* net 2 CS
* net 9 IE
* net 14 PD
* net 33 PAD
* net 36 VDD
* net 51 gf180mcu_gnd
* cell instance $1 m90 *1 69.66,48.62
X$1 40 14 1 16 26 56 46 58 52 51 comp018green_in_logic_pupd
* cell instance $2 r90 *1 2.075,15.295
X$2 1 35 M2_M1_CDNS_40661956134237
* cell instance $3 r0 *1 63.135,15.035
X$3 1 15 M2_M1_CDNS_40661956134237
* cell instance $4 r0 *1 1.7,11.12
X$4 1 35 M2_M1_CDNS_40661956134237
* cell instance $5 r0 *1 1.205,10.62
X$5 65 1 8 61 8 pn_6p0_CDNS_4066195613428
* cell instance $6 r0 *1 66.97,53.065
X$6 1 50 M2_M1_CDNS_40661956134270
* cell instance $7 r0 *1 66.97,31.515
X$7 1 50 M2_M1_CDNS_40661956134270
* cell instance $8 r0 *1 63.87,31.515
X$8 1 15 M2_M1_CDNS_40661956134270
* cell instance $9 r270 *1 1.395,6.625
X$9 2 3 M2_M1_CDNS_40661956134237
* cell instance $10 r0 *1 1.205,6.12
X$10 64 2 8 60 8 pn_6p0_CDNS_4066195613428
* cell instance $11 r0 *1 -0.27,12.995
X$11 2 3 M2_M1_CDNS_40661956134237
* cell instance $12 r0 *1 37.645,12.995
X$12 2 28 M2_M1_CDNS_40661956134237
* cell instance $13 r0 *1 37.905,6.975
X$13 2 28 M2_M1_CDNS_40661956134270
* cell instance $14 r180 *1 39.765,12.46
X$14 20 27 90 79 86 84 76 73 82 24 7 2 6 6 7 51 comp018green_sigbuf
* cell instance $15 r180 *1 65.985,12.46
X$15 23 18 89 81 87 85 78 75 83 29 5 16 4 4 5 51 comp018green_sigbuf
* cell instance $16 m0 *1 39.315,12.46
X$16 91 27 30 79 87 85 76 73 83 29 5 26 6 6 5 51 comp018green_sigbuf
* cell instance $17 m0 *1 13.095,12.46
X$17 10 19 88 80 86 84 77 74 82 24 7 9 8 8 7 51 comp018green_sigbuf
* cell instance $18 r0 *1 7.45,6.12
X$18 63 9 8 59 8 pn_6p0_CDNS_4066195613428
* cell instance $19 r0 *1 7.45,10.62
X$19 66 14 8 62 8 pn_6p0_CDNS_4066195613428
* cell instance $20 r0 *1 7.945,6.62
X$20 9 12 M2_M1_CDNS_40661956134237
* cell instance $21 r0 *1 14.955,6.975
X$21 9 12 M2_M1_CDNS_40661956134270
* cell instance $22 r0 *1 15.295,16.605
X$22 10 11 M2_M1_CDNS_40661956134237
* cell instance $23 r0 *1 7.66,15.79
X$23 38 32 20 54 53 10 39 33 20 42 33 34 51 32 comp018green_in_cms_smt
* cell instance $24 r0 *1 21.86,10.24
X$24 10 11 M2_M1_CDNS_40661956134270
* cell instance $25 r0 *1 7.945,11.12
X$25 14 13 M2_M1_CDNS_40661956134237
* cell instance $26 r0 *1 9.37,13.675
X$26 14 13 M2_M1_CDNS_40661956134237
* cell instance $27 r270 *1 47.26,13.415
X$27 14 40 M2_M1_CDNS_40661956134237
* cell instance $28 r0 *1 57.735,13.78
X$28 16 48 M2_M1_CDNS_40661956134237
* cell instance $29 r0 *1 63.845,13.78
X$29 16 17 M2_M1_CDNS_40661956134237
* cell instance $30 r0 *1 64.105,6.975
X$30 16 17 M2_M1_CDNS_40661956134270
* cell instance $31 r0 *1 61.01,48.67
X$31 16 48 M2_M1_CDNS_40661956134270
* cell instance $32 r0 *1 16.305,14.35
X$32 20 32 M2_M1_CDNS_40661956134237
* cell instance $33 r0 *1 30.985,14.35
X$33 20 21 M2_M1_CDNS_40661956134237
* cell instance $34 r0 *1 31,10.24
X$34 20 21 M2_M1_CDNS_40661956134270
* cell instance $35 r0 *1 56.96,12.995
X$35 23 22 M2_M1_CDNS_40661956134237
* cell instance $36 r0 *1 57.22,10.24
X$36 23 22 M2_M1_CDNS_40661956134270
* cell instance $37 m135 *1 14.895,74.285
X$37 68 67 55 69 57 23 30 23 51 comp018green_in_pupd
* cell instance $38 r0 *1 50.405,31.375
X$38 23 49 M2_M1_CDNS_40661956134237
* cell instance $39 r0 *1 48.3,31.375
X$39 23 43 M2_M1_CDNS_40661956134237
* cell instance $40 r0 *1 50.665,38.905
X$40 23 49 M2_M1_CDNS_40661956134270
* cell instance $41 r0 *1 48.04,13.255
X$41 23 43 M2_M1_CDNS_40661956134270
* cell instance $42 r0 *1 40.74,14.355
X$42 26 25 M2_M1_CDNS_40661956134237
* cell instance $43 r0 *1 41,6.975
X$43 26 25 M2_M1_CDNS_40661956134270
* cell instance $44 r0 *1 55.92,54.135
X$44 26 41 M2_M1_CDNS_40661956134237
* cell instance $45 r0 *1 49.91,14.355
X$45 26 41 M2_M1_CDNS_40661956134237
* cell instance $46 r0 *1 49.08,30.695
X$46 30 45 M2_M1_CDNS_40661956134237
* cell instance $47 r0 *1 50.26,13.675
X$47 30 31 M2_M1_CDNS_40661956134237
* cell instance $48 r0 *1 51.305,30.695
X$48 30 47 M2_M1_CDNS_40661956134237
* cell instance $49 r90 *1 49.08,13.675
X$49 30 45 M2_M1_CDNS_40661956134270
* cell instance $50 r0 *1 50.52,10.24
X$50 30 31 M2_M1_CDNS_40661956134270
* cell instance $51 r0 *1 51.565,36.455
X$51 30 47 M2_M1_CDNS_40661956134270
* cell instance $52 r0 *1 34.55,21.2
X$52 33 34 M2_M1_CDNS_40661956134237
* cell instance $53 r0 *1 67.07,25.64
X$53 36 71 M2_M1_CDNS_40661956134415
* cell instance $54 r0 *1 67.07,25.64
X$54 36 71 M3_M2_CDNS_40661956134416
* cell instance $55 r0 *1 50.325,25.64
X$55 36 72 M2_M1_CDNS_40661956134415
* cell instance $56 r0 *1 50.325,25.64
X$56 36 72 M3_M2_CDNS_40661956134416
* cell instance $57 r0 *1 44.5,15.79
X$57 38 36 37 46 42 39 51 comp018green_in_drv
* cell instance $58 r0 *1 66.97,21.9
X$58 37 92 M2_M1_CDNS_40661956134270
* cell instance $59 r0 *1 61.13,16.6
X$59 46 44 M3_M2_CDNS_40661956134417
* cell instance $60 r0 *1 61.13,15.995
X$60 46 44 M2_M1_CDNS_40661956134237
* cell instance $61 r0 *1 61.13,32.44
X$61 46 44 M2_M1_CDNS_40661956134237
* cell instance $62 r0 *1 50.325,19.71
X$62 46 70 M2_M1_CDNS_40661956134415
* cell instance $63 r0 *1 50.325,19.71
X$63 46 70 M3_M2_CDNS_40661956134416
.ENDS comp018green_inpath_cms_smt

* cell comp018green_out_paddrv_16T
* pin
* pin
* pin
* pin
* pin
* pin
* pin
* pin
* pin
* pin
* pin
* pin
* pin
* pin
* pin
* pin
* pin
* pin
* pin
* pin
* pin gf180mcu_gnd
* pin
* pin
* pin
* pin
* pin
* pin
* pin
* pin
* pin
* pin
* pin
* pin
* pin
* pin
* pin
* pin
* pin
* pin
* pin
* pin
* pin
* pin
* pin
* pin
* pin
.SUBCKT comp018green_out_paddrv_16T 1 2 3 4 5 6 7 8 9 10 11 12 13 14 15 16 17
+ 18 19 22 23 24 25 26 27 28 29 30 31 32 33 34 35 36 37 38 39 40 41 42 43 44 45
+ 46 47 51
* net 23 gf180mcu_gnd
* cell instance $1 r90 *1 5.58,47.42
X$1 11 1 M2_M1_CDNS_40661956134270
* cell instance $2 r90 *1 5.58,46.59
X$2 12 2 M2_M1_CDNS_40661956134270
* cell instance $3 r90 *1 5.58,45.79
X$3 13 3 M2_M1_CDNS_40661956134270
* cell instance $4 r90 *1 5.58,44.96
X$4 14 4 M2_M1_CDNS_40661956134270
* cell instance $5 m45 *1 61.975,47.42
X$5 15 5 M2_M1_CDNS_40661956134270
* cell instance $6 m45 *1 61.975,46.59
X$6 16 6 M2_M1_CDNS_40661956134270
* cell instance $7 m45 *1 61.975,45.79
X$7 17 7 M2_M1_CDNS_40661956134270
* cell instance $8 m45 *1 61.975,44.96
X$8 18 8 M2_M1_CDNS_40661956134270
* cell instance $9 r0 *1 2.74,61.735
X$9 45 29 34 33 35 36 38 37 40 39 41 42 44 43 19 28 19 19 27 26 19 25 19 24 19
+ 47 9 9 9 9 9 9 46 comp018green_out_paddrv_4T_PMOS_GROUP
* cell instance $10 r0 *1 6.695,0.155
X$10 14 18 15 16 17 13 12 11 22 19 32 31 19 19 30 19 22 23 21 20 10 22 9 9 9 9
+ comp018green_out_paddrv_4T_NMOS_GROUP
* cell instance $11 r0 *1 5.445,51.465
X$11 10 48 M2_M1_CDNS_40661956134446
* cell instance $12 r0 *1 5.445,51.465
X$12 10 48 M3_M2_CDNS_40661956134382
* cell instance $13 r0 *1 62.035,51.465
X$13 10 49 M2_M1_CDNS_40661956134446
* cell instance $14 r0 *1 62.035,51.465
X$14 10 49 M3_M2_CDNS_40661956134382
* cell instance $15 r0 *1 -0.73,51.465
X$15 10 50 M3_M2_CDNS_40661956134367
* cell instance $16 r0 *1 -0.75,51.35
X$16 10 50 M2_M1_CDNS_40661956134447
* cell instance $17 m90 *1 67.94,51.465
X$17 10 51 M3_M2_CDNS_40661956134367
* cell instance $18 m90 *1 67.96,51.35
X$18 10 51 M2_M1_CDNS_40661956134447
* cell instance $19 r0 *1 8.895,24.17
X$19 22 20 M3_M2_CDNS_40661956134444
* cell instance $20 r0 *1 8.895,24.215
X$20 22 20 M2_M1_CDNS_40661956134383
* cell instance $21 r0 *1 8.895,9.155
X$21 22 20 M3_M2_CDNS_40661956134445
* cell instance $22 r0 *1 8.895,9.06
X$22 22 20 M2_M1_CDNS_40661956134384
* cell instance $23 r0 *1 8.895,38.505
X$23 22 20 M2_M1_CDNS_40661956134305
* cell instance $24 r0 *1 8.895,38.48
X$24 22 20 M3_M2_CDNS_40661956134443
* cell instance $25 m90 *1 58.265,24.17
X$25 22 21 M3_M2_CDNS_40661956134444
* cell instance $26 m90 *1 58.265,24.215
X$26 22 21 M2_M1_CDNS_40661956134383
* cell instance $27 m90 *1 58.265,9.155
X$27 22 21 M3_M2_CDNS_40661956134445
* cell instance $28 m90 *1 58.265,9.06
X$28 22 21 M2_M1_CDNS_40661956134384
* cell instance $29 m90 *1 58.265,38.505
X$29 22 21 M2_M1_CDNS_40661956134305
* cell instance $30 m90 *1 58.265,38.48
X$30 22 21 M3_M2_CDNS_40661956134443
.ENDS comp018green_out_paddrv_16T

* cell M3_M2_CDNS_40661956134316
* pin
* pin
.SUBCKT M3_M2_CDNS_40661956134316 1 2
.ENDS M3_M2_CDNS_40661956134316

* cell M1_PACTIVE_CDNS_40661956134274
* pin
* pin
.SUBCKT M1_PACTIVE_CDNS_40661956134274 1 2
.ENDS M1_PACTIVE_CDNS_40661956134274

* cell M2_M1_CDNS_40661956134315
* pin
* pin
.SUBCKT M2_M1_CDNS_40661956134315 1 2
.ENDS M2_M1_CDNS_40661956134315

* cell nmoscap_6p0_CDNS_4066195613423
* pin
* pin
* pin
.SUBCKT nmoscap_6p0_CDNS_4066195613423 1 2 4
.ENDS nmoscap_6p0_CDNS_4066195613423

* cell M1_PSUB_CDNS_40661956134441
* pin
.SUBCKT M1_PSUB_CDNS_40661956134441 1
.ENDS M1_PSUB_CDNS_40661956134441

* cell comp018green_esd_cdm
* pin
* pin
* pin
* pin
* pin
* pin IP_IN
* pin DVSS
* pin
* pin
* pin DVDD
* pin
* pin PAD
* pin
* pin gf180mcu_gnd
.SUBCKT comp018green_esd_cdm 1 4 5 6 7 8 10 12 14 15 17 28 30 32
* net 8 IP_IN
* net 10 DVSS
* net 15 DVDD
* net 28 PAD
* net 32 gf180mcu_gnd
* cell instance $1 r0 *1 14.745,0.975
X$1 1 2 M1_NACTIVE_CDNS_40661956134359
* cell instance $2 r0 *1 14.745,14.475
X$2 1 2 M1_NACTIVE_CDNS_40661956134359
* cell instance $3 r0 *1 0.975,11.275
X$3 1 12 M2_M1_CDNS_40661956134365
* cell instance $4 r0 *1 0.975,7.725
X$4 1 2 M1_NACTIVE_CDNS_40661956134346
* cell instance $5 r0 *1 0.975,11.27
X$5 1 12 M3_M2_CDNS_40661956134367
* cell instance $6 r0 *1 28.515,7.725
X$6 1 2 M1_NACTIVE_CDNS_40661956134346
* cell instance $7 r0 *1 28.515,11.795
X$7 1 11 M2_M1_CDNS_40661956134364
* cell instance $8 r0 *1 28.515,11.83
X$8 1 11 M3_M2_CDNS_40661956134285
* cell instance $9 r0 *1 8.39,12.01
X$9 4 3 M2_M1_CDNS_40661956134351
* cell instance $10 r0 *1 8.39,5.885
X$10 4 3 M3_M2_CDNS_40661956134362
* cell instance $11 r0 *1 8.39,7.725
X$11 4 3 M2_M1_CDNS_40661956134287
* cell instance $12 r0 *1 8.355,3.44
X$12 4 3 M3_M2_CDNS_40661956134373
* cell instance $13 r0 *1 3.295,5.06
X$13 4 3 M2_M1_CDNS_40661956134361
* cell instance $14 r0 *1 8.805,3.44
X$14 4 3 M2_M1_CDNS_40661956134374
* cell instance $15 r0 *1 3.295,5.885
X$15 4 3 M3_M2_CDNS_40661956134368
* cell instance $16 r0 *1 13.17,12.01
X$16 4 3 M2_M1_CDNS_40661956134235
* cell instance $17 r0 *1 13.17,5.885
X$17 4 3 M3_M2_CDNS_40661956134368
* cell instance $18 r0 *1 13.16,7.725
X$18 4 3 M2_M1_CDNS_40661956134360
* cell instance $19 r0 *1 14.745,7.725
X$19 4 13 M1_PACTIVE_CDNS_40661956134356
* cell instance $20 r0 *1 14.745,8.495
X$20 4 13 M1_PACTIVE_CDNS_40661956134354
* cell instance $21 r0 *1 14.745,6.955
X$21 4 13 M1_PACTIVE_CDNS_40661956134354
* cell instance $22 r0 *1 16.315,7.725
X$22 4 5 M2_M1_CDNS_40661956134360
* cell instance $23 r0 *1 16.325,5.885
X$23 4 5 M3_M2_CDNS_40661956134368
* cell instance $24 r0 *1 21.1,7.725
X$24 4 5 M2_M1_CDNS_40661956134287
* cell instance $25 r0 *1 21.1,5.885
X$25 4 5 M3_M2_CDNS_40661956134362
* cell instance $26 r0 *1 14.745,11.625
X$26 4 13 M1_PACTIVE_CDNS_40661956134354
* cell instance $27 r0 *1 16.325,12.01
X$27 4 5 M2_M1_CDNS_40661956134235
* cell instance $28 r0 *1 21.1,12.01
X$28 4 5 M2_M1_CDNS_40661956134351
* cell instance $29 r0 *1 14.745,12.395
X$29 4 13 M1_PACTIVE_CDNS_40661956134352
* cell instance $30 r0 *1 25.81,10.075
X$30 4 13 M1_PACTIVE_CDNS_40661956134355
* cell instance $31 r0 *1 3.68,10.075
X$31 4 13 M1_PACTIVE_CDNS_40661956134355
* cell instance $32 r0 *1 14.745,3.055
X$32 4 13 M1_PACTIVE_CDNS_40661956134352
* cell instance $33 r0 *1 14.745,3.825
X$33 4 13 M1_PACTIVE_CDNS_40661956134354
* cell instance $34 r0 *1 20.685,3.44
X$34 4 5 M2_M1_CDNS_40661956134374
* cell instance $35 r0 *1 21.135,3.44
X$35 4 5 M3_M2_CDNS_40661956134373
* cell instance $36 r0 *1 26.195,5.06
X$36 4 5 M2_M1_CDNS_40661956134361
* cell instance $37 r0 *1 2.91,7.725
X$37 4 13 M1_PACTIVE_CDNS_40661956134353
* cell instance $38 r0 *1 3.68,5.405
X$38 4 13 M1_PACTIVE_CDNS_40661956134355
* cell instance $39 r0 *1 25.81,5.405
X$39 4 13 M1_PACTIVE_CDNS_40661956134355
* cell instance $40 r0 *1 26.195,5.885
X$40 4 5 M3_M2_CDNS_40661956134368
* cell instance $41 r0 *1 26.58,7.725
X$41 4 13 M1_PACTIVE_CDNS_40661956134353
* cell instance $42 r0 *1 3.68,21.59
X$42 6 24 M1_NACTIVE_CDNS_40661956134348
* cell instance $43 r0 *1 25.81,21.59
X$43 6 24 M1_NACTIVE_CDNS_40661956134348
* cell instance $44 r270 *1 4.745,22.075
X$44 8 26 6 pn_6p0_CDNS_4066195613427
* cell instance $45 r270 *1 4.745,26.745
X$45 8 26 6 pn_6p0_CDNS_4066195613427
* cell instance $46 r0 *1 8.39,23.91
X$46 6 23 M2_M1_CDNS_40661956134287
* cell instance $47 r0 *1 14.745,23.91
X$47 6 24 M1_NACTIVE_CDNS_40661956134349
* cell instance $48 r0 *1 14.745,23.14
X$48 6 24 M1_NACTIVE_CDNS_40661956134347
* cell instance $49 r0 *1 14.745,24.68
X$49 6 24 M1_NACTIVE_CDNS_40661956134347
* cell instance $50 r0 *1 8.39,26.525
X$50 6 23 M3_M2_CDNS_40661956134366
* cell instance $51 r0 *1 13.45,23.91
X$51 6 22 M2_M1_CDNS_40661956134287
* cell instance $52 r0 *1 13.45,26.525
X$52 6 22 M3_M2_CDNS_40661956134366
* cell instance $53 r0 *1 16.04,23.91
X$53 6 21 M2_M1_CDNS_40661956134287
* cell instance $54 r0 *1 16.04,26.525
X$54 6 21 M3_M2_CDNS_40661956134366
* cell instance $55 r0 *1 21.1,23.91
X$55 6 20 M2_M1_CDNS_40661956134287
* cell instance $56 r0 *1 21.1,26.525
X$56 6 20 M3_M2_CDNS_40661956134366
* cell instance $57 r0 *1 3.295,26.52
X$57 6 19 M2_M1_CDNS_40661956134361
* cell instance $58 r0 *1 2.91,23.91
X$58 6 24 M1_NACTIVE_CDNS_40661956134350
* cell instance $59 r0 *1 3.295,26.525
X$59 6 19 M3_M2_CDNS_40661956134372
* cell instance $60 r0 *1 14.745,28.58
X$60 6 24 M1_NACTIVE_CDNS_40661956134345
* cell instance $61 r0 *1 3.68,26.26
X$61 6 24 M1_NACTIVE_CDNS_40661956134348
* cell instance $62 r0 *1 8.39,28.195
X$62 6 23 M2_M1_CDNS_40661956134351
* cell instance $63 r0 *1 14.745,27.81
X$63 6 24 M1_NACTIVE_CDNS_40661956134347
* cell instance $64 r0 *1 13.45,28.195
X$64 6 22 M2_M1_CDNS_40661956134351
* cell instance $65 r0 *1 16.04,28.195
X$65 6 21 M2_M1_CDNS_40661956134351
* cell instance $66 r0 *1 21.1,28.195
X$66 6 20 M2_M1_CDNS_40661956134351
* cell instance $67 r0 *1 26.195,26.52
X$67 6 25 M2_M1_CDNS_40661956134361
* cell instance $68 r0 *1 26.195,26.525
X$68 6 25 M3_M2_CDNS_40661956134372
* cell instance $69 r0 *1 26.58,23.91
X$69 6 24 M1_NACTIVE_CDNS_40661956134350
* cell instance $70 r0 *1 25.81,26.26
X$70 6 24 M1_NACTIVE_CDNS_40661956134348
* cell instance $71 r0 *1 8.39,19.625
X$71 6 23 M2_M1_CDNS_40661956134351
* cell instance $72 r0 *1 14.745,19.24
X$72 6 24 M1_NACTIVE_CDNS_40661956134345
* cell instance $73 r0 *1 14.745,20.01
X$73 6 24 M1_NACTIVE_CDNS_40661956134347
* cell instance $74 r0 *1 13.45,19.625
X$74 6 22 M2_M1_CDNS_40661956134351
* cell instance $75 r0 *1 16.04,19.625
X$75 6 21 M2_M1_CDNS_40661956134351
* cell instance $76 r0 *1 21.1,19.625
X$76 6 20 M2_M1_CDNS_40661956134351
* cell instance $77 m0 *1 14.74,35.335
X$77 8 7 M2_M1_CDNS_40661956134343
* cell instance $78 r0 *1 23.63,21.575
X$78 8 7 M2_M1_CDNS_40661956134351
* cell instance $79 r0 *1 18.57,21.575
X$79 8 7 M2_M1_CDNS_40661956134351
* cell instance $80 r0 *1 5.86,21.575
X$80 8 7 M2_M1_CDNS_40661956134351
* cell instance $81 r0 *1 10.92,21.575
X$81 8 7 M2_M1_CDNS_40661956134351
* cell instance $82 r0 *1 5.86,5.39
X$82 8 7 M2_M1_CDNS_40661956134351
* cell instance $83 r0 *1 18.57,10.06
X$83 8 7 M2_M1_CDNS_40661956134351
* cell instance $84 r0 *1 10.92,10.06
X$84 8 7 M2_M1_CDNS_40661956134351
* cell instance $85 r0 *1 5.86,26.245
X$85 8 7 M2_M1_CDNS_40661956134351
* cell instance $86 r0 *1 23.63,5.39
X$86 8 7 M2_M1_CDNS_40661956134351
* cell instance $87 r0 *1 5.86,10.06
X$87 8 7 M2_M1_CDNS_40661956134351
* cell instance $88 r0 *1 18.57,5.39
X$88 8 7 M2_M1_CDNS_40661956134351
* cell instance $89 r0 *1 10.92,26.245
X$89 8 7 M2_M1_CDNS_40661956134351
* cell instance $90 r0 *1 23.63,10.06
X$90 8 7 M2_M1_CDNS_40661956134351
* cell instance $91 r0 *1 23.63,26.245
X$91 8 7 M2_M1_CDNS_40661956134351
* cell instance $92 r0 *1 18.57,26.245
X$92 8 7 M2_M1_CDNS_40661956134351
* cell instance $93 r0 *1 10.92,5.39
X$93 8 7 M2_M1_CDNS_40661956134351
* cell instance $94 r270 *1 8.845,39.255
X$94 8 28 32 ppolyf_u_CDNS_4066195613425
* cell instance $95 r270 *1 11.945,39.255
X$95 8 28 32 ppolyf_u_CDNS_4066195613425
* cell instance $96 r270 *1 15.045,39.255
X$96 8 28 32 ppolyf_u_CDNS_4066195613425
* cell instance $97 r270 *1 18.145,39.255
X$97 8 28 32 ppolyf_u_CDNS_4066195613425
* cell instance $98 r270 *1 4.745,5.89
X$98 8 np_6p0_CDNS_4066195613426
* cell instance $99 r270 *1 4.745,10.56
X$99 8 np_6p0_CDNS_4066195613426
* cell instance $100 r0 *1 0.975,23.91
X$100 10 9 M1_PACTIVE_CDNS_40661956134344
* cell instance $101 r0 *1 14.745,17.16
X$101 10 9 M1_PACTIVE_CDNS_40661956134357
* cell instance $102 r0 *1 14.745,30.66
X$102 10 9 M1_PACTIVE_CDNS_40661956134357
* cell instance $103 r0 *1 28.515,23.91
X$103 10 9 M1_PACTIVE_CDNS_40661956134344
* cell instance $104 r0 *1 0.975,20.495
X$104 10 18 M2_M1_CDNS_40661956134363
* cell instance $105 r0 *1 0.975,20.495
X$105 10 18 M3_M2_CDNS_40661956134367
* cell instance $106 r0 *1 28.515,19.795
X$106 10 17 M2_M1_CDNS_40661956134364
* cell instance $107 r0 *1 28.515,19.795
X$107 10 17 M3_M2_CDNS_40661956134285
* cell instance $108 r0 *1 14.745,33.345
X$108 15 16 M1_NACTIVE_CDNS_40661956134359
* cell instance $109 r270 *1 0.975,37.345
X$109 15 27 M2_M1_CDNS_40661956134371
* cell instance $110 r0 *1 0.975,37.345
X$110 15 16 M1_NACTIVE_CDNS_40661956134358
* cell instance $111 r0 *1 0.975,35.84
X$111 15 27 M3_M2_CDNS_40661956134285
* cell instance $112 r0 *1 6.3,41.345
X$112 15 27 M3_M2_CDNS_40661956134369
* cell instance $113 r0 *1 7.59,41.345
X$113 15 27 M2_M1_CDNS_40661956134370
* cell instance $114 r0 *1 14.745,41.345
X$114 15 16 M1_NACTIVE_CDNS_40661956134359
* cell instance $115 r0 *1 21.9,41.345
X$115 15 29 M2_M1_CDNS_40661956134370
* cell instance $116 r0 *1 23.19,41.345
X$116 15 29 M3_M2_CDNS_40661956134369
* cell instance $117 r270 *1 28.515,37.345
X$117 15 29 M2_M1_CDNS_40661956134371
* cell instance $118 r0 *1 28.515,37.345
X$118 15 16 M1_NACTIVE_CDNS_40661956134358
* cell instance $119 r0 *1 28.515,35.84
X$119 15 29 M3_M2_CDNS_40661956134285
* cell instance $120 r0 *1 14.74,39.355
X$120 28 30 M2_M1_CDNS_40661956134343
* device instance $1 r0 *1 14.745,21.575 pn_6p0
D$1 8 6 pn_6p0 A=20P P=42U
* device instance $2 r0 *1 14.745,26.245 pn_6p0
D$2 8 6 pn_6p0 A=20P P=42U
.ENDS comp018green_esd_cdm

* cell 3LM_METAL_RAIL
* pin
* pin DVSS
* pin VSS
* pin VDD
* pin DVDD
* pin
.SUBCKT 3LM_METAL_RAIL 1 2 3 4 5 6
* net 2 DVSS
* net 3 VSS
* net 4 VDD
* net 5 DVDD
* cell instance $1 r0 *1 0.24,207.62
X$1 6 1 M1_PSUB_CDNS_40661956134176
* cell instance $2 r0 *1 37.665,349.365
X$2 6 1 M1_PSUB_CDNS_40661956134192
* cell instance $3 r0 *1 37.665,65.96
X$3 6 1 M1_PSUB_CDNS_40661956134192
* cell instance $4 r0 *1 74.76,207.62
X$4 6 1 M1_PSUB_CDNS_40661956134176
.ENDS 3LM_METAL_RAIL

* cell Bondpad_3LM
* pin
* pin
.SUBCKT Bondpad_3LM 1 2
* cell instance $1 r0 *1 32.035,1.015
X$1 2 1 M3_M2_CDNS_40661956134196
* cell instance $2 r0 *1 32.04,63.675
X$2 2 1 M3_M2_CDNS_40661956134195
* cell instance $3 r90 *1 64.01,31.27
X$3 2 1 M3_M2_CDNS_40661956134194
* cell instance $4 r90 *1 34.205,31.945
X$4 2 1 M3_M2_CDNS_40661956134193
* cell instance $5 r90 *1 60.2,31.945
X$5 2 1 M3_M2_CDNS_40661956134193
* cell instance $6 r90 *1 36.22,31.945
X$6 2 1 M3_M2_CDNS_40661956134193
* cell instance $7 r90 *1 38.19,31.945
X$7 2 1 M3_M2_CDNS_40661956134193
* cell instance $8 r90 *1 40.195,31.945
X$8 2 1 M3_M2_CDNS_40661956134193
* cell instance $9 r90 *1 42.195,31.945
X$9 2 1 M3_M2_CDNS_40661956134193
* cell instance $10 r90 *1 44.18,31.945
X$10 2 1 M3_M2_CDNS_40661956134193
* cell instance $11 r90 *1 46.165,31.945
X$11 2 1 M3_M2_CDNS_40661956134193
* cell instance $12 r90 *1 48.185,31.945
X$12 2 1 M3_M2_CDNS_40661956134193
* cell instance $13 r90 *1 50.165,31.945
X$13 2 1 M3_M2_CDNS_40661956134193
* cell instance $14 r90 *1 52.165,31.945
X$14 2 1 M3_M2_CDNS_40661956134193
* cell instance $15 r90 *1 54.15,31.945
X$15 2 1 M3_M2_CDNS_40661956134193
* cell instance $16 r90 *1 56.175,31.945
X$16 2 1 M3_M2_CDNS_40661956134193
* cell instance $17 r90 *1 58.175,31.945
X$17 2 1 M3_M2_CDNS_40661956134193
* cell instance $18 r90 *1 32.195,31.945
X$18 2 1 M3_M2_CDNS_40661956134193
* cell instance $19 r90 *1 6.205,31.945
X$19 2 1 M3_M2_CDNS_40661956134193
* cell instance $20 r90 *1 8.205,31.945
X$20 2 1 M3_M2_CDNS_40661956134193
* cell instance $21 r90 *1 10.19,31.945
X$21 2 1 M3_M2_CDNS_40661956134193
* cell instance $22 r90 *1 12.175,31.945
X$22 2 1 M3_M2_CDNS_40661956134193
* cell instance $23 r90 *1 14.195,31.945
X$23 2 1 M3_M2_CDNS_40661956134193
* cell instance $24 r90 *1 16.175,31.945
X$24 2 1 M3_M2_CDNS_40661956134193
* cell instance $25 r90 *1 18.175,31.945
X$25 2 1 M3_M2_CDNS_40661956134193
* cell instance $26 r90 *1 20.16,31.945
X$26 2 1 M3_M2_CDNS_40661956134193
* cell instance $27 r90 *1 22.185,31.945
X$27 2 1 M3_M2_CDNS_40661956134193
* cell instance $28 r90 *1 24.185,31.945
X$28 2 1 M3_M2_CDNS_40661956134193
* cell instance $29 r90 *1 26.21,31.945
X$29 2 1 M3_M2_CDNS_40661956134193
* cell instance $30 r90 *1 28.195,31.945
X$30 2 1 M3_M2_CDNS_40661956134193
* cell instance $31 r90 *1 4.2,31.945
X$31 2 1 M3_M2_CDNS_40661956134193
* cell instance $32 r90 *1 30.18,31.945
X$32 2 1 M3_M2_CDNS_40661956134193
* cell instance $33 r90 *1 -0.05,31.27
X$33 2 1 M3_M2_CDNS_40661956134194
.ENDS Bondpad_3LM

* cell M3_M2_CDNS_40661956134193
* pin
* pin
.SUBCKT M3_M2_CDNS_40661956134193 1 2
.ENDS M3_M2_CDNS_40661956134193

* cell M3_M2_CDNS_40661956134194
* pin
* pin
.SUBCKT M3_M2_CDNS_40661956134194 1 2
.ENDS M3_M2_CDNS_40661956134194

* cell M3_M2_CDNS_40661956134195
* pin
* pin
.SUBCKT M3_M2_CDNS_40661956134195 1 2
.ENDS M3_M2_CDNS_40661956134195

* cell M3_M2_CDNS_40661956134196
* pin
* pin
.SUBCKT M3_M2_CDNS_40661956134196 1 2
.ENDS M3_M2_CDNS_40661956134196

* cell M2_M1_CDNS_40661956134231
* pin
* pin
.SUBCKT M2_M1_CDNS_40661956134231 1 2
.ENDS M2_M1_CDNS_40661956134231

* cell M2_M1_CDNS_40661956134239
* pin
* pin
.SUBCKT M2_M1_CDNS_40661956134239 1 2
.ENDS M2_M1_CDNS_40661956134239

* cell M2_M1_CDNS_40661956134241
* pin
* pin
.SUBCKT M2_M1_CDNS_40661956134241 1 2
.ENDS M2_M1_CDNS_40661956134241

* cell nmos_clamp_20_50_4_DVDD
* pin
* pin
* pin
* pin
* pin
* pin
* pin
* pin
* pin
* pin
* pin
* pin
* pin
* pin
* pin
* pin
* pin gf180mcu_gnd
.SUBCKT nmos_clamp_20_50_4_DVDD 1 3 5 6 7 8 9 10 11 12 13 14 15 16 17 18 19
* net 19 gf180mcu_gnd
* cell instance $1 r90 *1 57.405,95.485
X$1 3 5 3 5 3 5 3 5 3 5 3 5 3 5 3 5 3 5 3 5 3 1 1 1 1 1 1 1 1 1 1 1 1 1 1 1 1 1
+ 1 1 1 19 nmos_6p0_CDNS_406619561341
* cell instance $2 r90 *1 57.405,7.405
X$2 3 5 3 5 3 5 3 5 3 5 3 5 3 5 3 5 3 5 3 5 3 1 1 1 1 1 1 1 1 1 1 1 1 1 1 1 1 1
+ 1 1 1 19 nmos_6p0_CDNS_406619561341
* cell instance $3 r90 *1 57.405,36.765
X$3 3 5 3 5 3 5 3 5 3 5 3 5 3 5 3 5 3 5 3 5 3 1 1 1 1 1 1 1 1 1 1 1 1 1 1 1 1 1
+ 1 1 1 19 nmos_6p0_CDNS_406619561341
* cell instance $4 r90 *1 57.405,66.125
X$4 3 5 3 5 3 5 3 5 3 5 3 5 3 5 3 5 3 5 3 5 3 1 1 1 1 1 1 1 1 1 1 1 1 1 1 1 1 1
+ 1 1 1 19 nmos_6p0_CDNS_406619561341
* cell instance $5 r0 *1 58.245,19.345
X$5 1 16 M2_M1_CDNS_40661956134141
* cell instance $6 m90 *1 58.165,19.345
X$6 1 M1_POLY2_CDNS_40661956134136
* cell instance $7 r0 *1 58.245,48.705
X$7 1 16 M2_M1_CDNS_40661956134141
* cell instance $8 m90 *1 58.165,48.705
X$8 1 M1_POLY2_CDNS_40661956134136
* cell instance $9 r0 *1 58.245,78.065
X$9 1 16 M2_M1_CDNS_40661956134141
* cell instance $10 m90 *1 58.165,78.065
X$10 1 M1_POLY2_CDNS_40661956134136
* cell instance $11 r0 *1 58.245,107.425
X$11 1 16 M2_M1_CDNS_40661956134141
* cell instance $12 m90 *1 58.165,107.425
X$12 1 M1_POLY2_CDNS_40661956134136
* cell instance $13 r0 *1 6.645,19.345
X$13 1 M1_POLY2_CDNS_40661956134136
* cell instance $14 r0 *1 6.565,19.345
X$14 1 7 M2_M1_CDNS_40661956134141
* cell instance $15 r0 *1 6.645,78.065
X$15 1 M1_POLY2_CDNS_40661956134136
* cell instance $16 r0 *1 6.565,78.065
X$16 1 7 M2_M1_CDNS_40661956134141
* cell instance $17 r0 *1 6.645,107.425
X$17 1 M1_POLY2_CDNS_40661956134136
* cell instance $18 r0 *1 6.565,107.425
X$18 1 7 M2_M1_CDNS_40661956134141
* cell instance $19 r0 *1 6.645,48.705
X$19 1 M1_POLY2_CDNS_40661956134136
* cell instance $20 r0 *1 6.565,48.705
X$20 1 7 M2_M1_CDNS_40661956134141
* cell instance $21 r0 *1 32.405,125.635
X$21 3 3 20 2 M1_NWELL_CDNS_40661956134139
* cell instance $22 r0 *1 32.405,1.135
X$22 3 3 20 2 M1_NWELL_CDNS_40661956134139
* cell instance $23 r0 *1 63.675,63.385
X$23 3 2 3 20 M1_NWELL_CDNS_40661956134135
* cell instance $24 r0 *1 1.135,63.385
X$24 3 2 3 20 M1_NWELL_CDNS_40661956134135
* cell instance $25 r0 *1 13.79,109.865
X$25 3 14 M2_M1_CDNS_40661956134249
* cell instance $26 r0 *1 25.64,109.865
X$26 3 13 M2_M1_CDNS_40661956134249
* cell instance $27 m90 *1 39.17,109.865
X$27 3 11 M2_M1_CDNS_40661956134249
* cell instance $28 m90 *1 51.02,109.865
X$28 3 9 M2_M1_CDNS_40661956134249
* cell instance $29 r0 *1 13.79,107.425
X$29 3 14 M2_M1_CDNS_40661956134249
* cell instance $30 r0 *1 25.64,107.425
X$30 3 13 M2_M1_CDNS_40661956134249
* cell instance $31 m90 *1 39.17,107.425
X$31 3 11 M2_M1_CDNS_40661956134249
* cell instance $32 m90 *1 51.02,107.425
X$32 3 9 M2_M1_CDNS_40661956134249
* cell instance $33 r0 *1 13.79,104.985
X$33 3 14 M2_M1_CDNS_40661956134249
* cell instance $34 r0 *1 25.64,104.985
X$34 3 13 M2_M1_CDNS_40661956134249
* cell instance $35 m90 *1 39.17,104.985
X$35 3 11 M2_M1_CDNS_40661956134249
* cell instance $36 m90 *1 51.02,104.985
X$36 3 9 M2_M1_CDNS_40661956134249
* cell instance $37 r0 *1 13.79,100.105
X$37 3 14 M2_M1_CDNS_40661956134249
* cell instance $38 r0 *1 25.64,100.105
X$38 3 13 M2_M1_CDNS_40661956134249
* cell instance $39 m90 *1 39.17,100.105
X$39 3 11 M2_M1_CDNS_40661956134249
* cell instance $40 m90 *1 51.02,100.105
X$40 3 9 M2_M1_CDNS_40661956134249
* cell instance $41 r0 *1 13.79,102.545
X$41 3 14 M2_M1_CDNS_40661956134249
* cell instance $42 r0 *1 25.64,102.545
X$42 3 13 M2_M1_CDNS_40661956134249
* cell instance $43 m90 *1 39.17,102.545
X$43 3 11 M2_M1_CDNS_40661956134249
* cell instance $44 m90 *1 51.02,102.545
X$44 3 9 M2_M1_CDNS_40661956134249
* cell instance $45 r0 *1 13.79,80.505
X$45 3 14 M2_M1_CDNS_40661956134249
* cell instance $46 r0 *1 25.64,80.505
X$46 3 13 M2_M1_CDNS_40661956134249
* cell instance $47 m90 *1 39.17,80.505
X$47 3 11 M2_M1_CDNS_40661956134249
* cell instance $48 m90 *1 51.02,80.505
X$48 3 9 M2_M1_CDNS_40661956134249
* cell instance $49 r0 *1 13.79,112.305
X$49 3 14 M2_M1_CDNS_40661956134249
* cell instance $50 r0 *1 25.64,112.305
X$50 3 13 M2_M1_CDNS_40661956134249
* cell instance $51 m90 *1 39.17,112.305
X$51 3 11 M2_M1_CDNS_40661956134249
* cell instance $52 m90 *1 51.02,112.305
X$52 3 9 M2_M1_CDNS_40661956134249
* cell instance $53 r0 *1 13.79,114.745
X$53 3 14 M2_M1_CDNS_40661956134249
* cell instance $54 r0 *1 25.64,114.745
X$54 3 13 M2_M1_CDNS_40661956134249
* cell instance $55 m90 *1 39.17,114.745
X$55 3 11 M2_M1_CDNS_40661956134249
* cell instance $56 m90 *1 51.02,114.745
X$56 3 9 M2_M1_CDNS_40661956134249
* cell instance $57 r0 *1 13.79,78.065
X$57 3 14 M2_M1_CDNS_40661956134249
* cell instance $58 r0 *1 25.64,78.065
X$58 3 13 M2_M1_CDNS_40661956134249
* cell instance $59 m90 *1 39.17,78.065
X$59 3 11 M2_M1_CDNS_40661956134249
* cell instance $60 m90 *1 51.02,78.065
X$60 3 9 M2_M1_CDNS_40661956134249
* cell instance $61 r0 *1 13.79,21.785
X$61 3 14 M2_M1_CDNS_40661956134249
* cell instance $62 r0 *1 25.64,21.785
X$62 3 13 M2_M1_CDNS_40661956134249
* cell instance $63 m90 *1 39.17,21.785
X$63 3 11 M2_M1_CDNS_40661956134249
* cell instance $64 m90 *1 51.02,21.785
X$64 3 9 M2_M1_CDNS_40661956134249
* cell instance $65 r0 *1 13.79,19.345
X$65 3 14 M2_M1_CDNS_40661956134249
* cell instance $66 r0 *1 25.64,19.345
X$66 3 13 M2_M1_CDNS_40661956134249
* cell instance $67 m90 *1 39.17,19.345
X$67 3 11 M2_M1_CDNS_40661956134249
* cell instance $68 m90 *1 51.02,19.345
X$68 3 9 M2_M1_CDNS_40661956134249
* cell instance $69 r0 *1 13.79,14.465
X$69 3 14 M2_M1_CDNS_40661956134249
* cell instance $70 r0 *1 25.64,14.465
X$70 3 13 M2_M1_CDNS_40661956134249
* cell instance $71 m90 *1 39.17,14.465
X$71 3 11 M2_M1_CDNS_40661956134249
* cell instance $72 m90 *1 51.02,14.465
X$72 3 9 M2_M1_CDNS_40661956134249
* cell instance $73 r0 *1 13.79,12.025
X$73 3 14 M2_M1_CDNS_40661956134249
* cell instance $74 r0 *1 25.64,12.025
X$74 3 13 M2_M1_CDNS_40661956134249
* cell instance $75 m90 *1 39.17,12.025
X$75 3 11 M2_M1_CDNS_40661956134249
* cell instance $76 m90 *1 51.02,12.025
X$76 3 9 M2_M1_CDNS_40661956134249
* cell instance $77 r0 *1 13.79,9.585
X$77 3 14 M2_M1_CDNS_40661956134249
* cell instance $78 r0 *1 25.64,9.585
X$78 3 13 M2_M1_CDNS_40661956134249
* cell instance $79 m90 *1 39.17,9.585
X$79 3 11 M2_M1_CDNS_40661956134249
* cell instance $80 m90 *1 51.02,9.585
X$80 3 9 M2_M1_CDNS_40661956134249
* cell instance $81 r0 *1 13.79,97.665
X$81 3 14 M2_M1_CDNS_40661956134249
* cell instance $82 r0 *1 25.64,97.665
X$82 3 13 M2_M1_CDNS_40661956134249
* cell instance $83 m90 *1 39.17,97.665
X$83 3 11 M2_M1_CDNS_40661956134249
* cell instance $84 m90 *1 51.02,97.665
X$84 3 9 M2_M1_CDNS_40661956134249
* cell instance $85 r0 *1 13.79,95.225
X$85 3 14 M2_M1_CDNS_40661956134249
* cell instance $86 r0 *1 25.64,95.225
X$86 3 13 M2_M1_CDNS_40661956134249
* cell instance $87 m90 *1 39.17,95.225
X$87 3 11 M2_M1_CDNS_40661956134249
* cell instance $88 m90 *1 51.02,95.225
X$88 3 9 M2_M1_CDNS_40661956134249
* cell instance $89 r0 *1 13.79,90.265
X$89 3 14 M2_M1_CDNS_40661956134249
* cell instance $90 r0 *1 25.64,90.265
X$90 3 13 M2_M1_CDNS_40661956134249
* cell instance $91 m90 *1 39.17,90.265
X$91 3 11 M2_M1_CDNS_40661956134249
* cell instance $92 m90 *1 51.02,90.265
X$92 3 9 M2_M1_CDNS_40661956134249
* cell instance $93 r0 *1 13.79,87.825
X$93 3 14 M2_M1_CDNS_40661956134249
* cell instance $94 r0 *1 25.64,87.825
X$94 3 13 M2_M1_CDNS_40661956134249
* cell instance $95 m90 *1 39.17,87.825
X$95 3 11 M2_M1_CDNS_40661956134249
* cell instance $96 m90 *1 51.02,87.825
X$96 3 9 M2_M1_CDNS_40661956134249
* cell instance $97 r0 *1 13.79,85.385
X$97 3 14 M2_M1_CDNS_40661956134249
* cell instance $98 r0 *1 25.64,85.385
X$98 3 13 M2_M1_CDNS_40661956134249
* cell instance $99 m90 *1 39.17,85.385
X$99 3 11 M2_M1_CDNS_40661956134249
* cell instance $100 m90 *1 51.02,85.385
X$100 3 9 M2_M1_CDNS_40661956134249
* cell instance $101 r0 *1 13.79,82.945
X$101 3 14 M2_M1_CDNS_40661956134249
* cell instance $102 r0 *1 25.64,82.945
X$102 3 13 M2_M1_CDNS_40661956134249
* cell instance $103 m90 *1 39.17,82.945
X$103 3 11 M2_M1_CDNS_40661956134249
* cell instance $104 m90 *1 51.02,82.945
X$104 3 9 M2_M1_CDNS_40661956134249
* cell instance $105 r0 *1 13.79,16.905
X$105 3 14 M2_M1_CDNS_40661956134249
* cell instance $106 r0 *1 25.64,16.905
X$106 3 13 M2_M1_CDNS_40661956134249
* cell instance $107 m90 *1 39.17,16.905
X$107 3 11 M2_M1_CDNS_40661956134249
* cell instance $108 m90 *1 51.02,16.905
X$108 3 9 M2_M1_CDNS_40661956134249
* cell instance $109 r0 *1 13.79,29.105
X$109 3 14 M2_M1_CDNS_40661956134249
* cell instance $110 r0 *1 25.64,29.105
X$110 3 13 M2_M1_CDNS_40661956134249
* cell instance $111 m90 *1 39.17,29.105
X$111 3 11 M2_M1_CDNS_40661956134249
* cell instance $112 m90 *1 51.02,29.105
X$112 3 9 M2_M1_CDNS_40661956134249
* cell instance $113 r0 *1 13.79,68.305
X$113 3 14 M2_M1_CDNS_40661956134249
* cell instance $114 r0 *1 25.64,68.305
X$114 3 13 M2_M1_CDNS_40661956134249
* cell instance $115 m90 *1 39.17,68.305
X$115 3 11 M2_M1_CDNS_40661956134249
* cell instance $116 m90 *1 51.02,68.305
X$116 3 9 M2_M1_CDNS_40661956134249
* cell instance $117 r0 *1 13.79,70.745
X$117 3 14 M2_M1_CDNS_40661956134249
* cell instance $118 r0 *1 25.64,70.745
X$118 3 13 M2_M1_CDNS_40661956134249
* cell instance $119 m90 *1 39.17,70.745
X$119 3 11 M2_M1_CDNS_40661956134249
* cell instance $120 m90 *1 51.02,70.745
X$120 3 9 M2_M1_CDNS_40661956134249
* cell instance $121 r0 *1 13.79,117.185
X$121 3 14 M2_M1_CDNS_40661956134249
* cell instance $122 r0 *1 25.64,117.185
X$122 3 13 M2_M1_CDNS_40661956134249
* cell instance $123 m90 *1 39.17,117.185
X$123 3 11 M2_M1_CDNS_40661956134249
* cell instance $124 m90 *1 51.02,117.185
X$124 3 9 M2_M1_CDNS_40661956134249
* cell instance $125 r0 *1 13.79,60.905
X$125 3 14 M2_M1_CDNS_40661956134249
* cell instance $126 r0 *1 25.64,60.905
X$126 3 13 M2_M1_CDNS_40661956134249
* cell instance $127 m90 *1 39.17,60.905
X$127 3 11 M2_M1_CDNS_40661956134249
* cell instance $128 m90 *1 51.02,60.905
X$128 3 9 M2_M1_CDNS_40661956134249
* cell instance $129 r0 *1 13.79,65.865
X$129 3 14 M2_M1_CDNS_40661956134249
* cell instance $130 r0 *1 25.64,65.865
X$130 3 13 M2_M1_CDNS_40661956134249
* cell instance $131 m90 *1 39.17,65.865
X$131 3 11 M2_M1_CDNS_40661956134249
* cell instance $132 m90 *1 51.02,65.865
X$132 3 9 M2_M1_CDNS_40661956134249
* cell instance $133 r0 *1 13.79,26.665
X$133 3 14 M2_M1_CDNS_40661956134249
* cell instance $134 r0 *1 25.64,26.665
X$134 3 13 M2_M1_CDNS_40661956134249
* cell instance $135 m90 *1 39.17,26.665
X$135 3 11 M2_M1_CDNS_40661956134249
* cell instance $136 m90 *1 51.02,26.665
X$136 3 9 M2_M1_CDNS_40661956134249
* cell instance $137 r0 *1 13.79,24.225
X$137 3 14 M2_M1_CDNS_40661956134249
* cell instance $138 r0 *1 25.64,24.225
X$138 3 13 M2_M1_CDNS_40661956134249
* cell instance $139 m90 *1 39.17,24.225
X$139 3 11 M2_M1_CDNS_40661956134249
* cell instance $140 m90 *1 51.02,24.225
X$140 3 9 M2_M1_CDNS_40661956134249
* cell instance $141 r0 *1 13.79,31.545
X$141 3 14 M2_M1_CDNS_40661956134249
* cell instance $142 r0 *1 25.64,31.545
X$142 3 13 M2_M1_CDNS_40661956134249
* cell instance $143 m90 *1 39.17,31.545
X$143 3 11 M2_M1_CDNS_40661956134249
* cell instance $144 m90 *1 51.02,31.545
X$144 3 9 M2_M1_CDNS_40661956134249
* cell instance $145 r0 *1 13.79,58.465
X$145 3 14 M2_M1_CDNS_40661956134249
* cell instance $146 r0 *1 25.64,58.465
X$146 3 13 M2_M1_CDNS_40661956134249
* cell instance $147 m90 *1 39.17,58.465
X$147 3 11 M2_M1_CDNS_40661956134249
* cell instance $148 m90 *1 51.02,58.465
X$148 3 9 M2_M1_CDNS_40661956134249
* cell instance $149 r0 *1 13.79,56.025
X$149 3 14 M2_M1_CDNS_40661956134249
* cell instance $150 r0 *1 25.64,56.025
X$150 3 13 M2_M1_CDNS_40661956134249
* cell instance $151 m90 *1 39.17,56.025
X$151 3 11 M2_M1_CDNS_40661956134249
* cell instance $152 m90 *1 51.02,56.025
X$152 3 9 M2_M1_CDNS_40661956134249
* cell instance $153 r0 *1 13.79,53.585
X$153 3 14 M2_M1_CDNS_40661956134249
* cell instance $154 r0 *1 25.64,53.585
X$154 3 13 M2_M1_CDNS_40661956134249
* cell instance $155 m90 *1 39.17,53.585
X$155 3 11 M2_M1_CDNS_40661956134249
* cell instance $156 m90 *1 51.02,53.585
X$156 3 9 M2_M1_CDNS_40661956134249
* cell instance $157 r0 *1 13.79,51.145
X$157 3 14 M2_M1_CDNS_40661956134249
* cell instance $158 r0 *1 25.64,51.145
X$158 3 13 M2_M1_CDNS_40661956134249
* cell instance $159 m90 *1 39.17,51.145
X$159 3 11 M2_M1_CDNS_40661956134249
* cell instance $160 m90 *1 51.02,51.145
X$160 3 9 M2_M1_CDNS_40661956134249
* cell instance $161 r0 *1 13.79,48.705
X$161 3 14 M2_M1_CDNS_40661956134249
* cell instance $162 r0 *1 25.64,48.705
X$162 3 13 M2_M1_CDNS_40661956134249
* cell instance $163 m90 *1 39.17,48.705
X$163 3 11 M2_M1_CDNS_40661956134249
* cell instance $164 m90 *1 51.02,48.705
X$164 3 9 M2_M1_CDNS_40661956134249
* cell instance $165 r0 *1 13.79,46.265
X$165 3 14 M2_M1_CDNS_40661956134249
* cell instance $166 r0 *1 25.64,46.265
X$166 3 13 M2_M1_CDNS_40661956134249
* cell instance $167 m90 *1 39.17,46.265
X$167 3 11 M2_M1_CDNS_40661956134249
* cell instance $168 m90 *1 51.02,46.265
X$168 3 9 M2_M1_CDNS_40661956134249
* cell instance $169 r0 *1 13.79,43.825
X$169 3 14 M2_M1_CDNS_40661956134249
* cell instance $170 r0 *1 25.64,43.825
X$170 3 13 M2_M1_CDNS_40661956134249
* cell instance $171 m90 *1 39.17,43.825
X$171 3 11 M2_M1_CDNS_40661956134249
* cell instance $172 m90 *1 51.02,43.825
X$172 3 9 M2_M1_CDNS_40661956134249
* cell instance $173 r0 *1 13.79,41.385
X$173 3 14 M2_M1_CDNS_40661956134249
* cell instance $174 r0 *1 25.64,41.385
X$174 3 13 M2_M1_CDNS_40661956134249
* cell instance $175 m90 *1 39.17,41.385
X$175 3 11 M2_M1_CDNS_40661956134249
* cell instance $176 m90 *1 51.02,41.385
X$176 3 9 M2_M1_CDNS_40661956134249
* cell instance $177 r0 *1 13.79,38.945
X$177 3 14 M2_M1_CDNS_40661956134249
* cell instance $178 r0 *1 25.64,38.945
X$178 3 13 M2_M1_CDNS_40661956134249
* cell instance $179 m90 *1 39.17,38.945
X$179 3 11 M2_M1_CDNS_40661956134249
* cell instance $180 m90 *1 51.02,38.945
X$180 3 9 M2_M1_CDNS_40661956134249
* cell instance $181 r0 *1 13.79,36.505
X$181 3 14 M2_M1_CDNS_40661956134249
* cell instance $182 r0 *1 25.64,36.505
X$182 3 13 M2_M1_CDNS_40661956134249
* cell instance $183 m90 *1 39.17,36.505
X$183 3 11 M2_M1_CDNS_40661956134249
* cell instance $184 m90 *1 51.02,36.505
X$184 3 9 M2_M1_CDNS_40661956134249
* cell instance $185 r0 *1 13.79,73.185
X$185 3 14 M2_M1_CDNS_40661956134249
* cell instance $186 r0 *1 25.64,73.185
X$186 3 13 M2_M1_CDNS_40661956134249
* cell instance $187 m90 *1 39.17,73.185
X$187 3 11 M2_M1_CDNS_40661956134249
* cell instance $188 m90 *1 51.02,73.185
X$188 3 9 M2_M1_CDNS_40661956134249
* cell instance $189 r0 *1 13.79,75.625
X$189 3 14 M2_M1_CDNS_40661956134249
* cell instance $190 r0 *1 25.64,75.625
X$190 3 13 M2_M1_CDNS_40661956134249
* cell instance $191 m90 *1 39.17,75.625
X$191 3 11 M2_M1_CDNS_40661956134249
* cell instance $192 m90 *1 51.02,75.625
X$192 3 9 M2_M1_CDNS_40661956134249
* cell instance $193 r0 *1 13.79,119.625
X$193 3 14 M2_M1_CDNS_40661956134249
* cell instance $194 r0 *1 25.64,119.625
X$194 3 13 M2_M1_CDNS_40661956134249
* cell instance $195 m90 *1 39.17,119.625
X$195 3 11 M2_M1_CDNS_40661956134249
* cell instance $196 m90 *1 51.02,119.625
X$196 3 9 M2_M1_CDNS_40661956134249
* cell instance $197 r0 *1 3.97,125.635
X$197 3 6 M2_M1_CDNS_40661956134248
* cell instance $198 r0 *1 13.79,125.635
X$198 3 14 M2_M1_CDNS_40661956134247
* cell instance $199 r0 *1 25.64,125.635
X$199 3 13 M2_M1_CDNS_40661956134247
* cell instance $200 m90 *1 39.17,125.635
X$200 3 11 M2_M1_CDNS_40661956134247
* cell instance $201 m90 *1 51.02,125.635
X$201 3 9 M2_M1_CDNS_40661956134247
* cell instance $202 r0 *1 60.84,125.635
X$202 3 18 M2_M1_CDNS_40661956134248
* cell instance $203 r0 *1 63.675,63.385
X$203 3 18 M2_M1_CDNS_40661956134246
* cell instance $204 r0 *1 13.79,7.145
X$204 3 14 M2_M1_CDNS_40661956134249
* cell instance $205 r0 *1 25.64,7.145
X$205 3 13 M2_M1_CDNS_40661956134249
* cell instance $206 m90 *1 39.17,7.145
X$206 3 11 M2_M1_CDNS_40661956134249
* cell instance $207 m90 *1 51.02,7.145
X$207 3 9 M2_M1_CDNS_40661956134249
* cell instance $208 r0 *1 3.97,1.135
X$208 3 6 M2_M1_CDNS_40661956134248
* cell instance $209 r0 *1 13.79,1.135
X$209 3 14 M2_M1_CDNS_40661956134247
* cell instance $210 r0 *1 25.64,1.135
X$210 3 13 M2_M1_CDNS_40661956134247
* cell instance $211 m90 *1 39.17,1.135
X$211 3 11 M2_M1_CDNS_40661956134247
* cell instance $212 m90 *1 51.02,1.135
X$212 3 9 M2_M1_CDNS_40661956134247
* cell instance $213 r0 *1 60.84,1.135
X$213 3 18 M2_M1_CDNS_40661956134248
* cell instance $214 r0 *1 1.135,63.385
X$214 3 6 M2_M1_CDNS_40661956134246
* cell instance $215 r0 *1 32.405,92.745
X$215 5 4 M1_PSUB_CDNS_40661956134134
* cell instance $216 r0 *1 32.405,63.385
X$216 5 4 M1_PSUB_CDNS_40661956134134
* cell instance $217 r0 *1 32.405,34.025
X$217 5 4 M1_PSUB_CDNS_40661956134134
* cell instance $218 r0 *1 32.405,4.135
X$218 5 4 M1_PSUB_CDNS_40661956134138
* cell instance $219 r0 *1 32.405,122.635
X$219 5 4 M1_PSUB_CDNS_40661956134138
* cell instance $220 r0 *1 3.885,63.385
X$220 5 4 M1_PSUB_CDNS_40661956134137
* cell instance $221 r0 *1 60.925,63.385
X$221 5 4 M1_PSUB_CDNS_40661956134137
* cell instance $222 r0 *1 7.865,63.385
X$222 5 8 M2_M1_CDNS_40661956134126
* cell instance $223 m90 *1 19.715,63.385
X$223 5 15 M2_M1_CDNS_40661956134126
* cell instance $224 r0 *1 32.405,63.385
X$224 5 12 M2_M1_CDNS_40661956134250
* cell instance $225 m90 *1 45.095,63.385
X$225 5 10 M2_M1_CDNS_40661956134126
* cell instance $226 m90 *1 56.945,63.385
X$226 5 17 M2_M1_CDNS_40661956134126
* cell instance $227 r0 *1 7.865,92.745
X$227 5 8 M2_M1_CDNS_40661956134126
* cell instance $228 m90 *1 19.715,92.745
X$228 5 15 M2_M1_CDNS_40661956134126
* cell instance $229 r0 *1 32.405,92.745
X$229 5 12 M2_M1_CDNS_40661956134250
* cell instance $230 m90 *1 45.095,92.745
X$230 5 10 M2_M1_CDNS_40661956134126
* cell instance $231 m90 *1 56.945,92.745
X$231 5 17 M2_M1_CDNS_40661956134126
* cell instance $232 r0 *1 7.865,15.685
X$232 5 8 M2_M1_CDNS_40661956134218
* cell instance $233 m90 *1 19.715,15.685
X$233 5 15 M2_M1_CDNS_40661956134218
* cell instance $234 r0 *1 32.405,15.685
X$234 5 12 M2_M1_CDNS_40661956134217
* cell instance $235 m90 *1 45.095,15.685
X$235 5 10 M2_M1_CDNS_40661956134218
* cell instance $236 m90 *1 56.945,15.685
X$236 5 17 M2_M1_CDNS_40661956134218
* cell instance $237 r0 *1 7.865,59.685
X$237 5 8 M2_M1_CDNS_40661956134218
* cell instance $238 m90 *1 19.715,59.685
X$238 5 15 M2_M1_CDNS_40661956134218
* cell instance $239 r0 *1 32.405,59.685
X$239 5 12 M2_M1_CDNS_40661956134217
* cell instance $240 m90 *1 45.095,59.685
X$240 5 10 M2_M1_CDNS_40661956134218
* cell instance $241 m90 *1 56.945,59.685
X$241 5 17 M2_M1_CDNS_40661956134218
* cell instance $242 r0 *1 7.865,23.005
X$242 5 8 M2_M1_CDNS_40661956134218
* cell instance $243 m90 *1 19.715,23.005
X$243 5 15 M2_M1_CDNS_40661956134218
* cell instance $244 r0 *1 32.405,23.005
X$244 5 12 M2_M1_CDNS_40661956134217
* cell instance $245 m90 *1 45.095,23.005
X$245 5 10 M2_M1_CDNS_40661956134218
* cell instance $246 m90 *1 56.945,23.005
X$246 5 17 M2_M1_CDNS_40661956134218
* cell instance $247 r0 *1 7.865,10.805
X$247 5 8 M2_M1_CDNS_40661956134218
* cell instance $248 m90 *1 19.715,10.805
X$248 5 15 M2_M1_CDNS_40661956134218
* cell instance $249 r0 *1 32.405,10.805
X$249 5 12 M2_M1_CDNS_40661956134217
* cell instance $250 m90 *1 45.095,10.805
X$250 5 10 M2_M1_CDNS_40661956134218
* cell instance $251 m90 *1 56.945,10.805
X$251 5 17 M2_M1_CDNS_40661956134218
* cell instance $252 r0 *1 7.865,20.565
X$252 5 8 M2_M1_CDNS_40661956134218
* cell instance $253 m90 *1 19.715,20.565
X$253 5 15 M2_M1_CDNS_40661956134218
* cell instance $254 r0 *1 32.405,20.565
X$254 5 12 M2_M1_CDNS_40661956134217
* cell instance $255 m90 *1 45.095,20.565
X$255 5 10 M2_M1_CDNS_40661956134218
* cell instance $256 m90 *1 56.945,20.565
X$256 5 17 M2_M1_CDNS_40661956134218
* cell instance $257 r0 *1 7.865,47.485
X$257 5 8 M2_M1_CDNS_40661956134218
* cell instance $258 m90 *1 19.715,47.485
X$258 5 15 M2_M1_CDNS_40661956134218
* cell instance $259 r0 *1 32.405,47.485
X$259 5 12 M2_M1_CDNS_40661956134217
* cell instance $260 m90 *1 45.095,47.485
X$260 5 10 M2_M1_CDNS_40661956134218
* cell instance $261 m90 *1 56.945,47.485
X$261 5 17 M2_M1_CDNS_40661956134218
* cell instance $262 r0 *1 7.865,37.725
X$262 5 8 M2_M1_CDNS_40661956134218
* cell instance $263 m90 *1 19.715,37.725
X$263 5 15 M2_M1_CDNS_40661956134218
* cell instance $264 r0 *1 32.405,37.725
X$264 5 12 M2_M1_CDNS_40661956134217
* cell instance $265 m90 *1 45.095,37.725
X$265 5 10 M2_M1_CDNS_40661956134218
* cell instance $266 m90 *1 56.945,37.725
X$266 5 17 M2_M1_CDNS_40661956134218
* cell instance $267 r0 *1 7.865,57.245
X$267 5 8 M2_M1_CDNS_40661956134218
* cell instance $268 m90 *1 19.715,57.245
X$268 5 15 M2_M1_CDNS_40661956134218
* cell instance $269 r0 *1 32.405,57.245
X$269 5 12 M2_M1_CDNS_40661956134217
* cell instance $270 m90 *1 45.095,57.245
X$270 5 10 M2_M1_CDNS_40661956134218
* cell instance $271 m90 *1 56.945,57.245
X$271 5 17 M2_M1_CDNS_40661956134218
* cell instance $272 r0 *1 7.865,54.805
X$272 5 8 M2_M1_CDNS_40661956134218
* cell instance $273 m90 *1 19.715,54.805
X$273 5 15 M2_M1_CDNS_40661956134218
* cell instance $274 r0 *1 32.405,54.805
X$274 5 12 M2_M1_CDNS_40661956134217
* cell instance $275 m90 *1 45.095,54.805
X$275 5 10 M2_M1_CDNS_40661956134218
* cell instance $276 m90 *1 56.945,54.805
X$276 5 17 M2_M1_CDNS_40661956134218
* cell instance $277 r0 *1 7.865,74.405
X$277 5 8 M2_M1_CDNS_40661956134218
* cell instance $278 m90 *1 19.715,74.405
X$278 5 15 M2_M1_CDNS_40661956134218
* cell instance $279 r0 *1 32.405,74.405
X$279 5 12 M2_M1_CDNS_40661956134217
* cell instance $280 m90 *1 45.095,74.405
X$280 5 10 M2_M1_CDNS_40661956134218
* cell instance $281 m90 *1 56.945,74.405
X$281 5 17 M2_M1_CDNS_40661956134218
* cell instance $282 r0 *1 7.865,101.325
X$282 5 8 M2_M1_CDNS_40661956134218
* cell instance $283 m90 *1 19.715,101.325
X$283 5 15 M2_M1_CDNS_40661956134218
* cell instance $284 r0 *1 32.405,101.325
X$284 5 12 M2_M1_CDNS_40661956134217
* cell instance $285 m90 *1 45.095,101.325
X$285 5 10 M2_M1_CDNS_40661956134218
* cell instance $286 m90 *1 56.945,101.325
X$286 5 17 M2_M1_CDNS_40661956134218
* cell instance $287 r0 *1 7.865,111.085
X$287 5 8 M2_M1_CDNS_40661956134218
* cell instance $288 m90 *1 19.715,111.085
X$288 5 15 M2_M1_CDNS_40661956134218
* cell instance $289 r0 *1 32.405,111.085
X$289 5 12 M2_M1_CDNS_40661956134217
* cell instance $290 m90 *1 45.095,111.085
X$290 5 10 M2_M1_CDNS_40661956134218
* cell instance $291 m90 *1 56.945,111.085
X$291 5 17 M2_M1_CDNS_40661956134218
* cell instance $292 r0 *1 7.865,118.405
X$292 5 8 M2_M1_CDNS_40661956134218
* cell instance $293 m90 *1 19.715,118.405
X$293 5 15 M2_M1_CDNS_40661956134218
* cell instance $294 r0 *1 32.405,118.405
X$294 5 12 M2_M1_CDNS_40661956134217
* cell instance $295 m90 *1 45.095,118.405
X$295 5 10 M2_M1_CDNS_40661956134218
* cell instance $296 m90 *1 56.945,118.405
X$296 5 17 M2_M1_CDNS_40661956134218
* cell instance $297 r0 *1 7.865,69.525
X$297 5 8 M2_M1_CDNS_40661956134218
* cell instance $298 m90 *1 19.715,69.525
X$298 5 15 M2_M1_CDNS_40661956134218
* cell instance $299 r0 *1 32.405,69.525
X$299 5 12 M2_M1_CDNS_40661956134217
* cell instance $300 m90 *1 45.095,69.525
X$300 5 10 M2_M1_CDNS_40661956134218
* cell instance $301 m90 *1 56.945,69.525
X$301 5 17 M2_M1_CDNS_40661956134218
* cell instance $302 r0 *1 7.865,13.245
X$302 5 8 M2_M1_CDNS_40661956134218
* cell instance $303 m90 *1 19.715,13.245
X$303 5 15 M2_M1_CDNS_40661956134218
* cell instance $304 r0 *1 32.405,13.245
X$304 5 12 M2_M1_CDNS_40661956134217
* cell instance $305 m90 *1 45.095,13.245
X$305 5 10 M2_M1_CDNS_40661956134218
* cell instance $306 m90 *1 56.945,13.245
X$306 5 17 M2_M1_CDNS_40661956134218
* cell instance $307 r0 *1 7.865,45.045
X$307 5 8 M2_M1_CDNS_40661956134218
* cell instance $308 m90 *1 19.715,45.045
X$308 5 15 M2_M1_CDNS_40661956134218
* cell instance $309 r0 *1 32.405,45.045
X$309 5 12 M2_M1_CDNS_40661956134217
* cell instance $310 m90 *1 45.095,45.045
X$310 5 10 M2_M1_CDNS_40661956134218
* cell instance $311 m90 *1 56.945,45.045
X$311 5 17 M2_M1_CDNS_40661956134218
* cell instance $312 r0 *1 7.865,40.165
X$312 5 8 M2_M1_CDNS_40661956134218
* cell instance $313 m90 *1 19.715,40.165
X$313 5 15 M2_M1_CDNS_40661956134218
* cell instance $314 r0 *1 32.405,40.165
X$314 5 12 M2_M1_CDNS_40661956134217
* cell instance $315 m90 *1 45.095,40.165
X$315 5 10 M2_M1_CDNS_40661956134218
* cell instance $316 m90 *1 56.945,40.165
X$316 5 17 M2_M1_CDNS_40661956134218
* cell instance $317 r0 *1 7.865,52.365
X$317 5 8 M2_M1_CDNS_40661956134218
* cell instance $318 m90 *1 19.715,52.365
X$318 5 15 M2_M1_CDNS_40661956134218
* cell instance $319 r0 *1 32.405,52.365
X$319 5 12 M2_M1_CDNS_40661956134217
* cell instance $320 m90 *1 45.095,52.365
X$320 5 10 M2_M1_CDNS_40661956134218
* cell instance $321 m90 *1 56.945,52.365
X$321 5 17 M2_M1_CDNS_40661956134218
* cell instance $322 r0 *1 7.865,27.885
X$322 5 8 M2_M1_CDNS_40661956134218
* cell instance $323 m90 *1 19.715,27.885
X$323 5 15 M2_M1_CDNS_40661956134218
* cell instance $324 r0 *1 32.405,27.885
X$324 5 12 M2_M1_CDNS_40661956134217
* cell instance $325 m90 *1 45.095,27.885
X$325 5 10 M2_M1_CDNS_40661956134218
* cell instance $326 m90 *1 56.945,27.885
X$326 5 17 M2_M1_CDNS_40661956134218
* cell instance $327 r0 *1 7.865,49.925
X$327 5 8 M2_M1_CDNS_40661956134218
* cell instance $328 m90 *1 19.715,49.925
X$328 5 15 M2_M1_CDNS_40661956134218
* cell instance $329 r0 *1 32.405,49.925
X$329 5 12 M2_M1_CDNS_40661956134217
* cell instance $330 m90 *1 45.095,49.925
X$330 5 10 M2_M1_CDNS_40661956134218
* cell instance $331 m90 *1 56.945,49.925
X$331 5 17 M2_M1_CDNS_40661956134218
* cell instance $332 r0 *1 7.865,18.125
X$332 5 8 M2_M1_CDNS_40661956134218
* cell instance $333 m90 *1 19.715,18.125
X$333 5 15 M2_M1_CDNS_40661956134218
* cell instance $334 r0 *1 32.405,18.125
X$334 5 12 M2_M1_CDNS_40661956134217
* cell instance $335 m90 *1 45.095,18.125
X$335 5 10 M2_M1_CDNS_40661956134218
* cell instance $336 m90 *1 56.945,18.125
X$336 5 17 M2_M1_CDNS_40661956134218
* cell instance $337 r0 *1 7.865,42.605
X$337 5 8 M2_M1_CDNS_40661956134218
* cell instance $338 m90 *1 19.715,42.605
X$338 5 15 M2_M1_CDNS_40661956134218
* cell instance $339 r0 *1 32.405,42.605
X$339 5 12 M2_M1_CDNS_40661956134217
* cell instance $340 m90 *1 45.095,42.605
X$340 5 10 M2_M1_CDNS_40661956134218
* cell instance $341 m90 *1 56.945,42.605
X$341 5 17 M2_M1_CDNS_40661956134218
* cell instance $342 r0 *1 7.865,89.045
X$342 5 8 M2_M1_CDNS_40661956134218
* cell instance $343 m90 *1 19.715,89.045
X$343 5 15 M2_M1_CDNS_40661956134218
* cell instance $344 r0 *1 32.405,89.045
X$344 5 12 M2_M1_CDNS_40661956134217
* cell instance $345 m90 *1 45.095,89.045
X$345 5 10 M2_M1_CDNS_40661956134218
* cell instance $346 m90 *1 56.945,89.045
X$346 5 17 M2_M1_CDNS_40661956134218
* cell instance $347 r0 *1 7.865,103.765
X$347 5 8 M2_M1_CDNS_40661956134218
* cell instance $348 m90 *1 19.715,103.765
X$348 5 15 M2_M1_CDNS_40661956134218
* cell instance $349 r0 *1 32.405,103.765
X$349 5 12 M2_M1_CDNS_40661956134217
* cell instance $350 m90 *1 45.095,103.765
X$350 5 10 M2_M1_CDNS_40661956134218
* cell instance $351 m90 *1 56.945,103.765
X$351 5 17 M2_M1_CDNS_40661956134218
* cell instance $352 r0 *1 7.865,25.445
X$352 5 8 M2_M1_CDNS_40661956134218
* cell instance $353 m90 *1 19.715,25.445
X$353 5 15 M2_M1_CDNS_40661956134218
* cell instance $354 r0 *1 32.405,25.445
X$354 5 12 M2_M1_CDNS_40661956134217
* cell instance $355 m90 *1 45.095,25.445
X$355 5 10 M2_M1_CDNS_40661956134218
* cell instance $356 m90 *1 56.945,25.445
X$356 5 17 M2_M1_CDNS_40661956134218
* cell instance $357 r0 *1 7.865,108.645
X$357 5 8 M2_M1_CDNS_40661956134218
* cell instance $358 m90 *1 19.715,108.645
X$358 5 15 M2_M1_CDNS_40661956134218
* cell instance $359 r0 *1 32.405,108.645
X$359 5 12 M2_M1_CDNS_40661956134217
* cell instance $360 m90 *1 45.095,108.645
X$360 5 10 M2_M1_CDNS_40661956134218
* cell instance $361 m90 *1 56.945,108.645
X$361 5 17 M2_M1_CDNS_40661956134218
* cell instance $362 r0 *1 7.865,86.605
X$362 5 8 M2_M1_CDNS_40661956134218
* cell instance $363 m90 *1 19.715,86.605
X$363 5 15 M2_M1_CDNS_40661956134218
* cell instance $364 r0 *1 32.405,86.605
X$364 5 12 M2_M1_CDNS_40661956134217
* cell instance $365 m90 *1 45.095,86.605
X$365 5 10 M2_M1_CDNS_40661956134218
* cell instance $366 m90 *1 56.945,86.605
X$366 5 17 M2_M1_CDNS_40661956134218
* cell instance $367 r0 *1 7.865,81.725
X$367 5 8 M2_M1_CDNS_40661956134218
* cell instance $368 m90 *1 19.715,81.725
X$368 5 15 M2_M1_CDNS_40661956134218
* cell instance $369 r0 *1 32.405,81.725
X$369 5 12 M2_M1_CDNS_40661956134217
* cell instance $370 m90 *1 45.095,81.725
X$370 5 10 M2_M1_CDNS_40661956134218
* cell instance $371 m90 *1 56.945,81.725
X$371 5 17 M2_M1_CDNS_40661956134218
* cell instance $372 r0 *1 7.865,79.285
X$372 5 8 M2_M1_CDNS_40661956134218
* cell instance $373 m90 *1 19.715,79.285
X$373 5 15 M2_M1_CDNS_40661956134218
* cell instance $374 r0 *1 32.405,79.285
X$374 5 12 M2_M1_CDNS_40661956134217
* cell instance $375 m90 *1 45.095,79.285
X$375 5 10 M2_M1_CDNS_40661956134218
* cell instance $376 m90 *1 56.945,79.285
X$376 5 17 M2_M1_CDNS_40661956134218
* cell instance $377 r0 *1 7.865,96.445
X$377 5 8 M2_M1_CDNS_40661956134218
* cell instance $378 m90 *1 19.715,96.445
X$378 5 15 M2_M1_CDNS_40661956134218
* cell instance $379 r0 *1 32.405,96.445
X$379 5 12 M2_M1_CDNS_40661956134217
* cell instance $380 m90 *1 45.095,96.445
X$380 5 10 M2_M1_CDNS_40661956134218
* cell instance $381 m90 *1 56.945,96.445
X$381 5 17 M2_M1_CDNS_40661956134218
* cell instance $382 r0 *1 7.865,76.845
X$382 5 8 M2_M1_CDNS_40661956134218
* cell instance $383 m90 *1 19.715,76.845
X$383 5 15 M2_M1_CDNS_40661956134218
* cell instance $384 r0 *1 32.405,76.845
X$384 5 12 M2_M1_CDNS_40661956134217
* cell instance $385 m90 *1 45.095,76.845
X$385 5 10 M2_M1_CDNS_40661956134218
* cell instance $386 m90 *1 56.945,76.845
X$386 5 17 M2_M1_CDNS_40661956134218
* cell instance $387 r0 *1 7.865,30.325
X$387 5 8 M2_M1_CDNS_40661956134218
* cell instance $388 m90 *1 19.715,30.325
X$388 5 15 M2_M1_CDNS_40661956134218
* cell instance $389 r0 *1 32.405,30.325
X$389 5 12 M2_M1_CDNS_40661956134217
* cell instance $390 m90 *1 45.095,30.325
X$390 5 10 M2_M1_CDNS_40661956134218
* cell instance $391 m90 *1 56.945,30.325
X$391 5 17 M2_M1_CDNS_40661956134218
* cell instance $392 r0 *1 7.865,113.525
X$392 5 8 M2_M1_CDNS_40661956134218
* cell instance $393 m90 *1 19.715,113.525
X$393 5 15 M2_M1_CDNS_40661956134218
* cell instance $394 r0 *1 32.405,113.525
X$394 5 12 M2_M1_CDNS_40661956134217
* cell instance $395 m90 *1 45.095,113.525
X$395 5 10 M2_M1_CDNS_40661956134218
* cell instance $396 m90 *1 56.945,113.525
X$396 5 17 M2_M1_CDNS_40661956134218
* cell instance $397 r0 *1 7.865,115.965
X$397 5 8 M2_M1_CDNS_40661956134218
* cell instance $398 m90 *1 19.715,115.965
X$398 5 15 M2_M1_CDNS_40661956134218
* cell instance $399 r0 *1 32.405,115.965
X$399 5 12 M2_M1_CDNS_40661956134217
* cell instance $400 m90 *1 45.095,115.965
X$400 5 10 M2_M1_CDNS_40661956134218
* cell instance $401 m90 *1 56.945,115.965
X$401 5 17 M2_M1_CDNS_40661956134218
* cell instance $402 r0 *1 7.865,67.085
X$402 5 8 M2_M1_CDNS_40661956134218
* cell instance $403 m90 *1 19.715,67.085
X$403 5 15 M2_M1_CDNS_40661956134218
* cell instance $404 r0 *1 32.405,67.085
X$404 5 12 M2_M1_CDNS_40661956134217
* cell instance $405 m90 *1 45.095,67.085
X$405 5 10 M2_M1_CDNS_40661956134218
* cell instance $406 m90 *1 56.945,67.085
X$406 5 17 M2_M1_CDNS_40661956134218
* cell instance $407 r0 *1 7.865,71.965
X$407 5 8 M2_M1_CDNS_40661956134218
* cell instance $408 m90 *1 19.715,71.965
X$408 5 15 M2_M1_CDNS_40661956134218
* cell instance $409 r0 *1 32.405,71.965
X$409 5 12 M2_M1_CDNS_40661956134217
* cell instance $410 m90 *1 45.095,71.965
X$410 5 10 M2_M1_CDNS_40661956134218
* cell instance $411 m90 *1 56.945,71.965
X$411 5 17 M2_M1_CDNS_40661956134218
* cell instance $412 r0 *1 7.865,98.885
X$412 5 8 M2_M1_CDNS_40661956134218
* cell instance $413 m90 *1 19.715,98.885
X$413 5 15 M2_M1_CDNS_40661956134218
* cell instance $414 r0 *1 32.405,98.885
X$414 5 12 M2_M1_CDNS_40661956134217
* cell instance $415 m90 *1 45.095,98.885
X$415 5 10 M2_M1_CDNS_40661956134218
* cell instance $416 m90 *1 56.945,98.885
X$416 5 17 M2_M1_CDNS_40661956134218
* cell instance $417 r0 *1 7.865,106.205
X$417 5 8 M2_M1_CDNS_40661956134218
* cell instance $418 m90 *1 19.715,106.205
X$418 5 15 M2_M1_CDNS_40661956134218
* cell instance $419 r0 *1 32.405,106.205
X$419 5 12 M2_M1_CDNS_40661956134217
* cell instance $420 m90 *1 45.095,106.205
X$420 5 10 M2_M1_CDNS_40661956134218
* cell instance $421 m90 *1 56.945,106.205
X$421 5 17 M2_M1_CDNS_40661956134218
* cell instance $422 r0 *1 7.865,84.165
X$422 5 8 M2_M1_CDNS_40661956134218
* cell instance $423 m90 *1 19.715,84.165
X$423 5 15 M2_M1_CDNS_40661956134218
* cell instance $424 r0 *1 32.405,84.165
X$424 5 12 M2_M1_CDNS_40661956134217
* cell instance $425 m90 *1 45.095,84.165
X$425 5 10 M2_M1_CDNS_40661956134218
* cell instance $426 m90 *1 56.945,84.165
X$426 5 17 M2_M1_CDNS_40661956134218
* cell instance $427 r0 *1 7.865,122.635
X$427 5 8 M2_M1_CDNS_40661956134206
* cell instance $428 m90 *1 19.715,122.635
X$428 5 15 M2_M1_CDNS_40661956134206
* cell instance $429 r0 *1 32.405,122.635
X$429 5 12 M2_M1_CDNS_40661956134207
* cell instance $430 m90 *1 45.095,122.635
X$430 5 10 M2_M1_CDNS_40661956134206
* cell instance $431 m90 *1 56.945,122.635
X$431 5 17 M2_M1_CDNS_40661956134206
* cell instance $432 r0 *1 7.865,34.025
X$432 5 8 M2_M1_CDNS_40661956134126
* cell instance $433 m90 *1 19.715,34.025
X$433 5 15 M2_M1_CDNS_40661956134126
* cell instance $434 r0 *1 32.405,34.025
X$434 5 12 M2_M1_CDNS_40661956134250
* cell instance $435 m90 *1 45.095,34.025
X$435 5 10 M2_M1_CDNS_40661956134126
* cell instance $436 m90 *1 56.945,34.025
X$436 5 17 M2_M1_CDNS_40661956134126
* cell instance $437 r0 *1 7.865,8.365
X$437 5 8 M2_M1_CDNS_40661956134218
* cell instance $438 m90 *1 19.715,8.365
X$438 5 15 M2_M1_CDNS_40661956134218
* cell instance $439 r0 *1 32.405,8.365
X$439 5 12 M2_M1_CDNS_40661956134217
* cell instance $440 m90 *1 45.095,8.365
X$440 5 10 M2_M1_CDNS_40661956134218
* cell instance $441 m90 *1 56.945,8.365
X$441 5 17 M2_M1_CDNS_40661956134218
* cell instance $442 r0 *1 7.865,4.135
X$442 5 8 M2_M1_CDNS_40661956134206
* cell instance $443 m90 *1 19.715,4.135
X$443 5 15 M2_M1_CDNS_40661956134206
* cell instance $444 r0 *1 32.405,4.135
X$444 5 12 M2_M1_CDNS_40661956134207
* cell instance $445 m90 *1 45.095,4.135
X$445 5 10 M2_M1_CDNS_40661956134206
* cell instance $446 m90 *1 56.945,4.135
X$446 5 17 M2_M1_CDNS_40661956134206
.ENDS nmos_clamp_20_50_4_DVDD

* cell M2_M1_CDNS_40661956134265
* pin
* pin
.SUBCKT M2_M1_CDNS_40661956134265 1 2
.ENDS M2_M1_CDNS_40661956134265

* cell M2_M1_CDNS_40661956134266
* pin
* pin
.SUBCKT M2_M1_CDNS_40661956134266 1 2
.ENDS M2_M1_CDNS_40661956134266

* cell nmos_clamp_20_50_4_DVSS
* pin
* pin
* pin
* pin
* pin
* pin
* pin
* pin
* pin
* pin
* pin
* pin
* pin
* pin
* pin
* pin
* pin gf180mcu_gnd
.SUBCKT nmos_clamp_20_50_4_DVSS 1 3 5 6 7 8 9 10 11 12 13 14 15 16 17 18 19
* net 19 gf180mcu_gnd
* cell instance $1 r90 *1 57.405,66.125
X$1 5 3 5 3 5 3 5 3 5 3 5 3 5 3 5 3 5 3 5 3 5 1 1 1 1 1 1 1 1 1 1 1 1 1 1 1 1 1
+ 1 1 1 19 nmos_6p0_CDNS_406619561341
* cell instance $2 r90 *1 57.405,36.765
X$2 5 3 5 3 5 3 5 3 5 3 5 3 5 3 5 3 5 3 5 3 5 1 1 1 1 1 1 1 1 1 1 1 1 1 1 1 1 1
+ 1 1 1 19 nmos_6p0_CDNS_406619561341
* cell instance $3 r90 *1 57.405,7.405
X$3 5 3 5 3 5 3 5 3 5 3 5 3 5 3 5 3 5 3 5 3 5 1 1 1 1 1 1 1 1 1 1 1 1 1 1 1 1 1
+ 1 1 1 19 nmos_6p0_CDNS_406619561341
* cell instance $4 r90 *1 57.405,95.485
X$4 5 3 5 3 5 3 5 3 5 3 5 3 5 3 5 3 5 3 5 3 5 1 1 1 1 1 1 1 1 1 1 1 1 1 1 1 1 1
+ 1 1 1 19 nmos_6p0_CDNS_406619561341
* cell instance $5 r0 *1 58.245,78.065
X$5 1 16 M2_M1_CDNS_40661956134141
* cell instance $6 m90 *1 58.165,78.065
X$6 1 M1_POLY2_CDNS_40661956134136
* cell instance $7 r0 *1 58.245,107.425
X$7 1 16 M2_M1_CDNS_40661956134141
* cell instance $8 m90 *1 58.165,107.425
X$8 1 M1_POLY2_CDNS_40661956134136
* cell instance $9 r0 *1 58.245,48.705
X$9 1 16 M2_M1_CDNS_40661956134141
* cell instance $10 m90 *1 58.165,48.705
X$10 1 M1_POLY2_CDNS_40661956134136
* cell instance $11 r0 *1 58.245,19.345
X$11 1 16 M2_M1_CDNS_40661956134141
* cell instance $12 m90 *1 58.165,19.345
X$12 1 M1_POLY2_CDNS_40661956134136
* cell instance $13 r0 *1 6.645,19.345
X$13 1 M1_POLY2_CDNS_40661956134136
* cell instance $14 r0 *1 6.565,19.345
X$14 1 7 M2_M1_CDNS_40661956134141
* cell instance $15 r0 *1 6.645,48.705
X$15 1 M1_POLY2_CDNS_40661956134136
* cell instance $16 r0 *1 6.565,48.705
X$16 1 7 M2_M1_CDNS_40661956134141
* cell instance $17 r0 *1 6.645,107.425
X$17 1 M1_POLY2_CDNS_40661956134136
* cell instance $18 r0 *1 6.565,107.425
X$18 1 7 M2_M1_CDNS_40661956134141
* cell instance $19 r0 *1 6.645,78.065
X$19 1 M1_POLY2_CDNS_40661956134136
* cell instance $20 r0 *1 6.565,78.065
X$20 1 7 M2_M1_CDNS_40661956134141
* cell instance $21 r0 *1 32.405,1.135
X$21 3 3 20 2 M1_NWELL_CDNS_40661956134139
* cell instance $22 r0 *1 32.405,125.635
X$22 3 3 20 2 M1_NWELL_CDNS_40661956134139
* cell instance $23 r0 *1 1.135,63.385
X$23 3 2 3 20 M1_NWELL_CDNS_40661956134135
* cell instance $24 r0 *1 63.675,63.385
X$24 3 2 3 20 M1_NWELL_CDNS_40661956134135
* cell instance $25 r0 *1 7.865,13.245
X$25 3 8 M2_M1_CDNS_40661956134218
* cell instance $26 m90 *1 19.715,13.245
X$26 3 15 M2_M1_CDNS_40661956134218
* cell instance $27 r0 *1 32.405,13.245
X$27 3 12 M2_M1_CDNS_40661956134217
* cell instance $28 m90 *1 45.095,13.245
X$28 3 10 M2_M1_CDNS_40661956134218
* cell instance $29 m90 *1 56.945,13.245
X$29 3 17 M2_M1_CDNS_40661956134218
* cell instance $30 r0 *1 7.865,15.685
X$30 3 8 M2_M1_CDNS_40661956134218
* cell instance $31 m90 *1 19.715,15.685
X$31 3 15 M2_M1_CDNS_40661956134218
* cell instance $32 r0 *1 32.405,15.685
X$32 3 12 M2_M1_CDNS_40661956134217
* cell instance $33 m90 *1 45.095,15.685
X$33 3 10 M2_M1_CDNS_40661956134218
* cell instance $34 m90 *1 56.945,15.685
X$34 3 17 M2_M1_CDNS_40661956134218
* cell instance $35 r0 *1 7.865,18.125
X$35 3 8 M2_M1_CDNS_40661956134218
* cell instance $36 m90 *1 19.715,18.125
X$36 3 15 M2_M1_CDNS_40661956134218
* cell instance $37 r0 *1 32.405,18.125
X$37 3 12 M2_M1_CDNS_40661956134217
* cell instance $38 m90 *1 45.095,18.125
X$38 3 10 M2_M1_CDNS_40661956134218
* cell instance $39 m90 *1 56.945,18.125
X$39 3 17 M2_M1_CDNS_40661956134218
* cell instance $40 r0 *1 7.865,20.565
X$40 3 8 M2_M1_CDNS_40661956134218
* cell instance $41 m90 *1 19.715,20.565
X$41 3 15 M2_M1_CDNS_40661956134218
* cell instance $42 r0 *1 32.405,20.565
X$42 3 12 M2_M1_CDNS_40661956134217
* cell instance $43 m90 *1 45.095,20.565
X$43 3 10 M2_M1_CDNS_40661956134218
* cell instance $44 m90 *1 56.945,20.565
X$44 3 17 M2_M1_CDNS_40661956134218
* cell instance $45 r0 *1 7.865,23.005
X$45 3 8 M2_M1_CDNS_40661956134218
* cell instance $46 m90 *1 19.715,23.005
X$46 3 15 M2_M1_CDNS_40661956134218
* cell instance $47 r0 *1 32.405,23.005
X$47 3 12 M2_M1_CDNS_40661956134217
* cell instance $48 m90 *1 45.095,23.005
X$48 3 10 M2_M1_CDNS_40661956134218
* cell instance $49 m90 *1 56.945,23.005
X$49 3 17 M2_M1_CDNS_40661956134218
* cell instance $50 r0 *1 7.865,25.445
X$50 3 8 M2_M1_CDNS_40661956134218
* cell instance $51 m90 *1 19.715,25.445
X$51 3 15 M2_M1_CDNS_40661956134218
* cell instance $52 r0 *1 32.405,25.445
X$52 3 12 M2_M1_CDNS_40661956134217
* cell instance $53 m90 *1 45.095,25.445
X$53 3 10 M2_M1_CDNS_40661956134218
* cell instance $54 m90 *1 56.945,25.445
X$54 3 17 M2_M1_CDNS_40661956134218
* cell instance $55 r0 *1 7.865,27.885
X$55 3 8 M2_M1_CDNS_40661956134218
* cell instance $56 m90 *1 19.715,27.885
X$56 3 15 M2_M1_CDNS_40661956134218
* cell instance $57 r0 *1 32.405,27.885
X$57 3 12 M2_M1_CDNS_40661956134217
* cell instance $58 m90 *1 45.095,27.885
X$58 3 10 M2_M1_CDNS_40661956134218
* cell instance $59 m90 *1 56.945,27.885
X$59 3 17 M2_M1_CDNS_40661956134218
* cell instance $60 r0 *1 7.865,71.965
X$60 3 8 M2_M1_CDNS_40661956134218
* cell instance $61 m90 *1 19.715,71.965
X$61 3 15 M2_M1_CDNS_40661956134218
* cell instance $62 r0 *1 32.405,71.965
X$62 3 12 M2_M1_CDNS_40661956134217
* cell instance $63 m90 *1 45.095,71.965
X$63 3 10 M2_M1_CDNS_40661956134218
* cell instance $64 m90 *1 56.945,71.965
X$64 3 17 M2_M1_CDNS_40661956134218
* cell instance $65 r0 *1 7.865,103.765
X$65 3 8 M2_M1_CDNS_40661956134218
* cell instance $66 m90 *1 19.715,103.765
X$66 3 15 M2_M1_CDNS_40661956134218
* cell instance $67 r0 *1 32.405,103.765
X$67 3 12 M2_M1_CDNS_40661956134217
* cell instance $68 m90 *1 45.095,103.765
X$68 3 10 M2_M1_CDNS_40661956134218
* cell instance $69 m90 *1 56.945,103.765
X$69 3 17 M2_M1_CDNS_40661956134218
* cell instance $70 r0 *1 7.865,98.885
X$70 3 8 M2_M1_CDNS_40661956134218
* cell instance $71 m90 *1 19.715,98.885
X$71 3 15 M2_M1_CDNS_40661956134218
* cell instance $72 r0 *1 32.405,98.885
X$72 3 12 M2_M1_CDNS_40661956134217
* cell instance $73 m90 *1 45.095,98.885
X$73 3 10 M2_M1_CDNS_40661956134218
* cell instance $74 m90 *1 56.945,98.885
X$74 3 17 M2_M1_CDNS_40661956134218
* cell instance $75 r0 *1 7.865,111.085
X$75 3 8 M2_M1_CDNS_40661956134218
* cell instance $76 m90 *1 19.715,111.085
X$76 3 15 M2_M1_CDNS_40661956134218
* cell instance $77 r0 *1 32.405,111.085
X$77 3 12 M2_M1_CDNS_40661956134217
* cell instance $78 m90 *1 45.095,111.085
X$78 3 10 M2_M1_CDNS_40661956134218
* cell instance $79 m90 *1 56.945,111.085
X$79 3 17 M2_M1_CDNS_40661956134218
* cell instance $80 r0 *1 7.865,115.965
X$80 3 8 M2_M1_CDNS_40661956134218
* cell instance $81 m90 *1 19.715,115.965
X$81 3 15 M2_M1_CDNS_40661956134218
* cell instance $82 r0 *1 32.405,115.965
X$82 3 12 M2_M1_CDNS_40661956134217
* cell instance $83 m90 *1 45.095,115.965
X$83 3 10 M2_M1_CDNS_40661956134218
* cell instance $84 m90 *1 56.945,115.965
X$84 3 17 M2_M1_CDNS_40661956134218
* cell instance $85 r0 *1 7.865,118.405
X$85 3 8 M2_M1_CDNS_40661956134218
* cell instance $86 m90 *1 19.715,118.405
X$86 3 15 M2_M1_CDNS_40661956134218
* cell instance $87 r0 *1 32.405,118.405
X$87 3 12 M2_M1_CDNS_40661956134217
* cell instance $88 m90 *1 45.095,118.405
X$88 3 10 M2_M1_CDNS_40661956134218
* cell instance $89 m90 *1 56.945,118.405
X$89 3 17 M2_M1_CDNS_40661956134218
* cell instance $90 r0 *1 7.865,69.525
X$90 3 8 M2_M1_CDNS_40661956134218
* cell instance $91 m90 *1 19.715,69.525
X$91 3 15 M2_M1_CDNS_40661956134218
* cell instance $92 r0 *1 32.405,69.525
X$92 3 12 M2_M1_CDNS_40661956134217
* cell instance $93 m90 *1 45.095,69.525
X$93 3 10 M2_M1_CDNS_40661956134218
* cell instance $94 m90 *1 56.945,69.525
X$94 3 17 M2_M1_CDNS_40661956134218
* cell instance $95 r0 *1 7.865,96.445
X$95 3 8 M2_M1_CDNS_40661956134218
* cell instance $96 m90 *1 19.715,96.445
X$96 3 15 M2_M1_CDNS_40661956134218
* cell instance $97 r0 *1 32.405,96.445
X$97 3 12 M2_M1_CDNS_40661956134217
* cell instance $98 m90 *1 45.095,96.445
X$98 3 10 M2_M1_CDNS_40661956134218
* cell instance $99 m90 *1 56.945,96.445
X$99 3 17 M2_M1_CDNS_40661956134218
* cell instance $100 r0 *1 7.865,47.485
X$100 3 8 M2_M1_CDNS_40661956134218
* cell instance $101 m90 *1 19.715,47.485
X$101 3 15 M2_M1_CDNS_40661956134218
* cell instance $102 r0 *1 32.405,47.485
X$102 3 12 M2_M1_CDNS_40661956134217
* cell instance $103 m90 *1 45.095,47.485
X$103 3 10 M2_M1_CDNS_40661956134218
* cell instance $104 m90 *1 56.945,47.485
X$104 3 17 M2_M1_CDNS_40661956134218
* cell instance $105 r0 *1 7.865,45.045
X$105 3 8 M2_M1_CDNS_40661956134218
* cell instance $106 m90 *1 19.715,45.045
X$106 3 15 M2_M1_CDNS_40661956134218
* cell instance $107 r0 *1 32.405,45.045
X$107 3 12 M2_M1_CDNS_40661956134217
* cell instance $108 m90 *1 45.095,45.045
X$108 3 10 M2_M1_CDNS_40661956134218
* cell instance $109 m90 *1 56.945,45.045
X$109 3 17 M2_M1_CDNS_40661956134218
* cell instance $110 r0 *1 7.865,40.165
X$110 3 8 M2_M1_CDNS_40661956134218
* cell instance $111 m90 *1 19.715,40.165
X$111 3 15 M2_M1_CDNS_40661956134218
* cell instance $112 r0 *1 32.405,40.165
X$112 3 12 M2_M1_CDNS_40661956134217
* cell instance $113 m90 *1 45.095,40.165
X$113 3 10 M2_M1_CDNS_40661956134218
* cell instance $114 m90 *1 56.945,40.165
X$114 3 17 M2_M1_CDNS_40661956134218
* cell instance $115 r0 *1 7.865,30.325
X$115 3 8 M2_M1_CDNS_40661956134218
* cell instance $116 m90 *1 19.715,30.325
X$116 3 15 M2_M1_CDNS_40661956134218
* cell instance $117 r0 *1 32.405,30.325
X$117 3 12 M2_M1_CDNS_40661956134217
* cell instance $118 m90 *1 45.095,30.325
X$118 3 10 M2_M1_CDNS_40661956134218
* cell instance $119 m90 *1 56.945,30.325
X$119 3 17 M2_M1_CDNS_40661956134218
* cell instance $120 r0 *1 7.865,84.165
X$120 3 8 M2_M1_CDNS_40661956134218
* cell instance $121 m90 *1 19.715,84.165
X$121 3 15 M2_M1_CDNS_40661956134218
* cell instance $122 r0 *1 32.405,84.165
X$122 3 12 M2_M1_CDNS_40661956134217
* cell instance $123 m90 *1 45.095,84.165
X$123 3 10 M2_M1_CDNS_40661956134218
* cell instance $124 m90 *1 56.945,84.165
X$124 3 17 M2_M1_CDNS_40661956134218
* cell instance $125 r0 *1 7.865,86.605
X$125 3 8 M2_M1_CDNS_40661956134218
* cell instance $126 m90 *1 19.715,86.605
X$126 3 15 M2_M1_CDNS_40661956134218
* cell instance $127 r0 *1 32.405,86.605
X$127 3 12 M2_M1_CDNS_40661956134217
* cell instance $128 m90 *1 45.095,86.605
X$128 3 10 M2_M1_CDNS_40661956134218
* cell instance $129 m90 *1 56.945,86.605
X$129 3 17 M2_M1_CDNS_40661956134218
* cell instance $130 r0 *1 7.865,89.045
X$130 3 8 M2_M1_CDNS_40661956134218
* cell instance $131 m90 *1 19.715,89.045
X$131 3 15 M2_M1_CDNS_40661956134218
* cell instance $132 r0 *1 32.405,89.045
X$132 3 12 M2_M1_CDNS_40661956134217
* cell instance $133 m90 *1 45.095,89.045
X$133 3 10 M2_M1_CDNS_40661956134218
* cell instance $134 m90 *1 56.945,89.045
X$134 3 17 M2_M1_CDNS_40661956134218
* cell instance $135 r0 *1 7.865,108.645
X$135 3 8 M2_M1_CDNS_40661956134218
* cell instance $136 m90 *1 19.715,108.645
X$136 3 15 M2_M1_CDNS_40661956134218
* cell instance $137 r0 *1 32.405,108.645
X$137 3 12 M2_M1_CDNS_40661956134217
* cell instance $138 m90 *1 45.095,108.645
X$138 3 10 M2_M1_CDNS_40661956134218
* cell instance $139 m90 *1 56.945,108.645
X$139 3 17 M2_M1_CDNS_40661956134218
* cell instance $140 r0 *1 7.865,106.205
X$140 3 8 M2_M1_CDNS_40661956134218
* cell instance $141 m90 *1 19.715,106.205
X$141 3 15 M2_M1_CDNS_40661956134218
* cell instance $142 r0 *1 32.405,106.205
X$142 3 12 M2_M1_CDNS_40661956134217
* cell instance $143 m90 *1 45.095,106.205
X$143 3 10 M2_M1_CDNS_40661956134218
* cell instance $144 m90 *1 56.945,106.205
X$144 3 17 M2_M1_CDNS_40661956134218
* cell instance $145 r0 *1 7.865,81.725
X$145 3 8 M2_M1_CDNS_40661956134218
* cell instance $146 m90 *1 19.715,81.725
X$146 3 15 M2_M1_CDNS_40661956134218
* cell instance $147 r0 *1 32.405,81.725
X$147 3 12 M2_M1_CDNS_40661956134217
* cell instance $148 m90 *1 45.095,81.725
X$148 3 10 M2_M1_CDNS_40661956134218
* cell instance $149 m90 *1 56.945,81.725
X$149 3 17 M2_M1_CDNS_40661956134218
* cell instance $150 r0 *1 7.865,10.805
X$150 3 8 M2_M1_CDNS_40661956134218
* cell instance $151 m90 *1 19.715,10.805
X$151 3 15 M2_M1_CDNS_40661956134218
* cell instance $152 r0 *1 32.405,10.805
X$152 3 12 M2_M1_CDNS_40661956134217
* cell instance $153 m90 *1 45.095,10.805
X$153 3 10 M2_M1_CDNS_40661956134218
* cell instance $154 m90 *1 56.945,10.805
X$154 3 17 M2_M1_CDNS_40661956134218
* cell instance $155 r0 *1 7.865,8.365
X$155 3 8 M2_M1_CDNS_40661956134218
* cell instance $156 m90 *1 19.715,8.365
X$156 3 15 M2_M1_CDNS_40661956134218
* cell instance $157 r0 *1 32.405,8.365
X$157 3 12 M2_M1_CDNS_40661956134217
* cell instance $158 m90 *1 45.095,8.365
X$158 3 10 M2_M1_CDNS_40661956134218
* cell instance $159 m90 *1 56.945,8.365
X$159 3 17 M2_M1_CDNS_40661956134218
* cell instance $160 r0 *1 7.865,59.685
X$160 3 8 M2_M1_CDNS_40661956134218
* cell instance $161 m90 *1 19.715,59.685
X$161 3 15 M2_M1_CDNS_40661956134218
* cell instance $162 r0 *1 32.405,59.685
X$162 3 12 M2_M1_CDNS_40661956134217
* cell instance $163 m90 *1 45.095,59.685
X$163 3 10 M2_M1_CDNS_40661956134218
* cell instance $164 m90 *1 56.945,59.685
X$164 3 17 M2_M1_CDNS_40661956134218
* cell instance $165 r0 *1 7.865,42.605
X$165 3 8 M2_M1_CDNS_40661956134218
* cell instance $166 m90 *1 19.715,42.605
X$166 3 15 M2_M1_CDNS_40661956134218
* cell instance $167 r0 *1 32.405,42.605
X$167 3 12 M2_M1_CDNS_40661956134217
* cell instance $168 m90 *1 45.095,42.605
X$168 3 10 M2_M1_CDNS_40661956134218
* cell instance $169 m90 *1 56.945,42.605
X$169 3 17 M2_M1_CDNS_40661956134218
* cell instance $170 r0 *1 7.865,79.285
X$170 3 8 M2_M1_CDNS_40661956134218
* cell instance $171 m90 *1 19.715,79.285
X$171 3 15 M2_M1_CDNS_40661956134218
* cell instance $172 r0 *1 32.405,79.285
X$172 3 12 M2_M1_CDNS_40661956134217
* cell instance $173 m90 *1 45.095,79.285
X$173 3 10 M2_M1_CDNS_40661956134218
* cell instance $174 m90 *1 56.945,79.285
X$174 3 17 M2_M1_CDNS_40661956134218
* cell instance $175 r0 *1 7.865,76.845
X$175 3 8 M2_M1_CDNS_40661956134218
* cell instance $176 m90 *1 19.715,76.845
X$176 3 15 M2_M1_CDNS_40661956134218
* cell instance $177 r0 *1 32.405,76.845
X$177 3 12 M2_M1_CDNS_40661956134217
* cell instance $178 m90 *1 45.095,76.845
X$178 3 10 M2_M1_CDNS_40661956134218
* cell instance $179 m90 *1 56.945,76.845
X$179 3 17 M2_M1_CDNS_40661956134218
* cell instance $180 r0 *1 7.865,74.405
X$180 3 8 M2_M1_CDNS_40661956134218
* cell instance $181 m90 *1 19.715,74.405
X$181 3 15 M2_M1_CDNS_40661956134218
* cell instance $182 r0 *1 32.405,74.405
X$182 3 12 M2_M1_CDNS_40661956134217
* cell instance $183 m90 *1 45.095,74.405
X$183 3 10 M2_M1_CDNS_40661956134218
* cell instance $184 m90 *1 56.945,74.405
X$184 3 17 M2_M1_CDNS_40661956134218
* cell instance $185 r0 *1 7.865,67.085
X$185 3 8 M2_M1_CDNS_40661956134218
* cell instance $186 m90 *1 19.715,67.085
X$186 3 15 M2_M1_CDNS_40661956134218
* cell instance $187 r0 *1 32.405,67.085
X$187 3 12 M2_M1_CDNS_40661956134217
* cell instance $188 m90 *1 45.095,67.085
X$188 3 10 M2_M1_CDNS_40661956134218
* cell instance $189 m90 *1 56.945,67.085
X$189 3 17 M2_M1_CDNS_40661956134218
* cell instance $190 r0 *1 7.865,101.325
X$190 3 8 M2_M1_CDNS_40661956134218
* cell instance $191 m90 *1 19.715,101.325
X$191 3 15 M2_M1_CDNS_40661956134218
* cell instance $192 r0 *1 32.405,101.325
X$192 3 12 M2_M1_CDNS_40661956134217
* cell instance $193 m90 *1 45.095,101.325
X$193 3 10 M2_M1_CDNS_40661956134218
* cell instance $194 m90 *1 56.945,101.325
X$194 3 17 M2_M1_CDNS_40661956134218
* cell instance $195 r0 *1 7.865,37.725
X$195 3 8 M2_M1_CDNS_40661956134218
* cell instance $196 m90 *1 19.715,37.725
X$196 3 15 M2_M1_CDNS_40661956134218
* cell instance $197 r0 *1 32.405,37.725
X$197 3 12 M2_M1_CDNS_40661956134217
* cell instance $198 m90 *1 45.095,37.725
X$198 3 10 M2_M1_CDNS_40661956134218
* cell instance $199 m90 *1 56.945,37.725
X$199 3 17 M2_M1_CDNS_40661956134218
* cell instance $200 r0 *1 7.865,57.245
X$200 3 8 M2_M1_CDNS_40661956134218
* cell instance $201 m90 *1 19.715,57.245
X$201 3 15 M2_M1_CDNS_40661956134218
* cell instance $202 r0 *1 32.405,57.245
X$202 3 12 M2_M1_CDNS_40661956134217
* cell instance $203 m90 *1 45.095,57.245
X$203 3 10 M2_M1_CDNS_40661956134218
* cell instance $204 m90 *1 56.945,57.245
X$204 3 17 M2_M1_CDNS_40661956134218
* cell instance $205 r0 *1 7.865,54.805
X$205 3 8 M2_M1_CDNS_40661956134218
* cell instance $206 m90 *1 19.715,54.805
X$206 3 15 M2_M1_CDNS_40661956134218
* cell instance $207 r0 *1 32.405,54.805
X$207 3 12 M2_M1_CDNS_40661956134217
* cell instance $208 m90 *1 45.095,54.805
X$208 3 10 M2_M1_CDNS_40661956134218
* cell instance $209 m90 *1 56.945,54.805
X$209 3 17 M2_M1_CDNS_40661956134218
* cell instance $210 r0 *1 7.865,52.365
X$210 3 8 M2_M1_CDNS_40661956134218
* cell instance $211 m90 *1 19.715,52.365
X$211 3 15 M2_M1_CDNS_40661956134218
* cell instance $212 r0 *1 32.405,52.365
X$212 3 12 M2_M1_CDNS_40661956134217
* cell instance $213 m90 *1 45.095,52.365
X$213 3 10 M2_M1_CDNS_40661956134218
* cell instance $214 m90 *1 56.945,52.365
X$214 3 17 M2_M1_CDNS_40661956134218
* cell instance $215 r0 *1 7.865,113.525
X$215 3 8 M2_M1_CDNS_40661956134218
* cell instance $216 m90 *1 19.715,113.525
X$216 3 15 M2_M1_CDNS_40661956134218
* cell instance $217 r0 *1 32.405,113.525
X$217 3 12 M2_M1_CDNS_40661956134217
* cell instance $218 m90 *1 45.095,113.525
X$218 3 10 M2_M1_CDNS_40661956134218
* cell instance $219 m90 *1 56.945,113.525
X$219 3 17 M2_M1_CDNS_40661956134218
* cell instance $220 r0 *1 7.865,49.925
X$220 3 8 M2_M1_CDNS_40661956134218
* cell instance $221 m90 *1 19.715,49.925
X$221 3 15 M2_M1_CDNS_40661956134218
* cell instance $222 r0 *1 32.405,49.925
X$222 3 12 M2_M1_CDNS_40661956134217
* cell instance $223 m90 *1 45.095,49.925
X$223 3 10 M2_M1_CDNS_40661956134218
* cell instance $224 m90 *1 56.945,49.925
X$224 3 17 M2_M1_CDNS_40661956134218
* cell instance $225 r0 *1 7.865,1.135
X$225 3 8 M2_M1_CDNS_40661956134206
* cell instance $226 m90 *1 19.715,1.135
X$226 3 15 M2_M1_CDNS_40661956134206
* cell instance $227 r0 *1 32.405,1.135
X$227 3 12 M2_M1_CDNS_40661956134207
* cell instance $228 m90 *1 45.095,1.135
X$228 3 10 M2_M1_CDNS_40661956134206
* cell instance $229 m90 *1 56.945,1.135
X$229 3 17 M2_M1_CDNS_40661956134206
* cell instance $230 r0 *1 7.865,125.635
X$230 3 8 M2_M1_CDNS_40661956134206
* cell instance $231 m90 *1 19.715,125.635
X$231 3 15 M2_M1_CDNS_40661956134206
* cell instance $232 r0 *1 32.405,125.635
X$232 3 12 M2_M1_CDNS_40661956134207
* cell instance $233 m90 *1 45.095,125.635
X$233 3 10 M2_M1_CDNS_40661956134206
* cell instance $234 m90 *1 56.945,125.635
X$234 3 17 M2_M1_CDNS_40661956134206
* cell instance $235 r0 *1 32.405,34.025
X$235 5 4 M1_PSUB_CDNS_40661956134134
* cell instance $236 r0 *1 32.405,63.385
X$236 5 4 M1_PSUB_CDNS_40661956134134
* cell instance $237 r0 *1 32.405,92.745
X$237 5 4 M1_PSUB_CDNS_40661956134134
* cell instance $238 r0 *1 32.405,4.135
X$238 5 4 M1_PSUB_CDNS_40661956134138
* cell instance $239 r0 *1 32.405,122.635
X$239 5 4 M1_PSUB_CDNS_40661956134138
* cell instance $240 r0 *1 3.885,63.385
X$240 5 4 M1_PSUB_CDNS_40661956134137
* cell instance $241 r0 *1 60.925,63.385
X$241 5 4 M1_PSUB_CDNS_40661956134137
* cell instance $242 r0 *1 13.79,63.385
X$242 5 14 M2_M1_CDNS_40661956134255
* cell instance $243 r0 *1 25.64,63.385
X$243 5 13 M2_M1_CDNS_40661956134255
* cell instance $244 m90 *1 39.17,63.385
X$244 5 11 M2_M1_CDNS_40661956134255
* cell instance $245 m90 *1 51.02,63.385
X$245 5 9 M2_M1_CDNS_40661956134255
* cell instance $246 r0 *1 13.79,92.745
X$246 5 14 M2_M1_CDNS_40661956134255
* cell instance $247 r0 *1 25.64,92.745
X$247 5 13 M2_M1_CDNS_40661956134255
* cell instance $248 m90 *1 39.17,92.745
X$248 5 11 M2_M1_CDNS_40661956134255
* cell instance $249 m90 *1 51.02,92.745
X$249 5 9 M2_M1_CDNS_40661956134255
* cell instance $250 r0 *1 60.925,63.385
X$250 5 18 M2_M1_CDNS_40661956134268
* cell instance $251 r0 *1 13.79,29.105
X$251 5 14 M2_M1_CDNS_40661956134249
* cell instance $252 r0 *1 25.64,29.105
X$252 5 13 M2_M1_CDNS_40661956134249
* cell instance $253 m90 *1 39.17,29.105
X$253 5 11 M2_M1_CDNS_40661956134249
* cell instance $254 m90 *1 51.02,29.105
X$254 5 9 M2_M1_CDNS_40661956134249
* cell instance $255 r0 *1 13.79,31.545
X$255 5 14 M2_M1_CDNS_40661956134249
* cell instance $256 r0 *1 25.64,31.545
X$256 5 13 M2_M1_CDNS_40661956134249
* cell instance $257 m90 *1 39.17,31.545
X$257 5 11 M2_M1_CDNS_40661956134249
* cell instance $258 m90 *1 51.02,31.545
X$258 5 9 M2_M1_CDNS_40661956134249
* cell instance $259 r0 *1 13.79,46.265
X$259 5 14 M2_M1_CDNS_40661956134249
* cell instance $260 r0 *1 25.64,46.265
X$260 5 13 M2_M1_CDNS_40661956134249
* cell instance $261 m90 *1 39.17,46.265
X$261 5 11 M2_M1_CDNS_40661956134249
* cell instance $262 m90 *1 51.02,46.265
X$262 5 9 M2_M1_CDNS_40661956134249
* cell instance $263 r0 *1 13.79,43.825
X$263 5 14 M2_M1_CDNS_40661956134249
* cell instance $264 r0 *1 25.64,43.825
X$264 5 13 M2_M1_CDNS_40661956134249
* cell instance $265 m90 *1 39.17,43.825
X$265 5 11 M2_M1_CDNS_40661956134249
* cell instance $266 m90 *1 51.02,43.825
X$266 5 9 M2_M1_CDNS_40661956134249
* cell instance $267 r0 *1 13.79,41.385
X$267 5 14 M2_M1_CDNS_40661956134249
* cell instance $268 r0 *1 25.64,41.385
X$268 5 13 M2_M1_CDNS_40661956134249
* cell instance $269 m90 *1 39.17,41.385
X$269 5 11 M2_M1_CDNS_40661956134249
* cell instance $270 m90 *1 51.02,41.385
X$270 5 9 M2_M1_CDNS_40661956134249
* cell instance $271 r0 *1 13.79,38.945
X$271 5 14 M2_M1_CDNS_40661956134249
* cell instance $272 r0 *1 25.64,38.945
X$272 5 13 M2_M1_CDNS_40661956134249
* cell instance $273 m90 *1 39.17,38.945
X$273 5 11 M2_M1_CDNS_40661956134249
* cell instance $274 m90 *1 51.02,38.945
X$274 5 9 M2_M1_CDNS_40661956134249
* cell instance $275 r0 *1 13.79,36.505
X$275 5 14 M2_M1_CDNS_40661956134249
* cell instance $276 r0 *1 25.64,36.505
X$276 5 13 M2_M1_CDNS_40661956134249
* cell instance $277 m90 *1 39.17,36.505
X$277 5 11 M2_M1_CDNS_40661956134249
* cell instance $278 m90 *1 51.02,36.505
X$278 5 9 M2_M1_CDNS_40661956134249
* cell instance $279 r0 *1 13.79,60.905
X$279 5 14 M2_M1_CDNS_40661956134249
* cell instance $280 r0 *1 25.64,60.905
X$280 5 13 M2_M1_CDNS_40661956134249
* cell instance $281 m90 *1 39.17,60.905
X$281 5 11 M2_M1_CDNS_40661956134249
* cell instance $282 m90 *1 51.02,60.905
X$282 5 9 M2_M1_CDNS_40661956134249
* cell instance $283 r0 *1 13.79,80.505
X$283 5 14 M2_M1_CDNS_40661956134249
* cell instance $284 r0 *1 25.64,80.505
X$284 5 13 M2_M1_CDNS_40661956134249
* cell instance $285 m90 *1 39.17,80.505
X$285 5 11 M2_M1_CDNS_40661956134249
* cell instance $286 m90 *1 51.02,80.505
X$286 5 9 M2_M1_CDNS_40661956134249
* cell instance $287 r0 *1 13.79,75.625
X$287 5 14 M2_M1_CDNS_40661956134249
* cell instance $288 r0 *1 25.64,75.625
X$288 5 13 M2_M1_CDNS_40661956134249
* cell instance $289 m90 *1 39.17,75.625
X$289 5 11 M2_M1_CDNS_40661956134249
* cell instance $290 m90 *1 51.02,75.625
X$290 5 9 M2_M1_CDNS_40661956134249
* cell instance $291 r0 *1 13.79,73.185
X$291 5 14 M2_M1_CDNS_40661956134249
* cell instance $292 r0 *1 25.64,73.185
X$292 5 13 M2_M1_CDNS_40661956134249
* cell instance $293 m90 *1 39.17,73.185
X$293 5 11 M2_M1_CDNS_40661956134249
* cell instance $294 m90 *1 51.02,73.185
X$294 5 9 M2_M1_CDNS_40661956134249
* cell instance $295 r0 *1 13.79,70.745
X$295 5 14 M2_M1_CDNS_40661956134249
* cell instance $296 r0 *1 25.64,70.745
X$296 5 13 M2_M1_CDNS_40661956134249
* cell instance $297 m90 *1 39.17,70.745
X$297 5 11 M2_M1_CDNS_40661956134249
* cell instance $298 m90 *1 51.02,70.745
X$298 5 9 M2_M1_CDNS_40661956134249
* cell instance $299 r0 *1 13.79,68.305
X$299 5 14 M2_M1_CDNS_40661956134249
* cell instance $300 r0 *1 25.64,68.305
X$300 5 13 M2_M1_CDNS_40661956134249
* cell instance $301 m90 *1 39.17,68.305
X$301 5 11 M2_M1_CDNS_40661956134249
* cell instance $302 m90 *1 51.02,68.305
X$302 5 9 M2_M1_CDNS_40661956134249
* cell instance $303 r0 *1 13.79,65.865
X$303 5 14 M2_M1_CDNS_40661956134249
* cell instance $304 r0 *1 25.64,65.865
X$304 5 13 M2_M1_CDNS_40661956134249
* cell instance $305 m90 *1 39.17,65.865
X$305 5 11 M2_M1_CDNS_40661956134249
* cell instance $306 m90 *1 51.02,65.865
X$306 5 9 M2_M1_CDNS_40661956134249
* cell instance $307 r0 *1 13.79,85.385
X$307 5 14 M2_M1_CDNS_40661956134249
* cell instance $308 r0 *1 25.64,85.385
X$308 5 13 M2_M1_CDNS_40661956134249
* cell instance $309 m90 *1 39.17,85.385
X$309 5 11 M2_M1_CDNS_40661956134249
* cell instance $310 m90 *1 51.02,85.385
X$310 5 9 M2_M1_CDNS_40661956134249
* cell instance $311 r0 *1 13.79,82.945
X$311 5 14 M2_M1_CDNS_40661956134249
* cell instance $312 r0 *1 25.64,82.945
X$312 5 13 M2_M1_CDNS_40661956134249
* cell instance $313 m90 *1 39.17,82.945
X$313 5 11 M2_M1_CDNS_40661956134249
* cell instance $314 m90 *1 51.02,82.945
X$314 5 9 M2_M1_CDNS_40661956134249
* cell instance $315 r0 *1 13.79,87.825
X$315 5 14 M2_M1_CDNS_40661956134249
* cell instance $316 r0 *1 25.64,87.825
X$316 5 13 M2_M1_CDNS_40661956134249
* cell instance $317 m90 *1 39.17,87.825
X$317 5 11 M2_M1_CDNS_40661956134249
* cell instance $318 m90 *1 51.02,87.825
X$318 5 9 M2_M1_CDNS_40661956134249
* cell instance $319 r0 *1 13.79,90.265
X$319 5 14 M2_M1_CDNS_40661956134249
* cell instance $320 r0 *1 25.64,90.265
X$320 5 13 M2_M1_CDNS_40661956134249
* cell instance $321 m90 *1 39.17,90.265
X$321 5 11 M2_M1_CDNS_40661956134249
* cell instance $322 m90 *1 51.02,90.265
X$322 5 9 M2_M1_CDNS_40661956134249
* cell instance $323 r0 *1 13.79,95.225
X$323 5 14 M2_M1_CDNS_40661956134249
* cell instance $324 r0 *1 25.64,95.225
X$324 5 13 M2_M1_CDNS_40661956134249
* cell instance $325 m90 *1 39.17,95.225
X$325 5 11 M2_M1_CDNS_40661956134249
* cell instance $326 m90 *1 51.02,95.225
X$326 5 9 M2_M1_CDNS_40661956134249
* cell instance $327 r0 *1 13.79,97.665
X$327 5 14 M2_M1_CDNS_40661956134249
* cell instance $328 r0 *1 25.64,97.665
X$328 5 13 M2_M1_CDNS_40661956134249
* cell instance $329 m90 *1 39.17,97.665
X$329 5 11 M2_M1_CDNS_40661956134249
* cell instance $330 m90 *1 51.02,97.665
X$330 5 9 M2_M1_CDNS_40661956134249
* cell instance $331 r0 *1 13.79,100.105
X$331 5 14 M2_M1_CDNS_40661956134249
* cell instance $332 r0 *1 25.64,100.105
X$332 5 13 M2_M1_CDNS_40661956134249
* cell instance $333 m90 *1 39.17,100.105
X$333 5 11 M2_M1_CDNS_40661956134249
* cell instance $334 m90 *1 51.02,100.105
X$334 5 9 M2_M1_CDNS_40661956134249
* cell instance $335 r0 *1 13.79,104.985
X$335 5 14 M2_M1_CDNS_40661956134249
* cell instance $336 r0 *1 25.64,104.985
X$336 5 13 M2_M1_CDNS_40661956134249
* cell instance $337 m90 *1 39.17,104.985
X$337 5 11 M2_M1_CDNS_40661956134249
* cell instance $338 m90 *1 51.02,104.985
X$338 5 9 M2_M1_CDNS_40661956134249
* cell instance $339 r0 *1 13.79,107.425
X$339 5 14 M2_M1_CDNS_40661956134249
* cell instance $340 r0 *1 25.64,107.425
X$340 5 13 M2_M1_CDNS_40661956134249
* cell instance $341 m90 *1 39.17,107.425
X$341 5 11 M2_M1_CDNS_40661956134249
* cell instance $342 m90 *1 51.02,107.425
X$342 5 9 M2_M1_CDNS_40661956134249
* cell instance $343 r0 *1 13.79,109.865
X$343 5 14 M2_M1_CDNS_40661956134249
* cell instance $344 r0 *1 25.64,109.865
X$344 5 13 M2_M1_CDNS_40661956134249
* cell instance $345 m90 *1 39.17,109.865
X$345 5 11 M2_M1_CDNS_40661956134249
* cell instance $346 m90 *1 51.02,109.865
X$346 5 9 M2_M1_CDNS_40661956134249
* cell instance $347 r0 *1 13.79,112.305
X$347 5 14 M2_M1_CDNS_40661956134249
* cell instance $348 r0 *1 25.64,112.305
X$348 5 13 M2_M1_CDNS_40661956134249
* cell instance $349 m90 *1 39.17,112.305
X$349 5 11 M2_M1_CDNS_40661956134249
* cell instance $350 m90 *1 51.02,112.305
X$350 5 9 M2_M1_CDNS_40661956134249
* cell instance $351 r0 *1 13.79,114.745
X$351 5 14 M2_M1_CDNS_40661956134249
* cell instance $352 r0 *1 25.64,114.745
X$352 5 13 M2_M1_CDNS_40661956134249
* cell instance $353 m90 *1 39.17,114.745
X$353 5 11 M2_M1_CDNS_40661956134249
* cell instance $354 m90 *1 51.02,114.745
X$354 5 9 M2_M1_CDNS_40661956134249
* cell instance $355 r0 *1 13.79,119.625
X$355 5 14 M2_M1_CDNS_40661956134249
* cell instance $356 r0 *1 25.64,119.625
X$356 5 13 M2_M1_CDNS_40661956134249
* cell instance $357 m90 *1 39.17,119.625
X$357 5 11 M2_M1_CDNS_40661956134249
* cell instance $358 m90 *1 51.02,119.625
X$358 5 9 M2_M1_CDNS_40661956134249
* cell instance $359 r0 *1 13.79,117.185
X$359 5 14 M2_M1_CDNS_40661956134249
* cell instance $360 r0 *1 25.64,117.185
X$360 5 13 M2_M1_CDNS_40661956134249
* cell instance $361 m90 *1 39.17,117.185
X$361 5 11 M2_M1_CDNS_40661956134249
* cell instance $362 m90 *1 51.02,117.185
X$362 5 9 M2_M1_CDNS_40661956134249
* cell instance $363 r0 *1 13.79,102.545
X$363 5 14 M2_M1_CDNS_40661956134249
* cell instance $364 r0 *1 25.64,102.545
X$364 5 13 M2_M1_CDNS_40661956134249
* cell instance $365 m90 *1 39.17,102.545
X$365 5 11 M2_M1_CDNS_40661956134249
* cell instance $366 m90 *1 51.02,102.545
X$366 5 9 M2_M1_CDNS_40661956134249
* cell instance $367 r0 *1 13.79,19.345
X$367 5 14 M2_M1_CDNS_40661956134249
* cell instance $368 r0 *1 25.64,19.345
X$368 5 13 M2_M1_CDNS_40661956134249
* cell instance $369 m90 *1 39.17,19.345
X$369 5 11 M2_M1_CDNS_40661956134249
* cell instance $370 m90 *1 51.02,19.345
X$370 5 9 M2_M1_CDNS_40661956134249
* cell instance $371 r0 *1 13.79,16.905
X$371 5 14 M2_M1_CDNS_40661956134249
* cell instance $372 r0 *1 25.64,16.905
X$372 5 13 M2_M1_CDNS_40661956134249
* cell instance $373 m90 *1 39.17,16.905
X$373 5 11 M2_M1_CDNS_40661956134249
* cell instance $374 m90 *1 51.02,16.905
X$374 5 9 M2_M1_CDNS_40661956134249
* cell instance $375 r0 *1 13.79,14.465
X$375 5 14 M2_M1_CDNS_40661956134249
* cell instance $376 r0 *1 25.64,14.465
X$376 5 13 M2_M1_CDNS_40661956134249
* cell instance $377 m90 *1 39.17,14.465
X$377 5 11 M2_M1_CDNS_40661956134249
* cell instance $378 m90 *1 51.02,14.465
X$378 5 9 M2_M1_CDNS_40661956134249
* cell instance $379 r0 *1 13.79,12.025
X$379 5 14 M2_M1_CDNS_40661956134249
* cell instance $380 r0 *1 25.64,12.025
X$380 5 13 M2_M1_CDNS_40661956134249
* cell instance $381 m90 *1 39.17,12.025
X$381 5 11 M2_M1_CDNS_40661956134249
* cell instance $382 m90 *1 51.02,12.025
X$382 5 9 M2_M1_CDNS_40661956134249
* cell instance $383 r0 *1 13.79,7.145
X$383 5 14 M2_M1_CDNS_40661956134249
* cell instance $384 r0 *1 25.64,7.145
X$384 5 13 M2_M1_CDNS_40661956134249
* cell instance $385 m90 *1 39.17,7.145
X$385 5 11 M2_M1_CDNS_40661956134249
* cell instance $386 m90 *1 51.02,7.145
X$386 5 9 M2_M1_CDNS_40661956134249
* cell instance $387 r0 *1 13.79,58.465
X$387 5 14 M2_M1_CDNS_40661956134249
* cell instance $388 r0 *1 25.64,58.465
X$388 5 13 M2_M1_CDNS_40661956134249
* cell instance $389 m90 *1 39.17,58.465
X$389 5 11 M2_M1_CDNS_40661956134249
* cell instance $390 m90 *1 51.02,58.465
X$390 5 9 M2_M1_CDNS_40661956134249
* cell instance $391 r0 *1 13.79,78.065
X$391 5 14 M2_M1_CDNS_40661956134249
* cell instance $392 r0 *1 25.64,78.065
X$392 5 13 M2_M1_CDNS_40661956134249
* cell instance $393 m90 *1 39.17,78.065
X$393 5 11 M2_M1_CDNS_40661956134249
* cell instance $394 m90 *1 51.02,78.065
X$394 5 9 M2_M1_CDNS_40661956134249
* cell instance $395 r0 *1 13.79,56.025
X$395 5 14 M2_M1_CDNS_40661956134249
* cell instance $396 r0 *1 25.64,56.025
X$396 5 13 M2_M1_CDNS_40661956134249
* cell instance $397 m90 *1 39.17,56.025
X$397 5 11 M2_M1_CDNS_40661956134249
* cell instance $398 m90 *1 51.02,56.025
X$398 5 9 M2_M1_CDNS_40661956134249
* cell instance $399 r0 *1 13.79,24.225
X$399 5 14 M2_M1_CDNS_40661956134249
* cell instance $400 r0 *1 25.64,24.225
X$400 5 13 M2_M1_CDNS_40661956134249
* cell instance $401 m90 *1 39.17,24.225
X$401 5 11 M2_M1_CDNS_40661956134249
* cell instance $402 m90 *1 51.02,24.225
X$402 5 9 M2_M1_CDNS_40661956134249
* cell instance $403 r0 *1 13.79,53.585
X$403 5 14 M2_M1_CDNS_40661956134249
* cell instance $404 r0 *1 25.64,53.585
X$404 5 13 M2_M1_CDNS_40661956134249
* cell instance $405 m90 *1 39.17,53.585
X$405 5 11 M2_M1_CDNS_40661956134249
* cell instance $406 m90 *1 51.02,53.585
X$406 5 9 M2_M1_CDNS_40661956134249
* cell instance $407 r0 *1 13.79,26.665
X$407 5 14 M2_M1_CDNS_40661956134249
* cell instance $408 r0 *1 25.64,26.665
X$408 5 13 M2_M1_CDNS_40661956134249
* cell instance $409 m90 *1 39.17,26.665
X$409 5 11 M2_M1_CDNS_40661956134249
* cell instance $410 m90 *1 51.02,26.665
X$410 5 9 M2_M1_CDNS_40661956134249
* cell instance $411 r0 *1 13.79,21.785
X$411 5 14 M2_M1_CDNS_40661956134249
* cell instance $412 r0 *1 25.64,21.785
X$412 5 13 M2_M1_CDNS_40661956134249
* cell instance $413 m90 *1 39.17,21.785
X$413 5 11 M2_M1_CDNS_40661956134249
* cell instance $414 m90 *1 51.02,21.785
X$414 5 9 M2_M1_CDNS_40661956134249
* cell instance $415 r0 *1 13.79,48.705
X$415 5 14 M2_M1_CDNS_40661956134249
* cell instance $416 r0 *1 25.64,48.705
X$416 5 13 M2_M1_CDNS_40661956134249
* cell instance $417 m90 *1 39.17,48.705
X$417 5 11 M2_M1_CDNS_40661956134249
* cell instance $418 m90 *1 51.02,48.705
X$418 5 9 M2_M1_CDNS_40661956134249
* cell instance $419 r0 *1 13.79,9.585
X$419 5 14 M2_M1_CDNS_40661956134249
* cell instance $420 r0 *1 25.64,9.585
X$420 5 13 M2_M1_CDNS_40661956134249
* cell instance $421 m90 *1 39.17,9.585
X$421 5 11 M2_M1_CDNS_40661956134249
* cell instance $422 m90 *1 51.02,9.585
X$422 5 9 M2_M1_CDNS_40661956134249
* cell instance $423 r0 *1 13.79,51.145
X$423 5 14 M2_M1_CDNS_40661956134249
* cell instance $424 r0 *1 25.64,51.145
X$424 5 13 M2_M1_CDNS_40661956134249
* cell instance $425 m90 *1 39.17,51.145
X$425 5 11 M2_M1_CDNS_40661956134249
* cell instance $426 m90 *1 51.02,51.145
X$426 5 9 M2_M1_CDNS_40661956134249
* cell instance $427 r0 *1 13.79,122.635
X$427 5 14 M2_M1_CDNS_40661956134247
* cell instance $428 r0 *1 25.64,122.635
X$428 5 13 M2_M1_CDNS_40661956134247
* cell instance $429 m90 *1 39.17,122.635
X$429 5 11 M2_M1_CDNS_40661956134247
* cell instance $430 m90 *1 51.02,122.635
X$430 5 9 M2_M1_CDNS_40661956134247
* cell instance $431 r0 *1 13.79,4.135
X$431 5 14 M2_M1_CDNS_40661956134247
* cell instance $432 r0 *1 25.64,4.135
X$432 5 13 M2_M1_CDNS_40661956134247
* cell instance $433 m90 *1 39.17,4.135
X$433 5 11 M2_M1_CDNS_40661956134247
* cell instance $434 m90 *1 51.02,4.135
X$434 5 9 M2_M1_CDNS_40661956134247
* cell instance $435 r0 *1 13.79,34.025
X$435 5 14 M2_M1_CDNS_40661956134255
* cell instance $436 r0 *1 25.64,34.025
X$436 5 13 M2_M1_CDNS_40661956134255
* cell instance $437 m90 *1 39.17,34.025
X$437 5 11 M2_M1_CDNS_40661956134255
* cell instance $438 m90 *1 51.02,34.025
X$438 5 9 M2_M1_CDNS_40661956134255
* cell instance $439 r0 *1 3.885,63.385
X$439 5 6 M2_M1_CDNS_40661956134268
.ENDS nmos_clamp_20_50_4_DVSS

* cell M2_M1_CDNS_40661956134233
* pin
* pin
.SUBCKT M2_M1_CDNS_40661956134233 1 2
.ENDS M2_M1_CDNS_40661956134233

* cell M2_M1_CDNS_40661956134238
* pin
* pin
.SUBCKT M2_M1_CDNS_40661956134238 1 2
.ENDS M2_M1_CDNS_40661956134238

* cell M1_PSUB_CDNS_40661956134243
* pin
* pin
.SUBCKT M1_PSUB_CDNS_40661956134243 1 2
.ENDS M1_PSUB_CDNS_40661956134243

* cell M1_PSUB_CDNS_40661956134244
* pin
* pin
.SUBCKT M1_PSUB_CDNS_40661956134244 1 2
.ENDS M1_PSUB_CDNS_40661956134244

* cell M2_M1_CDNS_40661956134242
* pin
* pin
.SUBCKT M2_M1_CDNS_40661956134242 1 2
.ENDS M2_M1_CDNS_40661956134242

* cell M1_PSUB_CDNS_4066195613410
* pin
* pin
.SUBCKT M1_PSUB_CDNS_4066195613410 1 2
.ENDS M1_PSUB_CDNS_4066195613410

* cell M1_PSUB_CDNS_4066195613413
* pin
* pin
.SUBCKT M1_PSUB_CDNS_4066195613413 1 2
.ENDS M1_PSUB_CDNS_4066195613413

* cell M1_PSUB_CDNS_4066195613412
* pin
* pin
.SUBCKT M1_PSUB_CDNS_4066195613412 1 2
.ENDS M1_PSUB_CDNS_4066195613412

* cell M1_PSUB_CDNS_4066195613417
* pin
* pin
.SUBCKT M1_PSUB_CDNS_4066195613417 1 2
.ENDS M1_PSUB_CDNS_4066195613417

* cell M1_PSUB_CDNS_4066195613416
* pin
* pin
.SUBCKT M1_PSUB_CDNS_4066195613416 1 2
.ENDS M1_PSUB_CDNS_4066195613416

* cell M1_PSUB_CDNS_4066195613415
* pin
* pin
.SUBCKT M1_PSUB_CDNS_4066195613415 1 2
.ENDS M1_PSUB_CDNS_4066195613415

* cell M1_PSUB_CDNS_4066195613414
* pin
* pin
.SUBCKT M1_PSUB_CDNS_4066195613414 1 2
.ENDS M1_PSUB_CDNS_4066195613414

* cell power_via_cor_5
* pin
* pin
* pin
* pin
* pin
* pin
* pin
* pin
* pin
* pin
* pin
* pin
* pin
* pin
* pin
* pin
* pin
* pin
* pin
* pin
* pin
* pin
* pin
* pin
* pin
* pin
* pin
* pin
* pin
* pin
* pin
* pin
* pin
* pin
* pin
* pin
* pin
* pin
* pin
* pin
* pin
* pin
* pin
* pin
* pin
* pin
* pin
* pin
* pin
* pin
* pin
* pin
* pin
* pin
* pin
* pin
* pin
* pin
* pin
* pin
* pin
* pin
* pin
* pin
* pin
* pin
* pin
* pin
* pin
* pin
* pin
* pin
* pin
* pin
* pin
* pin
* pin
* pin
* pin
* pin
* pin
* pin
* pin
* pin
* pin
* pin
* pin
* pin
* pin
* pin
* pin
* pin
* pin
* pin
* pin
* pin
* pin
* pin
* pin
* pin
* pin
* pin
* pin
* pin
* pin
* pin
* pin
* pin
* pin
* pin
* pin
* pin
* pin
* pin
* pin
* pin
* pin
* pin
* pin
* pin
* pin
* pin
* pin
* pin
* pin
* pin
* pin
* pin
* pin
* pin
* pin
* pin
* pin
* pin
* pin
* pin
* pin
* pin
* pin
* pin
* pin
* pin
* pin
* pin
* pin
* pin
* pin
* pin
* pin
* pin
* pin
* pin
* pin
* pin
* pin
* pin
* pin
* pin
* pin
* pin
* pin
* pin
* pin
* pin
* pin
* pin
* pin
* pin
* pin
* pin
* pin
* pin
* pin
* pin
* pin
* pin
* pin
* pin
* pin
* pin
* pin
* pin
* pin
* pin
* pin
* pin
* pin
* pin
* pin
* pin
* pin
* pin
* pin
* pin
* pin
* pin
* pin
* pin
* pin
* pin
* pin
* pin
* pin
* pin
* pin
* pin
* pin
* pin
* pin
* pin
* pin
* pin
* pin
* pin
* pin
* pin
* pin
* pin
* pin
* pin
* pin
* pin
* pin
* pin
* pin
* pin
* pin
* pin
* pin
* pin
* pin
* pin
* pin
* pin
* pin
* pin
* pin
* pin
* pin
* pin
* pin
* pin
* pin
* pin
* pin
* pin
* pin
* pin
* pin
* pin
* pin
* pin
* pin
* pin
* pin
* pin
* pin
* pin
* pin
* pin
* pin
* pin
* pin
* pin
* pin
* pin
* pin
* pin
* pin
* pin
* pin
* pin
* pin
* pin
* pin
* pin
* pin
* pin
* pin
* pin
* pin
* pin
* pin
* pin
* pin
* pin
* pin
* pin
* pin
* pin
* pin
* pin
.SUBCKT power_via_cor_5 1 2 3 4 5 6 7 8 9 10 11 12 13 14 15 16 17 18 19 20 21
+ 22 23 24 25 26 27 28 29 30 31 32 33 34 35 36 37 38 39 40 41 42 43 44 45 46 47
+ 48 49 50 51 52 53 54 55 56 57 58 59 60 61 62 63 64 65 66 67 68 69 70 71 72 73
+ 74 75 76 77 78 79 80 81 82 83 84 85 86 87 88 89 90 91 92 93 94 95 96 97 98 99
+ 100 101 102 103 104 105 106 107 108 109 110 111 112 113 114 115 116 117 118
+ 119 120 121 122 123 124 125 126 127 128 129 130 131 132 133 134 135 136 137
+ 138 139 140 141 142 143 144 145 146 147 148 149 150 151 152 153 154 155 156
+ 157 158 159 160 161 162 163 164 165 166 167 168 169 170 171 172 173 174 175
+ 176 177 178 179 180 181 182 183 184 185 186 187 188 189 190 191 192 193 194
+ 195 196 197 198 199 200 201 202 203 204 205 206 207 208 209 210 211 212 213
+ 214 215 216 217 218 219 220 221 222 223 224 225 226 227 228 229 230 231 232
+ 233 234 235 236 237 238 239 240 241 242 243 244 245 246 247 248 249 250 251
+ 252 253 254 255 256 257 258 259 260 261 262 263 264 265 266 267 268 269 270
+ 271 272 273 274 275 276 277 278 279 280 281 282 283 284 285 286 287 288 289
+ 290 293 294
* cell instance $1 r0 *1 12.775,174.94
X$1 3 1 M3_M2_CDNS_40661956134157
* cell instance $2 r0 *1 5.915,158.77
X$2 4 2 M3_M2_CDNS_40661956134157
* cell instance $3 r0 *1 20.835,168.575
X$3 6 5 M3_M2_CDNS_40661956134158
* cell instance $4 r0 *1 19.595,169.21
X$4 9 7 M3_M2_CDNS_40661956134159
* cell instance $5 r0 *1 20.215,168.855
X$5 10 8 M3_M2_CDNS_40661956134159
* cell instance $6 r0 *1 18.975,169.42
X$6 12 11 M3_M2_CDNS_40661956134160
* cell instance $7 r0 *1 18.355,169.625
X$7 14 13 M3_M2_CDNS_40661956134161
* cell instance $8 r0 *1 17.735,169.98
X$8 16 15 M3_M2_CDNS_40661956134162
* cell instance $9 r0 *1 6.535,158.15
X$9 31 17 M3_M2_CDNS_40661956134163
* cell instance $10 r0 *1 9.635,155.05
X$10 32 18 M3_M2_CDNS_40661956134163
* cell instance $11 r0 *1 10.255,154.43
X$11 33 19 M3_M2_CDNS_40661956134163
* cell instance $12 r0 *1 13.395,174.32
X$12 34 20 M3_M2_CDNS_40661956134163
* cell instance $13 r0 *1 15.255,172.46
X$13 35 21 M3_M2_CDNS_40661956134163
* cell instance $14 r0 *1 15.875,171.84
X$14 36 22 M3_M2_CDNS_40661956134163
* cell instance $15 r0 *1 17.115,170.6
X$15 37 23 M3_M2_CDNS_40661956134163
* cell instance $16 r0 *1 7.155,157.53
X$16 38 24 M3_M2_CDNS_40661956134163
* cell instance $17 r0 *1 8.395,156.29
X$17 39 25 M3_M2_CDNS_40661956134163
* cell instance $18 r0 *1 9.015,155.67
X$18 40 26 M3_M2_CDNS_40661956134163
* cell instance $19 r0 *1 7.775,156.91
X$19 41 27 M3_M2_CDNS_40661956134163
* cell instance $20 r0 *1 14.015,173.7
X$20 42 28 M3_M2_CDNS_40661956134163
* cell instance $21 r0 *1 14.635,173.08
X$21 43 29 M3_M2_CDNS_40661956134163
* cell instance $22 r0 *1 16.495,171.22
X$22 44 30 M3_M2_CDNS_40661956134163
* cell instance $23 r0 *1 5.66,221.795
X$23 47 45 M3_M2_CDNS_40661956134164
* cell instance $24 r0 *1 5.775,142.055
X$24 48 46 M3_M2_CDNS_40661956134164
* cell instance $25 r0 *1 7.015,140.815
X$25 58 49 M3_M2_CDNS_40661956134165
* cell instance $26 r0 *1 6.395,141.435
X$26 59 50 M3_M2_CDNS_40661956134165
* cell instance $27 r0 *1 6.9,220.555
X$27 60 51 M3_M2_CDNS_40661956134165
* cell instance $28 r0 *1 9.38,218.075
X$28 61 52 M3_M2_CDNS_40661956134165
* cell instance $29 r0 *1 10,217.455
X$29 62 53 M3_M2_CDNS_40661956134165
* cell instance $30 r0 *1 8.76,218.695
X$30 63 54 M3_M2_CDNS_40661956134165
* cell instance $31 r0 *1 8.14,219.315
X$31 64 55 M3_M2_CDNS_40661956134165
* cell instance $32 r0 *1 7.52,219.935
X$32 65 56 M3_M2_CDNS_40661956134165
* cell instance $33 r0 *1 6.28,221.175
X$33 66 57 M3_M2_CDNS_40661956134165
* cell instance $34 r0 *1 57.875,71.48
X$34 84 67 M3_M2_CDNS_40661956134156
* cell instance $35 r0 *1 48.235,39.48
X$35 85 68 M3_M2_CDNS_40661956134156
* cell instance $36 r0 *1 48.235,23.48
X$36 86 69 M3_M2_CDNS_40661956134156
* cell instance $37 r0 *1 48.235,7.48
X$37 87 70 M3_M2_CDNS_40661956134156
* cell instance $38 r0 *1 57.875,87.48
X$38 88 71 M3_M2_CDNS_40661956134156
* cell instance $39 r0 *1 48.235,167.48
X$39 89 72 M3_M2_CDNS_40661956134156
* cell instance $40 r0 *1 57.875,151.48
X$40 90 73 M3_M2_CDNS_40661956134156
* cell instance $41 r0 *1 57.875,103.48
X$41 91 74 M3_M2_CDNS_40661956134156
* cell instance $42 r0 *1 26.655,87.48
X$42 92 75 M3_M2_CDNS_40661956134156
* cell instance $43 r0 *1 57.875,119.48
X$43 93 76 M3_M2_CDNS_40661956134156
* cell instance $44 r0 *1 26.655,151.48
X$44 94 77 M3_M2_CDNS_40661956134156
* cell instance $45 r0 *1 17.015,39.48
X$45 95 78 M3_M2_CDNS_40661956134156
* cell instance $46 r0 *1 17.015,23.48
X$46 96 79 M3_M2_CDNS_40661956134156
* cell instance $47 r0 *1 17.015,7.48
X$47 97 80 M3_M2_CDNS_40661956134156
* cell instance $48 r0 *1 26.655,71.48
X$48 98 81 M3_M2_CDNS_40661956134156
* cell instance $49 r0 *1 26.655,119.48
X$49 99 82 M3_M2_CDNS_40661956134156
* cell instance $50 r0 *1 26.655,103.48
X$50 100 83 M3_M2_CDNS_40661956134156
* cell instance $51 r0 *1 66.88,23.48
X$51 118 101 M3_M2_CDNS_40661956134155
* cell instance $52 r0 *1 66.88,7.48
X$52 119 102 M3_M2_CDNS_40661956134155
* cell instance $53 r0 *1 40.43,151.48
X$53 120 103 M3_M2_CDNS_40661956134155
* cell instance $54 r0 *1 40.43,71.48
X$54 121 104 M3_M2_CDNS_40661956134155
* cell instance $55 r0 *1 66.88,39.48
X$55 122 105 M3_M2_CDNS_40661956134155
* cell instance $56 r0 *1 40.43,87.48
X$56 123 106 M3_M2_CDNS_40661956134155
* cell instance $57 r0 *1 40.43,103.48
X$57 124 107 M3_M2_CDNS_40661956134155
* cell instance $58 r0 *1 40.43,119.48
X$58 125 108 M3_M2_CDNS_40661956134155
* cell instance $59 r0 *1 66.88,167.48
X$59 126 109 M3_M2_CDNS_40661956134155
* cell instance $60 r0 *1 34.46,167.48
X$60 127 110 M3_M2_CDNS_40661956134155
* cell instance $61 r0 *1 34.46,23.48
X$61 128 111 M3_M2_CDNS_40661956134155
* cell instance $62 r0 *1 34.46,7.48
X$62 129 112 M3_M2_CDNS_40661956134155
* cell instance $63 r0 *1 8.01,119.48
X$63 130 113 M3_M2_CDNS_40661956134155
* cell instance $64 r0 *1 8.01,103.48
X$64 131 114 M3_M2_CDNS_40661956134155
* cell instance $65 r0 *1 8.01,87.48
X$65 132 115 M3_M2_CDNS_40661956134155
* cell instance $66 r0 *1 8.01,71.48
X$66 133 116 M3_M2_CDNS_40661956134155
* cell instance $67 r0 *1 34.46,39.48
X$67 134 117 M3_M2_CDNS_40661956134155
* cell instance $68 r0 *1 22.49,215.95
X$68 138 135 M3_M2_CDNS_40661956134120
* cell instance $69 r0 *1 22.49,227.445
X$69 139 136 M3_M2_CDNS_40661956134120
* cell instance $70 r0 *1 22.49,204.775
X$70 140 137 M3_M2_CDNS_40661956134120
* cell instance $71 r0 *1 9.495,139.455
X$71 143 141 M3_M2_CDNS_40661956134121
* cell instance $72 r0 *1 10.115,139.445
X$72 144 142 M3_M2_CDNS_40661956134121
* cell instance $73 r0 *1 30.55,219.385
X$73 193 145 M3_M2_CDNS_40661956134122
* cell instance $74 r0 *1 26.21,223.725
X$74 194 146 M3_M2_CDNS_40661956134122
* cell instance $75 r0 *1 25.59,212.85
X$75 195 147 M3_M2_CDNS_40661956134122
* cell instance $76 r0 *1 24.35,214.09
X$76 196 148 M3_M2_CDNS_40661956134122
* cell instance $77 r0 *1 34.59,226.7
X$77 197 149 M3_M2_CDNS_40661956134122
* cell instance $78 r0 *1 33.97,227.32
X$78 198 150 M3_M2_CDNS_40661956134122
* cell instance $79 r0 *1 33.35,227.94
X$79 199 151 M3_M2_CDNS_40661956134122
* cell instance $80 r0 *1 23.11,215.33
X$80 200 152 M3_M2_CDNS_40661956134122
* cell instance $81 r0 *1 24.97,224.965
X$81 201 153 M3_M2_CDNS_40661956134122
* cell instance $82 r0 *1 26.83,223.105
X$82 202 154 M3_M2_CDNS_40661956134122
* cell instance $83 r0 *1 32.11,229.18
X$83 203 155 M3_M2_CDNS_40661956134122
* cell instance $84 r0 *1 25.59,224.345
X$84 204 156 M3_M2_CDNS_40661956134122
* cell instance $85 r0 *1 28.69,198.575
X$85 205 157 M3_M2_CDNS_40661956134122
* cell instance $86 r0 *1 29.31,197.955
X$86 206 158 M3_M2_CDNS_40661956134122
* cell instance $87 r0 *1 29.93,197.335
X$87 207 159 M3_M2_CDNS_40661956134122
* cell instance $88 r0 *1 30.55,196.715
X$88 208 160 M3_M2_CDNS_40661956134122
* cell instance $89 r0 *1 23.11,204.155
X$89 209 161 M3_M2_CDNS_40661956134122
* cell instance $90 r0 *1 23.73,203.535
X$90 210 162 M3_M2_CDNS_40661956134122
* cell instance $91 r0 *1 24.35,202.915
X$91 211 163 M3_M2_CDNS_40661956134122
* cell instance $92 r0 *1 27.45,222.485
X$92 212 164 M3_M2_CDNS_40661956134122
* cell instance $93 r0 *1 25.59,201.675
X$93 213 165 M3_M2_CDNS_40661956134122
* cell instance $94 r0 *1 26.21,201.055
X$94 214 166 M3_M2_CDNS_40661956134122
* cell instance $95 r0 *1 26.83,200.435
X$95 215 167 M3_M2_CDNS_40661956134122
* cell instance $96 r0 *1 27.45,199.815
X$96 216 168 M3_M2_CDNS_40661956134122
* cell instance $97 r0 *1 28.07,199.195
X$97 217 169 M3_M2_CDNS_40661956134122
* cell instance $98 r0 *1 28.07,210.37
X$98 218 170 M3_M2_CDNS_40661956134122
* cell instance $99 r0 *1 7.635,140.44
X$99 219 171 M3_M2_CDNS_40661956134122
* cell instance $100 r0 *1 32.73,228.56
X$100 220 172 M3_M2_CDNS_40661956134122
* cell instance $101 r0 *1 24.97,202.295
X$101 221 173 M3_M2_CDNS_40661956134122
* cell instance $102 r0 *1 29.93,208.51
X$102 222 174 M3_M2_CDNS_40661956134122
* cell instance $103 r0 *1 30.55,207.89
X$103 223 175 M3_M2_CDNS_40661956134122
* cell instance $104 r0 *1 26.83,211.61
X$104 224 176 M3_M2_CDNS_40661956134122
* cell instance $105 r0 *1 36.45,224.84
X$105 225 177 M3_M2_CDNS_40661956134122
* cell instance $106 r0 *1 27.45,210.99
X$106 226 178 M3_M2_CDNS_40661956134122
* cell instance $107 r0 *1 35.21,226.08
X$107 227 179 M3_M2_CDNS_40661956134122
* cell instance $108 r0 *1 28.69,209.75
X$108 228 180 M3_M2_CDNS_40661956134122
* cell instance $109 r0 *1 29.93,220.005
X$109 229 181 M3_M2_CDNS_40661956134122
* cell instance $110 r0 *1 29.31,220.625
X$110 230 182 M3_M2_CDNS_40661956134122
* cell instance $111 r0 *1 23.73,226.205
X$111 231 183 M3_M2_CDNS_40661956134122
* cell instance $112 r0 *1 35.83,225.46
X$112 232 184 M3_M2_CDNS_40661956134122
* cell instance $113 r0 *1 24.35,225.585
X$113 233 185 M3_M2_CDNS_40661956134122
* cell instance $114 r0 *1 26.21,212.23
X$114 234 186 M3_M2_CDNS_40661956134122
* cell instance $115 r0 *1 29.31,209.13
X$115 235 187 M3_M2_CDNS_40661956134122
* cell instance $116 r0 *1 28.07,221.865
X$116 236 188 M3_M2_CDNS_40661956134122
* cell instance $117 r0 *1 23.73,214.71
X$117 237 189 M3_M2_CDNS_40661956134122
* cell instance $118 r0 *1 23.11,226.825
X$118 238 190 M3_M2_CDNS_40661956134122
* cell instance $119 r0 *1 24.97,213.47
X$119 239 191 M3_M2_CDNS_40661956134122
* cell instance $120 r0 *1 28.69,221.245
X$120 240 192 M3_M2_CDNS_40661956134122
* cell instance $121 r0 *1 8.255,140.18
X$121 242 241 M3_M2_CDNS_40661956134123
* cell instance $122 r0 *1 8.875,139.715
X$122 244 243 M3_M2_CDNS_40661956134124
* cell instance $123 r0 *1 66.88,131.48
X$123 245 268 M3_M2_CDNS_40661956134118
* cell instance $124 r0 *1 66.88,219.48
X$124 246 269 M3_M2_CDNS_40661956134118
* cell instance $125 r0 *1 34.46,131.48
X$125 247 270 M3_M2_CDNS_40661956134118
* cell instance $126 r0 *1 40.43,51.48
X$126 248 271 M3_M2_CDNS_40661956134118
* cell instance $127 r0 *1 40.43,195.48
X$127 249 272 M3_M2_CDNS_40661956134118
* cell instance $128 r0 *1 40.43,203.48
X$128 250 273 M3_M2_CDNS_40661956134118
* cell instance $129 r0 *1 40.43,139.48
X$129 251 274 M3_M2_CDNS_40661956134118
* cell instance $130 r0 *1 40.43,211.48
X$130 252 275 M3_M2_CDNS_40661956134118
* cell instance $131 r0 *1 66.88,59.48
X$131 253 276 M3_M2_CDNS_40661956134118
* cell instance $132 r0 *1 34.46,59.48
X$132 254 277 M3_M2_CDNS_40661956134118
* cell instance $133 r0 *1 8.01,51.48
X$133 255 278 M3_M2_CDNS_40661956134118
* cell instance $134 r0 *1 57.875,211.48
X$134 256 279 M3_M2_CDNS_40661956134119
* cell instance $135 r0 *1 57.875,203.48
X$135 257 280 M3_M2_CDNS_40661956134119
* cell instance $136 r0 *1 57.875,195.48
X$136 258 281 M3_M2_CDNS_40661956134119
* cell instance $137 r0 *1 57.875,139.48
X$137 259 282 M3_M2_CDNS_40661956134119
* cell instance $138 r0 *1 48.235,219.48
X$138 260 283 M3_M2_CDNS_40661956134119
* cell instance $139 r0 *1 57.875,51.48
X$139 261 284 M3_M2_CDNS_40661956134119
* cell instance $140 r0 *1 26.655,51.48
X$140 262 285 M3_M2_CDNS_40661956134119
* cell instance $141 r0 *1 48.235,131.48
X$141 263 286 M3_M2_CDNS_40661956134119
* cell instance $142 r0 *1 48.235,59.48
X$142 264 287 M3_M2_CDNS_40661956134119
* cell instance $143 r0 *1 17.015,131.48
X$143 265 288 M3_M2_CDNS_40661956134119
* cell instance $144 r0 *1 26.655,139.48
X$144 266 289 M3_M2_CDNS_40661956134119
* cell instance $145 r0 *1 17.015,59.48
X$145 267 290 M3_M2_CDNS_40661956134119
* cell instance $146 r0 *1 73.975,179.48
X$146 293 291 M3_M2_CDNS_40661956134114
* cell instance $147 r0 *1 73.975,179.48
X$147 293 291 M2_M1_CDNS_40661956134115
* cell instance $148 r0 *1 73.975,251.48
X$148 294 292 M3_M2_CDNS_40661956134114
* cell instance $149 r0 *1 73.975,251.48
X$149 294 292 M2_M1_CDNS_40661956134115
.ENDS power_via_cor_5

* cell power_via_cor_3
* pin
* pin
* pin
* pin
* pin
* pin
* pin
* pin
* pin
* pin
* pin
* pin
* pin
* pin
* pin
* pin
* pin
* pin
* pin
* pin
* pin
* pin
* pin
* pin
* pin
* pin
* pin
* pin
* pin
* pin
* pin
* pin
* pin
* pin
* pin
* pin
* pin
* pin
* pin
* pin
* pin
* pin
* pin
* pin
* pin
* pin
* pin
* pin
* pin
* pin
* pin
* pin
* pin
* pin
* pin
* pin
* pin
* pin
* pin
* pin
* pin
* pin
* pin
* pin
* pin
* pin
* pin
* pin
* pin
* pin
* pin
* pin
* pin
* pin
* pin
* pin
* pin
* pin
* pin
* pin
* pin
* pin
* pin
* pin
* pin
* pin
* pin
* pin
* pin
* pin
* pin
* pin
* pin
* pin
* pin
* pin
.SUBCKT power_via_cor_3 1 2 3 4 5 6 7 8 9 10 11 12 13 14 15 16 17 18 19 20 21
+ 22 23 24 25 26 27 28 29 30 31 32 33 34 35 36 37 38 39 40 41 42 43 44 45 46 47
+ 48 49 50 51 52 53 54 55 56 57 58 59 60 61 62 63 64 65 66 67 68 69 70 71 72 73
+ 74 75 76 77 78 79 80 81 82 83 84 85 86 87 88 89 90 91 92 93 94 97 98
* cell instance $1 r0 *1 57.875,243.49
X$1 4 1 M3_M2_CDNS_40661956134119
* cell instance $2 r0 *1 66.88,251.45
X$2 5 2 M3_M2_CDNS_40661956134118
* cell instance $3 r0 *1 45.75,260.755
X$3 6 3 M3_M2_CDNS_40661956134112
* cell instance $4 r0 *1 40.25,254.95
X$4 8 7 M3_M2_CDNS_40661956134113
* cell instance $5 r0 *1 32.96,274.22
X$5 10 9 M3_M2_CDNS_40661956134116
* cell instance $6 r0 *1 40.25,273.035
X$6 12 11 M3_M2_CDNS_40661956134117
* cell instance $7 r0 *1 12.775,191.855
X$7 16 13 M3_M2_CDNS_40661956134120
* cell instance $8 r0 *1 22.49,193.45
X$8 17 14 M3_M2_CDNS_40661956134120
* cell instance $9 r0 *1 5.66,210.28
X$9 18 15 M3_M2_CDNS_40661956134120
* cell instance $10 r0 *1 29.31,187.57
X$10 22 19 M3_M2_CDNS_40661956134121
* cell instance $11 r0 *1 29.93,187.465
X$11 23 20 M3_M2_CDNS_40661956134121
* cell instance $12 r0 *1 30.55,187.46
X$12 24 21 M3_M2_CDNS_40661956134121
* cell instance $13 r0 *1 27.45,188.49
X$13 53 25 M3_M2_CDNS_40661956134122
* cell instance $14 r0 *1 17.735,186.895
X$14 54 26 M3_M2_CDNS_40661956134122
* cell instance $15 r0 *1 18.975,185.655
X$15 55 27 M3_M2_CDNS_40661956134122
* cell instance $16 r0 *1 19.595,185.035
X$16 56 28 M3_M2_CDNS_40661956134122
* cell instance $17 r0 *1 18.355,186.275
X$17 57 29 M3_M2_CDNS_40661956134122
* cell instance $18 r0 *1 10,205.94
X$18 58 30 M3_M2_CDNS_40661956134122
* cell instance $19 r0 *1 9.38,206.56
X$19 59 31 M3_M2_CDNS_40661956134122
* cell instance $20 r0 *1 8.76,207.18
X$20 60 32 M3_M2_CDNS_40661956134122
* cell instance $21 r0 *1 8.14,207.8
X$21 61 33 M3_M2_CDNS_40661956134122
* cell instance $22 r0 *1 7.52,208.42
X$22 62 34 M3_M2_CDNS_40661956134122
* cell instance $23 r0 *1 6.9,209.04
X$23 63 35 M3_M2_CDNS_40661956134122
* cell instance $24 r0 *1 6.28,209.66
X$24 64 36 M3_M2_CDNS_40661956134122
* cell instance $25 r0 *1 26.21,189.73
X$25 65 37 M3_M2_CDNS_40661956134122
* cell instance $26 r0 *1 26.83,189.11
X$26 66 38 M3_M2_CDNS_40661956134122
* cell instance $27 r0 *1 15.255,189.375
X$27 67 39 M3_M2_CDNS_40661956134122
* cell instance $28 r0 *1 15.875,188.755
X$28 68 40 M3_M2_CDNS_40661956134122
* cell instance $29 r0 *1 16.495,188.135
X$29 69 41 M3_M2_CDNS_40661956134122
* cell instance $30 r0 *1 23.11,192.83
X$30 70 42 M3_M2_CDNS_40661956134122
* cell instance $31 r0 *1 17.115,187.515
X$31 71 43 M3_M2_CDNS_40661956134122
* cell instance $32 r0 *1 20.215,184.415
X$32 72 44 M3_M2_CDNS_40661956134122
* cell instance $33 r0 *1 20.835,183.795
X$33 73 45 M3_M2_CDNS_40661956134122
* cell instance $34 r0 *1 23.73,192.21
X$34 74 46 M3_M2_CDNS_40661956134122
* cell instance $35 r0 *1 24.35,191.59
X$35 75 47 M3_M2_CDNS_40661956134122
* cell instance $36 r0 *1 24.97,190.97
X$36 76 48 M3_M2_CDNS_40661956134122
* cell instance $37 r0 *1 25.59,190.35
X$37 77 49 M3_M2_CDNS_40661956134122
* cell instance $38 r0 *1 14.015,190.615
X$38 78 50 M3_M2_CDNS_40661956134122
* cell instance $39 r0 *1 13.395,191.235
X$39 79 51 M3_M2_CDNS_40661956134122
* cell instance $40 r0 *1 14.635,189.995
X$40 80 52 M3_M2_CDNS_40661956134122
* cell instance $41 r0 *1 28.07,188.15
X$41 82 81 M3_M2_CDNS_40661956134123
* cell instance $42 r0 *1 28.69,187.815
X$42 84 83 M3_M2_CDNS_40661956134124
* cell instance $43 r0 *1 66.88,179.48
X$43 85 90 M3_M2_CDNS_40661956134118
* cell instance $44 r0 *1 40.43,187.48
X$44 86 91 M3_M2_CDNS_40661956134118
* cell instance $45 r0 *1 34.46,179.48
X$45 87 92 M3_M2_CDNS_40661956134118
* cell instance $46 r0 *1 57.875,187.48
X$46 88 93 M3_M2_CDNS_40661956134119
* cell instance $47 r0 *1 48.235,179.48
X$47 89 94 M3_M2_CDNS_40661956134119
* cell instance $48 r0 *1 73.975,179.48
X$48 97 95 M2_M1_CDNS_40661956134115
* cell instance $49 r0 *1 73.975,179.48
X$49 97 95 M3_M2_CDNS_40661956134114
* cell instance $50 r0 *1 73.975,251.48
X$50 98 96 M2_M1_CDNS_40661956134115
* cell instance $51 r0 *1 73.975,251.48
X$51 98 96 M3_M2_CDNS_40661956134114
.ENDS power_via_cor_3

* cell top_routing_cor
* pin DVDD
* pin DVSS
* pin VDD
* pin VSS
.SUBCKT top_routing_cor 1 2 3 4
* net 1 DVDD
* net 2 DVSS
* net 3 VDD
* net 4 VSS
.ENDS top_routing_cor

* cell comp018green_esd_clamp_v5p0_2
* pin
* pin
* pin gf180mcu_gnd
* pin
* pin
* pin
* pin
* pin
* pin
* pin
* pin
.SUBCKT comp018green_esd_clamp_v5p0_2 1 3 10 11 12 13 14 15 16 17 18
* net 10 gf180mcu_gnd
* cell instance $1 r0 *1 20.645,130.03
X$1 1 5 2 10 nmos_6p0_CDNS_406619561347
* cell instance $2 r0 *1 33.275,130.03
X$2 20 1 6 1 6 1 6 1 7 7 7 7 7 7 nmos_6p0_CDNS_406619561346
* cell instance $3 r0 *1 25.955,130.03
X$3 20 1 7 1 7 1 7 1 5 5 5 5 5 5 nmos_6p0_CDNS_406619561346
* cell instance $4 m0 *1 -1.78,232.535
X$4 3 2 1 10 comp018green_esd_rc_v5p0
* cell instance $5 r0 *1 0.215,128.085
X$5 1 18 17 15 16 14 13 12 11 1 3 top_route_1
* cell instance $6 m0 *1 11.49,132.61
X$6 1 4 M1_PSUB_CDNS_40661956134125
* cell instance $7 m0 *1 53.32,132.61
X$7 1 4 M1_PSUB_CDNS_40661956134125
* cell instance $8 r0 *1 0,0
X$8 6 3 1 18 22 17 16 15 14 13 21 12 11 10 nmos_clamp_20_50_4
* cell instance $9 r0 *1 15.505,137.795
X$9 2 M1_POLY2_CDNS_40661956134127
* cell instance $10 r0 *1 20.71,135.54
X$10 2 M1_POLY2_CDNS_40661956134128
* cell instance $11 r0 *1 13.325,138.945
X$11 19 5 3 5 3 3 2 2 2 2 9 3 pmos_6p0_CDNS_406619561344
* cell instance $12 r0 *1 11.49,141.595
X$12 3 8 9 3 M1_NWELL_CDNS_40661956134133
* cell instance $13 r0 *1 53.32,141.595
X$13 3 8 9 3 M1_NWELL_CDNS_40661956134133
* cell instance $14 r0 *1 22.725,138.945
X$14 3 6 3 6 3 6 3 6 3 6 3 6 3 6 3 6 3 6 3 6 3 6 3 6 3 7 7 7 7 7 7 7 7 7 7 7 7
+ 7 7 7 7 7 7 7 7 7 7 7 7 3 9 pmos_6p0_CDNS_406619561342
* cell instance $15 r0 *1 18.205,138.945
X$15 19 7 3 3 7 5 5 5 9 3 pmos_6p0_CDNS_406619561343
* cell instance $16 r0 *1 32.405,145.185
X$16 3 8 9 3 M1_NWELL_CDNS_40661956134129
* cell instance $17 r0 *1 19.775,137.795
X$17 5 M1_POLY2_CDNS_40661956134130
* cell instance $18 r0 *1 29.355,136.18
X$18 5 M1_POLY2_CDNS_40661956134131
* cell instance $19 r0 *1 6.565,127.585
X$19 6 22 M2_M1_CDNS_40661956134126
* cell instance $20 r0 *1 58.245,127.585
X$20 6 21 M2_M1_CDNS_40661956134126
* cell instance $21 r0 *1 37.105,137.795
X$21 7 M1_POLY2_CDNS_40661956134132
* cell instance $22 r0 *1 36.675,136.18
X$22 7 M1_POLY2_CDNS_40661956134131
* device instance $1 r0 *1 13.675,141.445 pmos_6p0
M$1 5 2 3 3 pmos_6p0 L=0.7U W=5U AS=2.2P AD=1.3P PS=10.88U PD=5.52U
* device instance $2 r0 *1 14.895,141.445 pmos_6p0
M$2 3 2 5 3 pmos_6p0 L=0.7U W=5U AS=1.3P AD=1.3P PS=5.52U PD=5.52U
* device instance $3 r0 *1 16.115,141.445 pmos_6p0
M$3 5 2 3 3 pmos_6p0 L=0.7U W=5U AS=1.3P AD=1.3P PS=5.52U PD=5.52U
* device instance $4 r0 *1 17.335,141.445 pmos_6p0
M$4 3 2 5 3 pmos_6p0 L=0.7U W=5U AS=1.3P AD=1.3P PS=5.52U PD=5.52U
* device instance $5 r0 *1 18.555,141.445 pmos_6p0
M$5 7 5 3 3 pmos_6p0 L=0.7U W=5U AS=1.3P AD=1.3P PS=5.52U PD=5.52U
* device instance $6 r0 *1 19.775,141.445 pmos_6p0
M$6 3 5 7 3 pmos_6p0 L=0.7U W=5U AS=1.3P AD=1.3P PS=5.52U PD=5.52U
* device instance $7 r0 *1 20.995,141.445 pmos_6p0
M$7 7 5 3 3 pmos_6p0 L=0.7U W=5U AS=1.3P AD=2.2P PS=5.52U PD=10.88U
* device instance $8 r0 *1 23.075,141.445 pmos_6p0
M$8 6 7 3 3 pmos_6p0 L=0.7U W=5U AS=2.2P AD=1.3P PS=10.88U PD=5.52U
* device instance $9 r0 *1 24.295,141.445 pmos_6p0
M$9 3 7 6 3 pmos_6p0 L=0.7U W=5U AS=1.3P AD=1.3P PS=5.52U PD=5.52U
* device instance $10 r0 *1 25.515,141.445 pmos_6p0
M$10 6 7 3 3 pmos_6p0 L=0.7U W=5U AS=1.3P AD=1.3P PS=5.52U PD=5.52U
* device instance $11 r0 *1 26.735,141.445 pmos_6p0
M$11 3 7 6 3 pmos_6p0 L=0.7U W=5U AS=1.3P AD=1.3P PS=5.52U PD=5.52U
* device instance $12 r0 *1 27.955,141.445 pmos_6p0
M$12 6 7 3 3 pmos_6p0 L=0.7U W=5U AS=1.3P AD=1.3P PS=5.52U PD=5.52U
* device instance $13 r0 *1 29.175,141.445 pmos_6p0
M$13 3 7 6 3 pmos_6p0 L=0.7U W=5U AS=1.3P AD=1.3P PS=5.52U PD=5.52U
* device instance $14 r0 *1 30.395,141.445 pmos_6p0
M$14 6 7 3 3 pmos_6p0 L=0.7U W=5U AS=1.3P AD=1.3P PS=5.52U PD=5.52U
* device instance $15 r0 *1 31.615,141.445 pmos_6p0
M$15 3 7 6 3 pmos_6p0 L=0.7U W=5U AS=1.3P AD=1.3P PS=5.52U PD=5.52U
* device instance $16 r0 *1 32.835,141.445 pmos_6p0
M$16 6 7 3 3 pmos_6p0 L=0.7U W=5U AS=1.3P AD=1.3P PS=5.52U PD=5.52U
* device instance $17 r0 *1 34.055,141.445 pmos_6p0
M$17 3 7 6 3 pmos_6p0 L=0.7U W=5U AS=1.3P AD=1.3P PS=5.52U PD=5.52U
* device instance $18 r0 *1 35.275,141.445 pmos_6p0
M$18 6 7 3 3 pmos_6p0 L=0.7U W=5U AS=1.3P AD=1.3P PS=5.52U PD=5.52U
* device instance $19 r0 *1 36.495,141.445 pmos_6p0
M$19 3 7 6 3 pmos_6p0 L=0.7U W=5U AS=1.3P AD=1.3P PS=5.52U PD=5.52U
* device instance $20 r0 *1 37.715,141.445 pmos_6p0
M$20 6 7 3 3 pmos_6p0 L=0.7U W=5U AS=1.3P AD=1.3P PS=5.52U PD=5.52U
* device instance $21 r0 *1 38.935,141.445 pmos_6p0
M$21 3 7 6 3 pmos_6p0 L=0.7U W=5U AS=1.3P AD=1.3P PS=5.52U PD=5.52U
* device instance $22 r0 *1 40.155,141.445 pmos_6p0
M$22 6 7 3 3 pmos_6p0 L=0.7U W=5U AS=1.3P AD=1.3P PS=5.52U PD=5.52U
* device instance $23 r0 *1 41.375,141.445 pmos_6p0
M$23 3 7 6 3 pmos_6p0 L=0.7U W=5U AS=1.3P AD=1.3P PS=5.52U PD=5.52U
* device instance $24 r0 *1 42.595,141.445 pmos_6p0
M$24 6 7 3 3 pmos_6p0 L=0.7U W=5U AS=1.3P AD=1.3P PS=5.52U PD=5.52U
* device instance $25 r0 *1 43.815,141.445 pmos_6p0
M$25 3 7 6 3 pmos_6p0 L=0.7U W=5U AS=1.3P AD=1.3P PS=5.52U PD=5.52U
* device instance $26 r0 *1 45.035,141.445 pmos_6p0
M$26 6 7 3 3 pmos_6p0 L=0.7U W=5U AS=1.3P AD=1.3P PS=5.52U PD=5.52U
* device instance $27 r0 *1 46.255,141.445 pmos_6p0
M$27 3 7 6 3 pmos_6p0 L=0.7U W=5U AS=1.3P AD=1.3P PS=5.52U PD=5.52U
* device instance $28 r0 *1 47.475,141.445 pmos_6p0
M$28 6 7 3 3 pmos_6p0 L=0.7U W=5U AS=1.3P AD=1.3P PS=5.52U PD=5.52U
* device instance $29 r0 *1 48.695,141.445 pmos_6p0
M$29 3 7 6 3 pmos_6p0 L=0.7U W=5U AS=1.3P AD=1.3P PS=5.52U PD=5.52U
* device instance $30 r0 *1 49.915,141.445 pmos_6p0
M$30 6 7 3 3 pmos_6p0 L=0.7U W=5U AS=1.3P AD=1.3P PS=5.52U PD=5.52U
* device instance $31 r0 *1 51.135,141.445 pmos_6p0
M$31 3 7 6 3 pmos_6p0 L=0.7U W=5U AS=1.3P AD=2.2P PS=5.52U PD=10.88U
* device instance $32 r0 *1 26.305,132.53 nmos_6p0
M$32 7 5 1 10 nmos_6p0 L=0.7U W=5U AS=2.2P AD=1.3P PS=10.88U PD=5.52U
* device instance $33 r0 *1 27.525,132.53 nmos_6p0
M$33 1 5 7 10 nmos_6p0 L=0.7U W=5U AS=1.3P AD=1.3P PS=5.52U PD=5.52U
* device instance $34 r0 *1 28.745,132.53 nmos_6p0
M$34 7 5 1 10 nmos_6p0 L=0.7U W=5U AS=1.3P AD=1.3P PS=5.52U PD=5.52U
* device instance $35 r0 *1 29.965,132.53 nmos_6p0
M$35 1 5 7 10 nmos_6p0 L=0.7U W=5U AS=1.3P AD=1.3P PS=5.52U PD=5.52U
* device instance $36 r0 *1 31.185,132.53 nmos_6p0
M$36 7 5 1 10 nmos_6p0 L=0.7U W=5U AS=1.3P AD=1.3P PS=5.52U PD=5.52U
* device instance $37 r0 *1 32.405,132.53 nmos_6p0
M$37 1 5 7 10 nmos_6p0 L=0.7U W=5U AS=1.3P AD=1.3P PS=5.52U PD=5.52U
* device instance $38 r0 *1 33.625,132.53 nmos_6p0
M$38 6 7 1 10 nmos_6p0 L=0.7U W=5U AS=1.3P AD=1.3P PS=5.52U PD=5.52U
* device instance $39 r0 *1 34.845,132.53 nmos_6p0
M$39 1 7 6 10 nmos_6p0 L=0.7U W=5U AS=1.3P AD=1.3P PS=5.52U PD=5.52U
* device instance $40 r0 *1 36.065,132.53 nmos_6p0
M$40 6 7 1 10 nmos_6p0 L=0.7U W=5U AS=1.3P AD=1.3P PS=5.52U PD=5.52U
* device instance $41 r0 *1 37.285,132.53 nmos_6p0
M$41 1 7 6 10 nmos_6p0 L=0.7U W=5U AS=1.3P AD=1.3P PS=5.52U PD=5.52U
* device instance $42 r0 *1 38.505,132.53 nmos_6p0
M$42 6 7 1 10 nmos_6p0 L=0.7U W=5U AS=1.3P AD=1.3P PS=5.52U PD=5.52U
* device instance $43 r0 *1 39.725,132.53 nmos_6p0
M$43 1 7 6 10 nmos_6p0 L=0.7U W=5U AS=1.3P AD=2.2P PS=5.52U PD=10.88U
.ENDS comp018green_esd_clamp_v5p0_2

* cell comp018green_esd_clamp_v5p0_1
* pin
* pin
* pin gf180mcu_gnd
* pin
* pin
* pin
* pin
* pin
* pin
* pin
* pin
.SUBCKT comp018green_esd_clamp_v5p0_1 1 4 10 11 12 13 14 15 16 17 18
* net 10 gf180mcu_gnd
* cell instance $1 r0 *1 20.645,130.03
X$1 1 5 2 10 nmos_6p0_CDNS_406619561347
* cell instance $2 m0 *1 53.32,132.61
X$2 1 3 M1_PSUB_CDNS_40661956134125
* cell instance $3 r0 *1 0.215,128.085
X$3 15 16 12 11 1 4 1 18 17 14 13 top_route
* cell instance $4 r0 *1 0,0
X$4 6 4 1 18 22 17 16 15 14 13 21 12 11 10 nmos_clamp_20_50_4
* cell instance $5 m0 *1 11.49,132.61
X$5 1 3 M1_PSUB_CDNS_40661956134125
* cell instance $6 m0 *1 -1.78,232.535
X$6 4 2 1 10 comp018green_esd_rc_v5p0_1
* cell instance $7 r0 *1 25.955,130.03
X$7 20 1 7 1 7 1 7 1 5 5 5 5 5 5 nmos_6p0_CDNS_406619561346
* cell instance $8 r0 *1 33.275,130.03
X$8 20 1 6 1 6 1 6 1 7 7 7 7 7 7 nmos_6p0_CDNS_406619561346
* cell instance $9 r0 *1 20.71,135.54
X$9 2 M1_POLY2_CDNS_40661956134128
* cell instance $10 r0 *1 15.505,137.795
X$10 2 M1_POLY2_CDNS_40661956134127
* cell instance $11 r0 *1 13.325,138.945
X$11 19 5 4 5 4 4 2 2 2 2 9 4 pmos_6p0_CDNS_406619561344
* cell instance $12 r0 *1 11.49,141.595
X$12 4 8 9 4 M1_NWELL_CDNS_40661956134133
* cell instance $13 r0 *1 53.32,141.595
X$13 4 8 9 4 M1_NWELL_CDNS_40661956134133
* cell instance $14 r0 *1 32.405,145.185
X$14 4 8 9 4 M1_NWELL_CDNS_40661956134129
* cell instance $15 r0 *1 22.725,138.945
X$15 4 6 4 6 4 6 4 6 4 6 4 6 4 6 4 6 4 6 4 6 4 6 4 6 4 7 7 7 7 7 7 7 7 7 7 7 7
+ 7 7 7 7 7 7 7 7 7 7 7 7 4 9 pmos_6p0_CDNS_406619561342
* cell instance $16 r0 *1 18.205,138.945
X$16 19 7 4 4 7 5 5 5 9 4 pmos_6p0_CDNS_406619561343
* cell instance $17 r0 *1 29.355,136.18
X$17 5 M1_POLY2_CDNS_40661956134131
* cell instance $18 r0 *1 19.775,137.795
X$18 5 M1_POLY2_CDNS_40661956134130
* cell instance $19 r0 *1 6.565,127.585
X$19 6 22 M2_M1_CDNS_40661956134126
* cell instance $20 r0 *1 58.245,127.585
X$20 6 21 M2_M1_CDNS_40661956134126
* cell instance $21 r0 *1 36.675,136.18
X$21 7 M1_POLY2_CDNS_40661956134131
* cell instance $22 r0 *1 37.105,137.795
X$22 7 M1_POLY2_CDNS_40661956134132
* device instance $1 r0 *1 13.675,141.445 pmos_6p0
M$1 5 2 4 4 pmos_6p0 L=0.7U W=5U AS=2.2P AD=1.3P PS=10.88U PD=5.52U
* device instance $2 r0 *1 14.895,141.445 pmos_6p0
M$2 4 2 5 4 pmos_6p0 L=0.7U W=5U AS=1.3P AD=1.3P PS=5.52U PD=5.52U
* device instance $3 r0 *1 16.115,141.445 pmos_6p0
M$3 5 2 4 4 pmos_6p0 L=0.7U W=5U AS=1.3P AD=1.3P PS=5.52U PD=5.52U
* device instance $4 r0 *1 17.335,141.445 pmos_6p0
M$4 4 2 5 4 pmos_6p0 L=0.7U W=5U AS=1.3P AD=1.3P PS=5.52U PD=5.52U
* device instance $5 r0 *1 18.555,141.445 pmos_6p0
M$5 7 5 4 4 pmos_6p0 L=0.7U W=5U AS=1.3P AD=1.3P PS=5.52U PD=5.52U
* device instance $6 r0 *1 19.775,141.445 pmos_6p0
M$6 4 5 7 4 pmos_6p0 L=0.7U W=5U AS=1.3P AD=1.3P PS=5.52U PD=5.52U
* device instance $7 r0 *1 20.995,141.445 pmos_6p0
M$7 7 5 4 4 pmos_6p0 L=0.7U W=5U AS=1.3P AD=2.2P PS=5.52U PD=10.88U
* device instance $8 r0 *1 23.075,141.445 pmos_6p0
M$8 6 7 4 4 pmos_6p0 L=0.7U W=5U AS=2.2P AD=1.3P PS=10.88U PD=5.52U
* device instance $9 r0 *1 24.295,141.445 pmos_6p0
M$9 4 7 6 4 pmos_6p0 L=0.7U W=5U AS=1.3P AD=1.3P PS=5.52U PD=5.52U
* device instance $10 r0 *1 25.515,141.445 pmos_6p0
M$10 6 7 4 4 pmos_6p0 L=0.7U W=5U AS=1.3P AD=1.3P PS=5.52U PD=5.52U
* device instance $11 r0 *1 26.735,141.445 pmos_6p0
M$11 4 7 6 4 pmos_6p0 L=0.7U W=5U AS=1.3P AD=1.3P PS=5.52U PD=5.52U
* device instance $12 r0 *1 27.955,141.445 pmos_6p0
M$12 6 7 4 4 pmos_6p0 L=0.7U W=5U AS=1.3P AD=1.3P PS=5.52U PD=5.52U
* device instance $13 r0 *1 29.175,141.445 pmos_6p0
M$13 4 7 6 4 pmos_6p0 L=0.7U W=5U AS=1.3P AD=1.3P PS=5.52U PD=5.52U
* device instance $14 r0 *1 30.395,141.445 pmos_6p0
M$14 6 7 4 4 pmos_6p0 L=0.7U W=5U AS=1.3P AD=1.3P PS=5.52U PD=5.52U
* device instance $15 r0 *1 31.615,141.445 pmos_6p0
M$15 4 7 6 4 pmos_6p0 L=0.7U W=5U AS=1.3P AD=1.3P PS=5.52U PD=5.52U
* device instance $16 r0 *1 32.835,141.445 pmos_6p0
M$16 6 7 4 4 pmos_6p0 L=0.7U W=5U AS=1.3P AD=1.3P PS=5.52U PD=5.52U
* device instance $17 r0 *1 34.055,141.445 pmos_6p0
M$17 4 7 6 4 pmos_6p0 L=0.7U W=5U AS=1.3P AD=1.3P PS=5.52U PD=5.52U
* device instance $18 r0 *1 35.275,141.445 pmos_6p0
M$18 6 7 4 4 pmos_6p0 L=0.7U W=5U AS=1.3P AD=1.3P PS=5.52U PD=5.52U
* device instance $19 r0 *1 36.495,141.445 pmos_6p0
M$19 4 7 6 4 pmos_6p0 L=0.7U W=5U AS=1.3P AD=1.3P PS=5.52U PD=5.52U
* device instance $20 r0 *1 37.715,141.445 pmos_6p0
M$20 6 7 4 4 pmos_6p0 L=0.7U W=5U AS=1.3P AD=1.3P PS=5.52U PD=5.52U
* device instance $21 r0 *1 38.935,141.445 pmos_6p0
M$21 4 7 6 4 pmos_6p0 L=0.7U W=5U AS=1.3P AD=1.3P PS=5.52U PD=5.52U
* device instance $22 r0 *1 40.155,141.445 pmos_6p0
M$22 6 7 4 4 pmos_6p0 L=0.7U W=5U AS=1.3P AD=1.3P PS=5.52U PD=5.52U
* device instance $23 r0 *1 41.375,141.445 pmos_6p0
M$23 4 7 6 4 pmos_6p0 L=0.7U W=5U AS=1.3P AD=1.3P PS=5.52U PD=5.52U
* device instance $24 r0 *1 42.595,141.445 pmos_6p0
M$24 6 7 4 4 pmos_6p0 L=0.7U W=5U AS=1.3P AD=1.3P PS=5.52U PD=5.52U
* device instance $25 r0 *1 43.815,141.445 pmos_6p0
M$25 4 7 6 4 pmos_6p0 L=0.7U W=5U AS=1.3P AD=1.3P PS=5.52U PD=5.52U
* device instance $26 r0 *1 45.035,141.445 pmos_6p0
M$26 6 7 4 4 pmos_6p0 L=0.7U W=5U AS=1.3P AD=1.3P PS=5.52U PD=5.52U
* device instance $27 r0 *1 46.255,141.445 pmos_6p0
M$27 4 7 6 4 pmos_6p0 L=0.7U W=5U AS=1.3P AD=1.3P PS=5.52U PD=5.52U
* device instance $28 r0 *1 47.475,141.445 pmos_6p0
M$28 6 7 4 4 pmos_6p0 L=0.7U W=5U AS=1.3P AD=1.3P PS=5.52U PD=5.52U
* device instance $29 r0 *1 48.695,141.445 pmos_6p0
M$29 4 7 6 4 pmos_6p0 L=0.7U W=5U AS=1.3P AD=1.3P PS=5.52U PD=5.52U
* device instance $30 r0 *1 49.915,141.445 pmos_6p0
M$30 6 7 4 4 pmos_6p0 L=0.7U W=5U AS=1.3P AD=1.3P PS=5.52U PD=5.52U
* device instance $31 r0 *1 51.135,141.445 pmos_6p0
M$31 4 7 6 4 pmos_6p0 L=0.7U W=5U AS=1.3P AD=2.2P PS=5.52U PD=10.88U
* device instance $32 r0 *1 26.305,132.53 nmos_6p0
M$32 7 5 1 10 nmos_6p0 L=0.7U W=5U AS=2.2P AD=1.3P PS=10.88U PD=5.52U
* device instance $33 r0 *1 27.525,132.53 nmos_6p0
M$33 1 5 7 10 nmos_6p0 L=0.7U W=5U AS=1.3P AD=1.3P PS=5.52U PD=5.52U
* device instance $34 r0 *1 28.745,132.53 nmos_6p0
M$34 7 5 1 10 nmos_6p0 L=0.7U W=5U AS=1.3P AD=1.3P PS=5.52U PD=5.52U
* device instance $35 r0 *1 29.965,132.53 nmos_6p0
M$35 1 5 7 10 nmos_6p0 L=0.7U W=5U AS=1.3P AD=1.3P PS=5.52U PD=5.52U
* device instance $36 r0 *1 31.185,132.53 nmos_6p0
M$36 7 5 1 10 nmos_6p0 L=0.7U W=5U AS=1.3P AD=1.3P PS=5.52U PD=5.52U
* device instance $37 r0 *1 32.405,132.53 nmos_6p0
M$37 1 5 7 10 nmos_6p0 L=0.7U W=5U AS=1.3P AD=1.3P PS=5.52U PD=5.52U
* device instance $38 r0 *1 33.625,132.53 nmos_6p0
M$38 6 7 1 10 nmos_6p0 L=0.7U W=5U AS=1.3P AD=1.3P PS=5.52U PD=5.52U
* device instance $39 r0 *1 34.845,132.53 nmos_6p0
M$39 1 7 6 10 nmos_6p0 L=0.7U W=5U AS=1.3P AD=1.3P PS=5.52U PD=5.52U
* device instance $40 r0 *1 36.065,132.53 nmos_6p0
M$40 6 7 1 10 nmos_6p0 L=0.7U W=5U AS=1.3P AD=1.3P PS=5.52U PD=5.52U
* device instance $41 r0 *1 37.285,132.53 nmos_6p0
M$41 1 7 6 10 nmos_6p0 L=0.7U W=5U AS=1.3P AD=1.3P PS=5.52U PD=5.52U
* device instance $42 r0 *1 38.505,132.53 nmos_6p0
M$42 6 7 1 10 nmos_6p0 L=0.7U W=5U AS=1.3P AD=1.3P PS=5.52U PD=5.52U
* device instance $43 r0 *1 39.725,132.53 nmos_6p0
M$43 1 7 6 10 nmos_6p0 L=0.7U W=5U AS=1.3P AD=2.2P PS=5.52U PD=10.88U
.ENDS comp018green_esd_clamp_v5p0_1

* cell M1_PSUB_CDNS_4066195613418
* pin
.SUBCKT M1_PSUB_CDNS_4066195613418 1
.ENDS M1_PSUB_CDNS_4066195613418

* cell M3_M2_CDNS_40661956134108
* pin
* pin
.SUBCKT M3_M2_CDNS_40661956134108 1 2
.ENDS M3_M2_CDNS_40661956134108

* cell M3_M2_CDNS_4066195613491
* pin
* pin
.SUBCKT M3_M2_CDNS_4066195613491 1 2
.ENDS M3_M2_CDNS_4066195613491

* cell M2_M1_CDNS_4066195613492
* pin
* pin
.SUBCKT M2_M1_CDNS_4066195613492 1 2
.ENDS M2_M1_CDNS_4066195613492

* cell M2_M1_CDNS_4066195613470
* pin
* pin
.SUBCKT M2_M1_CDNS_4066195613470 1 2
.ENDS M2_M1_CDNS_4066195613470

* cell M3_M2_CDNS_4066195613493
* pin
* pin
.SUBCKT M3_M2_CDNS_4066195613493 1 2
.ENDS M3_M2_CDNS_4066195613493

* cell M2_M1_CDNS_4066195613494
* pin
* pin
.SUBCKT M2_M1_CDNS_4066195613494 1 2
.ENDS M2_M1_CDNS_4066195613494

* cell M2_M1_CDNS_40661956134109
* pin
* pin
.SUBCKT M2_M1_CDNS_40661956134109 1 2
.ENDS M2_M1_CDNS_40661956134109

* cell M2_M1_CDNS_40661956134110
* pin
* pin
.SUBCKT M2_M1_CDNS_40661956134110 1 2
.ENDS M2_M1_CDNS_40661956134110

* cell M3_M2_CDNS_40661956134111
* pin
* pin
.SUBCKT M3_M2_CDNS_40661956134111 1 2
.ENDS M3_M2_CDNS_40661956134111

* cell M2_M1_CDNS_40661956134104
* pin
* pin
.SUBCKT M2_M1_CDNS_40661956134104 1 2
.ENDS M2_M1_CDNS_40661956134104

* cell M3_M2_CDNS_40661956134105
* pin
* pin
.SUBCKT M3_M2_CDNS_40661956134105 1 2
.ENDS M3_M2_CDNS_40661956134105

* cell M3_M2_CDNS_40661956134106
* pin
* pin
.SUBCKT M3_M2_CDNS_40661956134106 1 2
.ENDS M3_M2_CDNS_40661956134106

* cell M2_M1_CDNS_40661956134107
* pin
* pin
.SUBCKT M2_M1_CDNS_40661956134107 1 2
.ENDS M2_M1_CDNS_40661956134107

* cell M1_PSUB_CDNS_4066195613455
* pin
.SUBCKT M1_PSUB_CDNS_4066195613455 1
.ENDS M1_PSUB_CDNS_4066195613455

* cell M1_PSUB_CDNS_4066195613458
* pin
* pin
.SUBCKT M1_PSUB_CDNS_4066195613458 1 2
.ENDS M1_PSUB_CDNS_4066195613458

* cell M1_PSUB_CDNS_4066195613448
* pin
* pin
.SUBCKT M1_PSUB_CDNS_4066195613448 1 2
.ENDS M1_PSUB_CDNS_4066195613448

* cell M2_M1_CDNS_4066195613471
* pin
* pin
.SUBCKT M2_M1_CDNS_4066195613471 1 2
.ENDS M2_M1_CDNS_4066195613471

* cell M1_PSUB_CDNS_4066195613450
* pin
* pin
.SUBCKT M1_PSUB_CDNS_4066195613450 1 2
.ENDS M1_PSUB_CDNS_4066195613450

* cell M3_M2_CDNS_4066195613472
* pin
* pin
.SUBCKT M3_M2_CDNS_4066195613472 1 2
.ENDS M3_M2_CDNS_4066195613472

* cell M1_PSUB_CDNS_4066195613456
* pin
* pin
.SUBCKT M1_PSUB_CDNS_4066195613456 1 2
.ENDS M1_PSUB_CDNS_4066195613456

* cell M2_M1_CDNS_4066195613478
* pin
* pin
.SUBCKT M2_M1_CDNS_4066195613478 1 2
.ENDS M2_M1_CDNS_4066195613478

* cell M3_M2_CDNS_4066195613479
* pin
* pin
.SUBCKT M3_M2_CDNS_4066195613479 1 2
.ENDS M3_M2_CDNS_4066195613479

* cell M3_M2_CDNS_4066195613473
* pin
* pin
.SUBCKT M3_M2_CDNS_4066195613473 1 2
.ENDS M3_M2_CDNS_4066195613473

* cell M3_M2_CDNS_4066195613488
* pin
* pin
.SUBCKT M3_M2_CDNS_4066195613488 1 2
.ENDS M3_M2_CDNS_4066195613488

* cell M2_M1_CDNS_4066195613486
* pin
* pin
.SUBCKT M2_M1_CDNS_4066195613486 1 2
.ENDS M2_M1_CDNS_4066195613486

* cell M2_M1_CDNS_40661956134102
* pin
* pin
.SUBCKT M2_M1_CDNS_40661956134102 1 2
.ENDS M2_M1_CDNS_40661956134102

* cell M3_M2_CDNS_40661956134103
* pin
* pin
.SUBCKT M3_M2_CDNS_40661956134103 1 2
.ENDS M3_M2_CDNS_40661956134103

* cell M1_PSUB_CDNS_4066195613451
* pin
* pin
.SUBCKT M1_PSUB_CDNS_4066195613451 1 2
.ENDS M1_PSUB_CDNS_4066195613451

* cell M3_M2_CDNS_4066195613495
* pin
* pin
.SUBCKT M3_M2_CDNS_4066195613495 1 2
.ENDS M3_M2_CDNS_4066195613495

* cell M2_M1_CDNS_4066195613496
* pin
* pin
.SUBCKT M2_M1_CDNS_4066195613496 1 2
.ENDS M2_M1_CDNS_4066195613496

* cell M3_M2_CDNS_4066195613497
* pin
* pin
.SUBCKT M3_M2_CDNS_4066195613497 1 2
.ENDS M3_M2_CDNS_4066195613497

* cell M2_M1_CDNS_4066195613498
* pin
* pin
.SUBCKT M2_M1_CDNS_4066195613498 1 2
.ENDS M2_M1_CDNS_4066195613498

* cell M3_M2_CDNS_4066195613462
* pin
* pin
.SUBCKT M3_M2_CDNS_4066195613462 1 2
.ENDS M3_M2_CDNS_4066195613462

* cell M2_M1_CDNS_4066195613463
* pin
* pin
.SUBCKT M2_M1_CDNS_4066195613463 1 2
.ENDS M2_M1_CDNS_4066195613463

* cell M3_M2_CDNS_40661956134101
* pin
* pin
.SUBCKT M3_M2_CDNS_40661956134101 1 2
.ENDS M3_M2_CDNS_40661956134101

* cell M2_M1_CDNS_4066195613487
* pin
* pin
.SUBCKT M2_M1_CDNS_4066195613487 1 2
.ENDS M2_M1_CDNS_4066195613487

* cell M1_PSUB_CDNS_4066195613434
* pin
* pin
.SUBCKT M1_PSUB_CDNS_4066195613434 1 2
.ENDS M1_PSUB_CDNS_4066195613434

* cell M2_M1_CDNS_4066195613460
* pin
* pin
.SUBCKT M2_M1_CDNS_4066195613460 1 2
.ENDS M2_M1_CDNS_4066195613460

* cell M3_M2_CDNS_4066195613461
* pin
* pin
.SUBCKT M3_M2_CDNS_4066195613461 1 2
.ENDS M3_M2_CDNS_4066195613461

* cell M2_M1_CDNS_4066195613466
* pin
* pin
.SUBCKT M2_M1_CDNS_4066195613466 1 2
.ENDS M2_M1_CDNS_4066195613466

* cell M2_M1_CDNS_4066195613421
* pin
* pin
.SUBCKT M2_M1_CDNS_4066195613421 1 2
.ENDS M2_M1_CDNS_4066195613421

* cell M2_M1_CDNS_4066195613483
* pin
.SUBCKT M2_M1_CDNS_4066195613483 1
.ENDS M2_M1_CDNS_4066195613483

* cell M3_M2_CDNS_4066195613482
* pin
* pin
.SUBCKT M3_M2_CDNS_4066195613482 1 2
.ENDS M3_M2_CDNS_4066195613482

* cell M1_PSUB_CDNS_4066195613431
* pin
* pin
.SUBCKT M1_PSUB_CDNS_4066195613431 1 2
.ENDS M1_PSUB_CDNS_4066195613431

* cell M3_M2_CDNS_4066195613454
* pin
* pin
.SUBCKT M3_M2_CDNS_4066195613454 1 2
.ENDS M3_M2_CDNS_4066195613454

* cell M2_M1_CDNS_4066195613459
* pin
* pin
.SUBCKT M2_M1_CDNS_4066195613459 1 2
.ENDS M2_M1_CDNS_4066195613459

* cell M2_M1_CDNS_4066195613464
* pin
* pin
.SUBCKT M2_M1_CDNS_4066195613464 1 2
.ENDS M2_M1_CDNS_4066195613464

* cell M3_M2_CDNS_4066195613465
* pin
* pin
.SUBCKT M3_M2_CDNS_4066195613465 1 2
.ENDS M3_M2_CDNS_4066195613465

* cell M2_M1_CDNS_4066195613469
* pin
* pin
.SUBCKT M2_M1_CDNS_4066195613469 1 2
.ENDS M2_M1_CDNS_4066195613469

* cell M3_M2_CDNS_4066195613474
* pin
* pin
.SUBCKT M3_M2_CDNS_4066195613474 1 2
.ENDS M3_M2_CDNS_4066195613474

* cell M2_M1_CDNS_4066195613475
* pin
* pin
.SUBCKT M2_M1_CDNS_4066195613475 1 2
.ENDS M2_M1_CDNS_4066195613475

* cell M3_M2_CDNS_4066195613476
* pin
* pin
.SUBCKT M3_M2_CDNS_4066195613476 1 2
.ENDS M3_M2_CDNS_4066195613476

* cell M3_M2_CDNS_4066195613477
* pin
* pin
.SUBCKT M3_M2_CDNS_4066195613477 1 2
.ENDS M3_M2_CDNS_4066195613477

* cell M2_M1_CDNS_4066195613484
* pin
* pin
.SUBCKT M2_M1_CDNS_4066195613484 1 2
.ENDS M2_M1_CDNS_4066195613484

* cell M3_M2_CDNS_4066195613485
* pin
* pin
.SUBCKT M3_M2_CDNS_4066195613485 1 2
.ENDS M3_M2_CDNS_4066195613485

* cell M2_M1_CDNS_4066195613419
* pin
* pin
.SUBCKT M2_M1_CDNS_4066195613419 1 2
.ENDS M2_M1_CDNS_4066195613419

* cell M2_M1_CDNS_4066195613420
* pin
* pin
.SUBCKT M2_M1_CDNS_4066195613420 1 2
.ENDS M2_M1_CDNS_4066195613420

* cell M3_M2_CDNS_4066195613422
* pin
* pin
.SUBCKT M3_M2_CDNS_4066195613422 1 2
.ENDS M3_M2_CDNS_4066195613422

* cell M3_M2_CDNS_4066195613423
* pin
* pin
.SUBCKT M3_M2_CDNS_4066195613423 1 2
.ENDS M3_M2_CDNS_4066195613423

* cell M3_M2_CDNS_4066195613424
* pin
* pin
.SUBCKT M3_M2_CDNS_4066195613424 1 2
.ENDS M3_M2_CDNS_4066195613424

* cell M2_M1_CDNS_4066195613425
* pin
* pin
.SUBCKT M2_M1_CDNS_4066195613425 1 2
.ENDS M2_M1_CDNS_4066195613425

* cell M3_M2_CDNS_4066195613426
* pin
* pin
.SUBCKT M3_M2_CDNS_4066195613426 1 2
.ENDS M3_M2_CDNS_4066195613426

* cell M3_M2_CDNS_4066195613427
* pin
* pin
.SUBCKT M3_M2_CDNS_4066195613427 1 2
.ENDS M3_M2_CDNS_4066195613427

* cell M2_M1_CDNS_4066195613428
* pin
* pin
.SUBCKT M2_M1_CDNS_4066195613428 1 2
.ENDS M2_M1_CDNS_4066195613428

* cell M3_M2_CDNS_4066195613499
* pin
* pin
.SUBCKT M3_M2_CDNS_4066195613499 1 2
.ENDS M3_M2_CDNS_4066195613499

* cell M3_M2_CDNS_4066195613430
* pin
* pin
.SUBCKT M3_M2_CDNS_4066195613430 1 2
.ENDS M3_M2_CDNS_4066195613430

* cell M2_M1_CDNS_4066195613432
* pin
* pin
.SUBCKT M2_M1_CDNS_4066195613432 1 2
.ENDS M2_M1_CDNS_4066195613432

* cell M2_M1_CDNS_4066195613457
* pin
* pin
.SUBCKT M2_M1_CDNS_4066195613457 1 2
.ENDS M2_M1_CDNS_4066195613457

* cell M2_M1_CDNS_40661956134100
* pin
* pin
.SUBCKT M2_M1_CDNS_40661956134100 1 2
.ENDS M2_M1_CDNS_40661956134100

* cell M1_PSUB_CDNS_4066195613429
* pin
* pin
.SUBCKT M1_PSUB_CDNS_4066195613429 1 2
.ENDS M1_PSUB_CDNS_4066195613429

* cell M1_PSUB_CDNS_4066195613433
* pin
* pin
.SUBCKT M1_PSUB_CDNS_4066195613433 1 2
.ENDS M1_PSUB_CDNS_4066195613433

* cell M1_PSUB_CDNS_4066195613435
* pin
* pin
.SUBCKT M1_PSUB_CDNS_4066195613435 1 2
.ENDS M1_PSUB_CDNS_4066195613435

* cell M1_PSUB_CDNS_4066195613436
* pin
* pin
.SUBCKT M1_PSUB_CDNS_4066195613436 1 2
.ENDS M1_PSUB_CDNS_4066195613436

* cell M1_PSUB_CDNS_4066195613437
* pin
* pin
.SUBCKT M1_PSUB_CDNS_4066195613437 1 2
.ENDS M1_PSUB_CDNS_4066195613437

* cell M1_PSUB_CDNS_4066195613438
* pin
* pin
.SUBCKT M1_PSUB_CDNS_4066195613438 1 2
.ENDS M1_PSUB_CDNS_4066195613438

* cell M1_PSUB_CDNS_4066195613439
* pin
* pin
.SUBCKT M1_PSUB_CDNS_4066195613439 1 2
.ENDS M1_PSUB_CDNS_4066195613439

* cell M1_PSUB_CDNS_4066195613440
* pin
* pin
.SUBCKT M1_PSUB_CDNS_4066195613440 1 2
.ENDS M1_PSUB_CDNS_4066195613440

* cell M1_PSUB_CDNS_4066195613441
* pin
* pin
.SUBCKT M1_PSUB_CDNS_4066195613441 1 2
.ENDS M1_PSUB_CDNS_4066195613441

* cell M1_PSUB_CDNS_4066195613442
* pin
* pin
.SUBCKT M1_PSUB_CDNS_4066195613442 1 2
.ENDS M1_PSUB_CDNS_4066195613442

* cell M1_PSUB_CDNS_4066195613443
* pin
* pin
.SUBCKT M1_PSUB_CDNS_4066195613443 1 2
.ENDS M1_PSUB_CDNS_4066195613443

* cell M1_PSUB_CDNS_4066195613444
* pin
* pin
.SUBCKT M1_PSUB_CDNS_4066195613444 1 2
.ENDS M1_PSUB_CDNS_4066195613444

* cell M1_PSUB_CDNS_4066195613445
* pin
* pin
.SUBCKT M1_PSUB_CDNS_4066195613445 1 2
.ENDS M1_PSUB_CDNS_4066195613445

* cell M1_PSUB_CDNS_4066195613446
* pin
* pin
.SUBCKT M1_PSUB_CDNS_4066195613446 1 2
.ENDS M1_PSUB_CDNS_4066195613446

* cell M1_PSUB_CDNS_4066195613447
* pin
* pin
.SUBCKT M1_PSUB_CDNS_4066195613447 1 2
.ENDS M1_PSUB_CDNS_4066195613447

* cell M1_PSUB_CDNS_4066195613449
* pin
* pin
.SUBCKT M1_PSUB_CDNS_4066195613449 1 2
.ENDS M1_PSUB_CDNS_4066195613449

* cell M1_PSUB_CDNS_4066195613452
* pin
* pin
.SUBCKT M1_PSUB_CDNS_4066195613452 1 2
.ENDS M1_PSUB_CDNS_4066195613452

* cell M1_PSUB_CDNS_4066195613453
* pin
* pin
.SUBCKT M1_PSUB_CDNS_4066195613453 1 2
.ENDS M1_PSUB_CDNS_4066195613453

* cell M2_M1_CDNS_4066195613467
* pin
* pin
.SUBCKT M2_M1_CDNS_4066195613467 1 2
.ENDS M2_M1_CDNS_4066195613467

* cell M2_M1_CDNS_4066195613468
* pin
* pin
.SUBCKT M2_M1_CDNS_4066195613468 1 2
.ENDS M2_M1_CDNS_4066195613468

* cell M2_M1_CDNS_4066195613480
* pin
* pin
.SUBCKT M2_M1_CDNS_4066195613480 1 2
.ENDS M2_M1_CDNS_4066195613480

* cell M3_M2_CDNS_4066195613481
* pin
* pin
.SUBCKT M3_M2_CDNS_4066195613481 1 2
.ENDS M3_M2_CDNS_4066195613481

* cell M3_M2_CDNS_4066195613489
* pin
* pin
.SUBCKT M3_M2_CDNS_4066195613489 1 2
.ENDS M3_M2_CDNS_4066195613489

* cell M2_M1_CDNS_4066195613490
* pin
* pin
.SUBCKT M2_M1_CDNS_4066195613490 1 2
.ENDS M2_M1_CDNS_4066195613490

* cell M2_M1_CDNS_40661956134232
* pin
* pin
.SUBCKT M2_M1_CDNS_40661956134232 1 2
.ENDS M2_M1_CDNS_40661956134232

* cell M2_M1_CDNS_40661956134236
* pin
* pin
.SUBCKT M2_M1_CDNS_40661956134236 1 2
.ENDS M2_M1_CDNS_40661956134236

* cell M2_M1_CDNS_40661956134267
* pin
* pin
.SUBCKT M2_M1_CDNS_40661956134267 1 2
.ENDS M2_M1_CDNS_40661956134267

* cell M2_M1_CDNS_40661956134245
* pin
* pin
.SUBCKT M2_M1_CDNS_40661956134245 1 2
.ENDS M2_M1_CDNS_40661956134245

* cell M2_M1_CDNS_40661956134240
* pin
* pin
.SUBCKT M2_M1_CDNS_40661956134240 1 2
.ENDS M2_M1_CDNS_40661956134240

* cell M2_M1_CDNS_40661956134234
* pin
* pin
.SUBCKT M2_M1_CDNS_40661956134234 1 2
.ENDS M2_M1_CDNS_40661956134234

* cell M1_PSUB_CDNS_40661956134375
* pin
* pin
.SUBCKT M1_PSUB_CDNS_40661956134375 1 2
.ENDS M1_PSUB_CDNS_40661956134375

* cell M1_NWELL_CDNS_40661956134376
* pin
* pin
* pin
* pin
.SUBCKT M1_NWELL_CDNS_40661956134376 1 2 3 4
.ENDS M1_NWELL_CDNS_40661956134376

* cell M1_PSUB_CDNS_40661956134379
* pin
* pin
.SUBCKT M1_PSUB_CDNS_40661956134379 1 2
.ENDS M1_PSUB_CDNS_40661956134379

* cell M1_NWELL_CDNS_40661956134378
* pin
* pin
* pin
* pin
.SUBCKT M1_NWELL_CDNS_40661956134378 1 2 3 4
.ENDS M1_NWELL_CDNS_40661956134378

* cell M1_NWELL_CDNS_40661956134327
* pin
* pin
* pin
* pin
.SUBCKT M1_NWELL_CDNS_40661956134327 1 2 3 4
.ENDS M1_NWELL_CDNS_40661956134327

* cell M1_NWELL_CDNS_40661956134329
* pin
* pin
* pin
* pin
.SUBCKT M1_NWELL_CDNS_40661956134329 1 2 3 4
.ENDS M1_NWELL_CDNS_40661956134329

* cell pmos_6p0_CDNS_4066195613413
* pin
* pin
* pin
* pin
* pin
* pin
.SUBCKT pmos_6p0_CDNS_4066195613413 1 2 3 4 5 6
.ENDS pmos_6p0_CDNS_4066195613413

* cell pn_6p0_CDNS_4066195613410
* pin
* pin
.SUBCKT pn_6p0_CDNS_4066195613410 2 3
* device instance $1 r0 *1 0.24,0.24 pn_6p0
D$1 2 3 pn_6p0 A=0.2304P P=1.92U
.ENDS pn_6p0_CDNS_4066195613410

* cell M2_M1_CDNS_40661956134331
* pin
* pin
.SUBCKT M2_M1_CDNS_40661956134331 1 2
.ENDS M2_M1_CDNS_40661956134331

* cell M1_NWELL_CDNS_40661956134334
* pin
* pin
* pin
* pin
.SUBCKT M1_NWELL_CDNS_40661956134334 1 2 3 4
.ENDS M1_NWELL_CDNS_40661956134334

* cell M1_PSUB_CDNS_40661956134336
* pin
* pin
.SUBCKT M1_PSUB_CDNS_40661956134336 1 2
.ENDS M1_PSUB_CDNS_40661956134336

* cell M1_PSUB_CDNS_40661956134337
* pin
* pin
.SUBCKT M1_PSUB_CDNS_40661956134337 1 2
.ENDS M1_PSUB_CDNS_40661956134337

* cell M1_PSUB_CDNS_40661956134338
* pin
* pin
.SUBCKT M1_PSUB_CDNS_40661956134338 1 2
.ENDS M1_PSUB_CDNS_40661956134338

* cell M1_PSUB_CDNS_40661956134339
* pin
* pin
.SUBCKT M1_PSUB_CDNS_40661956134339 1 2
.ENDS M1_PSUB_CDNS_40661956134339

* cell M1_NWELL_CDNS_40661956134340
* pin
* pin
* pin
* pin
.SUBCKT M1_NWELL_CDNS_40661956134340 1 2 3 4
.ENDS M1_NWELL_CDNS_40661956134340

* cell M1_PSUB_CDNS_40661956134342
* pin
* pin
.SUBCKT M1_PSUB_CDNS_40661956134342 1 2
.ENDS M1_PSUB_CDNS_40661956134342

* cell pmos_6p0_CDNS_4066195613421
* pin
* pin
* pin
* pin
* pin
* pin
* pin
.SUBCKT pmos_6p0_CDNS_4066195613421 1 2 3 4 5 6 7
.ENDS pmos_6p0_CDNS_4066195613421

* cell pmos_6p0_CDNS_4066195613417
* pin
* pin
* pin
* pin
* pin
.SUBCKT pmos_6p0_CDNS_4066195613417 2 3 4 5 6
* device instance $1 r0 *1 0.35,0.6 pmos_6p0
M$1 3 4 2 6 pmos_6p0 L=0.7U W=1.2U AS=0.528P AD=0.528P PS=3.28U PD=3.28U
.ENDS pmos_6p0_CDNS_4066195613417

* cell pmos_6p0_CDNS_4066195613416
* pin
* pin
* pin
* pin
* pin
* pin
* pin
* pin
.SUBCKT pmos_6p0_CDNS_4066195613416 1 2 3 4 5 6 7 8
.ENDS pmos_6p0_CDNS_4066195613416

* cell pmos_6p0_CDNS_4066195613415
* pin
* pin
* pin
* pin
* pin
* pin
.SUBCKT pmos_6p0_CDNS_4066195613415 1 2 3 4 5 6
.ENDS pmos_6p0_CDNS_4066195613415

* cell nmos_6p0_CDNS_4066195613420
* pin
* pin
* pin
* pin
* pin
* pin
.SUBCKT nmos_6p0_CDNS_4066195613420 1 2 3 4 5 6
.ENDS nmos_6p0_CDNS_4066195613420

* cell nmos_6p0_CDNS_4066195613419
* pin
* pin
* pin
* pin
.SUBCKT nmos_6p0_CDNS_4066195613419 1 2 3 4
.ENDS nmos_6p0_CDNS_4066195613419

* cell nmos_6p0_CDNS_4066195613418
* pin
* pin
* pin
* pin
* pin
* pin
.SUBCKT nmos_6p0_CDNS_4066195613418 1 2 3 4 5 6
.ENDS nmos_6p0_CDNS_4066195613418

* cell nmos_6p0_CDNS_4066195613414
* pin
* pin
* pin
* pin gf180mcu_gnd
.SUBCKT nmos_6p0_CDNS_4066195613414 2 3 4 5
* net 5 gf180mcu_gnd
* device instance $1 r0 *1 0.35,0.6 nmos_6p0
M$1 3 4 2 5 nmos_6p0 L=0.7U W=1.2U AS=0.528P AD=0.528P PS=3.28U PD=3.28U
.ENDS nmos_6p0_CDNS_4066195613414

* cell M1_POLY2_CDNS_40661956134333
* pin
.SUBCKT M1_POLY2_CDNS_40661956134333 1
.ENDS M1_POLY2_CDNS_40661956134333

* cell M1_PSUB_CDNS_40661956134199
* pin
* pin
.SUBCKT M1_PSUB_CDNS_40661956134199 1 2
.ENDS M1_PSUB_CDNS_40661956134199

* cell M2_M1_CDNS_40661956134286
* pin
* pin
.SUBCKT M2_M1_CDNS_40661956134286 1 2
.ENDS M2_M1_CDNS_40661956134286

* cell comp018green_in_pupd
* pin
* pin
* pin DVSS
* pin DVDD
* pin A
* pin PU_B
* pin PD
* pin
* pin gf180mcu_gnd
.SUBCKT comp018green_in_pupd 3 5 6 8 11 12 13 21 22
* net 6 DVSS
* net 8 DVDD
* net 11 A
* net 12 PU_B
* net 13 PD
* net 22 gf180mcu_gnd
* cell instance $1 r270 *1 41.715,-36.675
X$1 6 1 M1_PSUB_CDNS_40661956134341
* cell instance $2 r270 *1 39.365,-34.965
X$2 6 1 M1_PSUB_CDNS_40661956134330
* cell instance $3 r270 *1 39.365,-38.385
X$3 6 1 M1_PSUB_CDNS_40661956134330
* cell instance $4 m0 *1 20.97,14.535
X$4 5 2 4 5 M1_NWELL_CDNS_40661956134419
* cell instance $5 m0 *1 0.225,7.72
X$5 5 2 4 5 M1_NWELL_CDNS_40661956134335
* cell instance $6 m0 *1 20.97,0.905
X$6 5 2 4 5 M1_NWELL_CDNS_40661956134419
* cell instance $7 m135 *1 32.615,-34.965
X$7 8 9 3 8 M1_NWELL_CDNS_40661956134418
* cell instance $8 m135 *1 30.265,-36.675
X$8 8 9 3 8 M1_NWELL_CDNS_40661956134377
* cell instance $9 m135 *1 34.39,-36.32
X$9 23 8 7 21 3 8 pmos_6p0_CDNS_4066195613412
* cell instance $10 m135 *1 40.59,-36.32
X$10 6 7 13 nmos_6p0_CDNS_4066195613430
* cell instance $11 r0 *1 2.02,12.22
X$11 7 14 22 ppolyf_u_CDNS_4066195613433
* cell instance $12 r0 *1 44.51,-37.39
X$12 7 10 M2_M1_CDNS_40661956134237
* cell instance $13 r0 *1 40.14,-37.39
X$13 7 10 M2_M1_CDNS_40661956134237
* cell instance $14 m90 *1 26.04,2.42
X$14 20 11 22 ppolyf_u_CDNS_4066195613432
* cell instance $15 r90 *1 37.83,-36.67
X$15 13 M1_POLY2_CDNS_40661956134326
* cell instance $16 r0 *1 2.02,10.82
X$16 15 14 22 ppolyf_u_CDNS_4066195613433
* cell instance $17 r0 *1 2.02,9.42
X$17 15 16 22 ppolyf_u_CDNS_4066195613433
* cell instance $18 m90 *1 38.74,8.02
X$18 16 17 22 ppolyf_u_CDNS_4066195613433
* cell instance $19 r0 *1 2.02,6.62
X$19 17 18 22 ppolyf_u_CDNS_4066195613433
* cell instance $20 m90 *1 38.74,5.22
X$20 18 19 22 ppolyf_u_CDNS_4066195613433
* cell instance $21 r0 *1 2.02,3.82
X$21 19 20 22 ppolyf_u_CDNS_4066195613433
* cell instance $22 r90 *1 35.015,-36.67
X$22 21 M1_POLY2_CDNS_40661956134326
* device instance $1 r0 *1 32.89,-36.67 pmos_6p0
M$1 8 21 7 8 pmos_6p0 L=0.7U W=3U AS=1.32P AD=1.32P PS=6.88U PD=6.88U
* device instance $2 r0 *1 39.84,-36.67 nmos_6p0
M$2 6 13 7 22 nmos_6p0 L=0.7U W=1.5U AS=0.66P AD=0.66P PS=3.88U PD=3.88U
.ENDS comp018green_in_pupd

* cell comp018green_in_drv
* pin DVSS
* pin VDD
* pin
* pin VSS
* pin DVDD
* pin A
* pin gf180mcu_gnd
.SUBCKT comp018green_in_drv 1 2 5 6 7 15 16
* net 1 DVSS
* net 2 VDD
* net 4 Z
* net 6 VSS
* net 7 DVDD
* net 15 A
* net 16 gf180mcu_gnd
* cell instance $1 r0 *1 -0.46,1.315
X$1 1 3 3 15 15 16 nmos_6p0_CDNS_4066195613447
* cell instance $2 m0 *1 0.36,0.225
X$2 1 9 M1_PSUB_CDNS_40661956134325
* cell instance $3 m0 *1 2.825,3.045
X$3 1 9 M1_PSUB_CDNS_40661956134429
* cell instance $4 m0 *1 -1.99,3.045
X$4 1 9 M1_PSUB_CDNS_40661956134429
* cell instance $5 r0 *1 7.055,7.61
X$5 4 2 4 2 2 3 3 3 3 13 2 pmos_6p0_CDNS_4066195613446
* cell instance $6 r0 *1 13.465,12.235
X$6 2 11 13 2 M1_NWELL_CDNS_40661956134428
* cell instance $7 r0 *1 12.795,7.61
X$7 5 2 5 2 5 2 2 4 4 4 4 4 4 13 2 pmos_6p0_CDNS_4066195613448
* cell instance $8 r0 *1 21.275,9.885
X$8 2 11 13 2 M1_NWELL_CDNS_40661956134418
* cell instance $9 r0 *1 5.805,9.885
X$9 2 11 13 2 M1_NWELL_CDNS_40661956134418
* cell instance $10 r0 *1 0.76,9.055
X$10 7 3 15 12 7 pmos_6p0_CDNS_4066195613439
* cell instance $11 r0 *1 8.275,1.35
X$11 4 6 6 3 3 16 nmos_6p0_CDNS_4066195613450
* cell instance $12 r0 *1 -0.72,2.57
X$12 3 14 M2_M1_CDNS_40661956134320
* cell instance $13 r0 *1 1.72,2.57
X$13 3 14 M2_M1_CDNS_40661956134320
* cell instance $14 r0 *1 7.405,5.975
X$14 3 M1_POLY2_CDNS_40661956134326
* cell instance $15 r0 *1 11.065,5.975
X$15 3 M1_POLY2_CDNS_40661956134326
* cell instance $16 r0 *1 9.845,5.975
X$16 3 M1_POLY2_CDNS_40661956134326
* cell instance $17 r0 *1 8.625,5.975
X$17 3 M1_POLY2_CDNS_40661956134326
* cell instance $18 r0 *1 12.795,1.35
X$18 5 6 5 6 5 6 6 4 4 4 4 4 4 16 nmos_6p0_CDNS_4066195613449
* cell instance $19 r0 *1 19.245,5.975
X$19 4 M1_POLY2_CDNS_40661956134326
* cell instance $20 r0 *1 18.025,5.975
X$20 4 M1_POLY2_CDNS_40661956134326
* cell instance $21 r0 *1 13.145,5.975
X$21 4 M1_POLY2_CDNS_40661956134326
* cell instance $22 r0 *1 14.365,5.975
X$22 4 M1_POLY2_CDNS_40661956134326
* cell instance $23 r0 *1 16.805,5.975
X$23 4 M1_POLY2_CDNS_40661956134326
* cell instance $24 r0 *1 15.585,5.975
X$24 4 M1_POLY2_CDNS_40661956134326
* cell instance $25 m0 *1 13.625,0.225
X$25 6 8 M1_PSUB_CDNS_40661956134430
* cell instance $26 m0 *1 21.445,2.575
X$26 6 8 M1_PSUB_CDNS_40661956134330
* cell instance $27 m0 *1 5.805,2.575
X$27 6 8 M1_PSUB_CDNS_40661956134330
* cell instance $28 r0 *1 -0.595,10.59
X$28 7 10 12 7 M1_NWELL_CDNS_40661956134431
* cell instance $29 r0 *1 2.825,10.59
X$29 7 10 12 7 M1_NWELL_CDNS_40661956134431
* cell instance $30 r0 *1 1.115,12.235
X$30 7 10 12 7 M1_NWELL_CDNS_40661956134377
* cell instance $31 r0 *1 1.11,6.71
X$31 15 M1_POLY2_CDNS_40661956134326
* cell instance $32 r0 *1 -0.12,6.71
X$32 15 M1_POLY2_CDNS_40661956134326
.ENDS comp018green_in_drv

* cell comp018green_in_logic_pupd
* pin
* pin PD_IN
* pin
* pin PUB_OUT
* pin PDB_OUT
* pin VDD
* pin VSS
* pin
* pin
* pin gf180mcu_gnd
.SUBCKT comp018green_in_logic_pupd 3 4 5 7 8 9 10 11 12 13
* net 4 PD_IN
* net 7 PUB_OUT
* net 8 PDB_OUT
* net 9 VDD
* net 10 VSS
* net 13 gf180mcu_gnd
* cell instance $1 m45 *1 7.44,4.65
X$1 5 1 M2_M1_CDNS_40661956134270
* cell instance $2 r0 *1 6.685,-6.175
X$2 5 1 M2_M1_CDNS_40661956134270
* cell instance $3 r0 *1 2.555,-16.385
X$3 2 5 4 6 9 10 13 comp018green_std_xor2
* cell instance $4 m0 *1 9.28,4.405
X$4 6 2 M2_M1_CDNS_40661956134270
* cell instance $5 m0 *1 14.11,4.45
X$5 4 3 M2_M1_CDNS_40661956134270
* cell instance $6 r0 *1 14.69,-2.835
X$6 4 3 M2_M1_CDNS_40661956134270
* cell instance $7 m0 *1 10.84,10.765
X$7 8 16 15 14 12 11 6 4 12 13 comp018green_std_nand2
* cell instance $8 m0 *1 6.01,10.765
X$8 7 16 15 14 12 11 5 6 12 13 comp018green_std_nand2
.ENDS comp018green_in_logic_pupd

* cell M3_M2_CDNS_40661956134416
* pin
* pin
.SUBCKT M3_M2_CDNS_40661956134416 1 2
.ENDS M3_M2_CDNS_40661956134416

* cell M2_M1_CDNS_40661956134415
* pin
* pin
.SUBCKT M2_M1_CDNS_40661956134415 1 2
.ENDS M2_M1_CDNS_40661956134415

* cell comp018green_sigbuf
* pin Z
* pin VSS
* pin ZB
* pin
* pin
* pin
* pin
* pin
* pin
* pin DVSS
* pin DVDD
* pin A
* pin VDD
* pin
* pin
* pin gf180mcu_gnd
.SUBCKT comp018green_sigbuf 1 2 3 5 6 7 8 9 10 11 12 13 14 15 16 17
* net 1 Z
* net 2 VSS
* net 3 ZB
* net 11 DVSS
* net 12 DVDD
* net 13 A
* net 14 VDD
* net 17 gf180mcu_gnd
* cell instance $1 r0 *1 10.245,8.11
X$1 18 3 12 12 1 1 10 16 pmos_6p0_CDNS_4066195613429
* cell instance $2 r0 *1 10.245,1.77
X$2 19 3 11 11 1 1 nmos_6p0_CDNS_4066195613431
* cell instance $3 r0 *1 10.545,5.485
X$3 1 M1_POLY2_CDNS_40661956134326
* cell instance $4 r0 *1 7.805,8.11
X$4 18 1 12 12 4 4 10 16 pmos_6p0_CDNS_4066195613429
* cell instance $5 r0 *1 7.805,1.77
X$5 19 1 11 11 4 4 nmos_6p0_CDNS_4066195613431
* cell instance $6 m0 *1 3.645,2.34
X$6 2 5 M1_PSUB_CDNS_40661956134332
* cell instance $7 m0 *1 1.935,0.225
X$7 2 5 M1_PSUB_CDNS_40661956134341
* cell instance $8 r0 *1 1.58,1.77
X$8 2 4 13 nmos_6p0_CDNS_4066195613430
* cell instance $9 m0 *1 0.225,2.575
X$9 2 5 M1_PSUB_CDNS_40661956134330
* cell instance $10 r0 *1 8.105,5.485
X$10 4 M1_POLY2_CDNS_40661956134326
* cell instance $11 r0 *1 1.58,7.43
X$11 20 14 4 13 9 15 pmos_6p0_CDNS_4066195613412
* cell instance $12 m0 *1 9.98,0.225
X$12 11 6 M1_PSUB_CDNS_40661956134424
* cell instance $13 m0 *1 6.625,2.34
X$13 11 6 M1_PSUB_CDNS_40661956134332
* cell instance $14 m0 *1 13.335,2.575
X$14 11 6 M1_PSUB_CDNS_40661956134330
* cell instance $15 r0 *1 9.98,12.235
X$15 12 7 10 16 M1_NWELL_CDNS_40661956134425
* cell instance $16 r0 *1 6.625,9.885
X$16 12 7 10 16 M1_NWELL_CDNS_40661956134418
* cell instance $17 r0 *1 13.335,9.885
X$17 12 7 10 16 M1_NWELL_CDNS_40661956134418
* cell instance $18 r0 *1 1.935,12.235
X$18 14 8 9 15 M1_NWELL_CDNS_40661956134377
* cell instance $19 r0 *1 3.645,9.885
X$19 14 8 9 15 M1_NWELL_CDNS_40661956134418
* cell instance $20 r0 *1 0.225,9.885
X$20 14 8 9 15 M1_NWELL_CDNS_40661956134418
* cell instance $21 r0 *1 1.88,5.485
X$21 13 M1_POLY2_CDNS_40661956134326
* device instance $1 r0 *1 8.155,9.61 pmos_6p0
M$1 1 4 12 16 pmos_6p0 L=0.7U W=3U AS=1.32P AD=0.78P PS=6.88U PD=3.52U
* device instance $2 r0 *1 9.375,9.61 pmos_6p0
M$2 12 4 1 16 pmos_6p0 L=0.7U W=3U AS=0.78P AD=0.78P PS=3.52U PD=3.52U
* device instance $3 r0 *1 10.595,9.61 pmos_6p0
M$3 3 1 12 16 pmos_6p0 L=0.7U W=3U AS=0.78P AD=0.78P PS=3.52U PD=3.52U
* device instance $4 r0 *1 11.815,9.61 pmos_6p0
M$4 12 1 3 16 pmos_6p0 L=0.7U W=3U AS=0.78P AD=1.32P PS=3.52U PD=6.88U
* device instance $5 r0 *1 1.93,8.93 pmos_6p0
M$5 4 13 14 15 pmos_6p0 L=0.7U W=3U AS=1.32P AD=1.32P PS=6.88U PD=6.88U
* device instance $6 r0 *1 8.155,2.52 nmos_6p0
M$6 1 4 11 17 nmos_6p0 L=0.7U W=1.5U AS=0.66P AD=0.39P PS=3.88U PD=2.02U
* device instance $7 r0 *1 9.375,2.52 nmos_6p0
M$7 11 4 1 17 nmos_6p0 L=0.7U W=1.5U AS=0.39P AD=0.39P PS=2.02U PD=2.02U
* device instance $8 r0 *1 10.595,2.52 nmos_6p0
M$8 3 1 11 17 nmos_6p0 L=0.7U W=1.5U AS=0.39P AD=0.39P PS=2.02U PD=2.02U
* device instance $9 r0 *1 11.815,2.52 nmos_6p0
M$9 11 1 3 17 nmos_6p0 L=0.7U W=1.5U AS=0.39P AD=0.66P PS=2.02U PD=3.88U
* device instance $10 r0 *1 1.93,2.52 nmos_6p0
M$10 4 13 2 17 nmos_6p0 L=0.7U W=1.5U AS=0.66P AD=0.66P PS=3.88U PD=3.88U
.ENDS comp018green_sigbuf

* cell M3_M2_CDNS_40661956134417
* pin
* pin
.SUBCKT M3_M2_CDNS_40661956134417 1 2
.ENDS M3_M2_CDNS_40661956134417

* cell pn_6p0_CDNS_4066195613428
* pin
* pin
* pin
* pin
* pin
.SUBCKT pn_6p0_CDNS_4066195613428 1 2 3 5 6
.ENDS pn_6p0_CDNS_4066195613428

* cell comp018green_in_cms_smt
* pin DVSS
* pin
* pin CS
* pin
* pin
* pin IE
* pin Z
* pin A
* pin
* pin DVDD
* pin
* pin
* pin gf180mcu_gnd
* pin
.SUBCKT comp018green_in_cms_smt 1 10 11 12 13 15 17 18 19 22 32 33 35 36
* net 1 DVSS
* net 11 CS
* net 15 IE
* net 17 Z
* net 18 A
* net 22 DVDD
* net 35 gf180mcu_gnd
* cell instance $1 r0 *1 2.295,1.4
X$1 9 1 1 19 19 35 nmos_6p0_CDNS_4066195613435
* cell instance $2 r0 *1 -3.25,2.845
X$2 1 M1_PSUB_CDNS_40661956134422
* cell instance $3 r0 *1 24.075,8.65
X$3 1 23 23 6 6 34 22 pmos_6p0_CDNS_4066195613444
* cell instance $4 r180 *1 6.55,4.6
X$4 1 8 9 nmos_6p0_CDNS_4066195613436
* cell instance $5 r0 *1 32.7,0.245
X$5 1 24 M2_M1_CDNS_40661956134237
* cell instance $6 m0 *1 17.205,0.225
X$6 1 4 M1_PSUB_CDNS_40661956134420
* cell instance $7 r0 *1 8.475,3.32
X$7 1 14 M2_M1_CDNS_40661956134270
* cell instance $8 r0 *1 8.735,1.4
X$8 2 1 2 1 1 2 15 15 15 15 15 35 nmos_6p0_CDNS_4066195613437
* cell instance $9 r0 *1 10.915,3.32
X$9 1 14 M2_M1_CDNS_40661956134270
* cell instance $10 r0 *1 13.36,3.32
X$10 1 14 M2_M1_CDNS_40661956134270
* cell instance $11 r0 *1 32.96,8.515
X$11 1 24 M2_M1_CDNS_40661956134270
* cell instance $12 m0 *1 33.72,2.575
X$12 1 4 M1_PSUB_CDNS_40661956134330
* cell instance $13 m0 *1 0.64,2.575
X$13 1 4 M1_PSUB_CDNS_40661956134330
* cell instance $14 r0 *1 16.015,1.69
X$14 2 3 2 3 3 18 18 18 18 35 nmos_6p0_CDNS_4066195613441
* cell instance $15 r0 *1 21.615,1.34
X$15 17 3 17 3 3 18 18 18 18 35 nmos_6p0_CDNS_4066195613442
* cell instance $16 r0 *1 27.215,3.04
X$16 12 3 8 35 nmos_6p0_CDNS_4066195613440
* cell instance $17 r0 *1 9.305,9.435
X$17 6 5 M2_M1_CDNS_40661956134270
* cell instance $18 r0 *1 28.895,8.63
X$18 6 5 M2_M1_CDNS_40661956134270
* cell instance $19 r0 *1 28.895,4.705
X$19 6 5 M2_M1_CDNS_40661956134270
* cell instance $20 m90 *1 10.265,8.985
X$20 6 22 22 11 11 34 22 pmos_6p0_CDNS_4066195613434
* cell instance $21 r180 *1 29.855,10.185
X$21 17 6 9 34 22 pmos_6p0_CDNS_4066195613439
* cell instance $22 r0 *1 29.155,3.655
X$22 6 17 11 nmos_6p0_CDNS_4066195613436
* cell instance $23 r90 *1 24.425,8.01
X$23 6 M1_POLY2_CDNS_40661956134326
* cell instance $24 r90 *1 25.645,8.01
X$24 6 M1_POLY2_CDNS_40661956134326
* cell instance $25 r90 *1 5.91,1.555
X$25 8 7 M2_M1_CDNS_40661956134270
* cell instance $26 r0 *1 32.055,4.705
X$26 8 7 M2_M1_CDNS_40661956134270
* cell instance $27 r0 *1 32.055,8.635
X$27 8 7 M2_M1_CDNS_40661956134270
* cell instance $28 r0 *1 27.66,2.355
X$28 8 M1_POLY2_CDNS_40661956134128
* cell instance $29 r0 *1 31.095,3.655
X$29 17 8 11 nmos_6p0_CDNS_4066195613430
* cell instance $30 m0 *1 31.095,10.185
X$30 17 8 9 34 22 pmos_6p0_CDNS_4066195613439
* cell instance $31 m90 *1 4.215,6.675
X$31 9 22 22 19 19 34 22 pmos_6p0_CDNS_4066195613445
* cell instance $32 r0 *1 8.65,7.4
X$32 9 25 M2_M1_CDNS_40661956134237
* cell instance $33 r0 *1 6.16,7.4
X$33 9 25 M2_M1_CDNS_40661956134237
* cell instance $34 r0 *1 6.2,5.39
X$34 9 M1_POLY2_CDNS_40661956134128
* cell instance $35 m45 *1 29.505,7.43
X$35 9 M1_POLY2_CDNS_40661956134326
* cell instance $36 m45 *1 31.445,7.43
X$36 9 M1_POLY2_CDNS_40661956134326
* cell instance $37 r0 *1 7.91,6.03
X$37 11 10 M2_M1_CDNS_40661956134237
* cell instance $38 r270 *1 29.505,5.95
X$38 11 M1_POLY2_CDNS_40661956134326
* cell instance $39 r270 *1 31.445,5.95
X$39 11 M1_POLY2_CDNS_40661956134326
* cell instance $40 r90 *1 9.915,8.01
X$40 11 M1_POLY2_CDNS_40661956134326
* cell instance $41 r90 *1 8.695,8.01
X$41 11 M1_POLY2_CDNS_40661956134326
* cell instance $42 r0 *1 26.955,3.89
X$42 12 13 M2_M1_CDNS_40661956134270
* cell instance $43 r180 *1 14.965,10.985
X$43 22 17 17 22 15 15 15 34 22 pmos_6p0_CDNS_4066195613443
* cell instance $44 r0 *1 13.505,5.37
X$44 15 27 M2_M1_CDNS_40661956134237
* cell instance $45 r0 *1 13.965,5.39
X$45 15 M1_POLY2_CDNS_40661956134128
* cell instance $46 r0 *1 12.745,5.39
X$46 15 M1_POLY2_CDNS_40661956134128
* cell instance $47 r0 *1 13.505,7.99
X$47 15 27 M2_M1_CDNS_40661956134237
* cell instance $48 r90 *1 13.395,8.01
X$48 15 M1_POLY2_CDNS_40661956134326
* cell instance $49 r0 *1 10.305,5.39
X$49 15 M1_POLY2_CDNS_40661956134128
* cell instance $50 r0 *1 11.525,5.39
X$50 15 M1_POLY2_CDNS_40661956134128
* cell instance $51 r0 *1 9.085,5.39
X$51 15 M1_POLY2_CDNS_40661956134128
* cell instance $52 r90 *1 14.615,8.01
X$52 15 M1_POLY2_CDNS_40661956134326
* cell instance $53 r90 *1 12.175,8.01
X$53 15 M1_POLY2_CDNS_40661956134326
* cell instance $54 r0 *1 15.22,6.685
X$54 17 16 M2_M1_CDNS_40661956134237
* cell instance $55 r0 *1 15.22,9.1
X$55 17 16 M2_M1_CDNS_40661956134270
* cell instance $56 r0 *1 30.475,4.705
X$56 17 26 M2_M1_CDNS_40661956134235
* cell instance $57 r0 *1 30.475,8.635
X$57 17 26 M2_M1_CDNS_40661956134235
* cell instance $58 r0 *1 24.755,6.69
X$58 17 21 M2_M1_CDNS_40661956134237
* cell instance $59 r0 *1 30.475,6.69
X$59 17 26 M2_M1_CDNS_40661956134237
* cell instance $60 r0 *1 22.195,6.69
X$60 17 20 M2_M1_CDNS_40661956134237
* cell instance $61 r0 *1 22.575,3.89
X$61 17 20 M2_M1_CDNS_40661956134270
* cell instance $62 r0 *1 25.015,3.895
X$62 17 21 M2_M1_CDNS_40661956134270
* cell instance $63 r0 *1 21.875,9.1
X$63 17 20 M2_M1_CDNS_40661956134270
* cell instance $64 r0 *1 20.915,8.65
X$64 17 23 23 18 18 34 22 pmos_6p0_CDNS_4066195613438
* cell instance $65 r0 *1 16.575,8.65
X$65 22 23 23 18 18 34 22 pmos_6p0_CDNS_4066195613444
* cell instance $66 r0 *1 19.83,8.03
X$66 18 28 M2_M1_CDNS_40661956134237
* cell instance $67 r0 *1 20.53,5.41
X$67 18 28 M2_M1_CDNS_40661956134237
* cell instance $68 r90 *1 20.025,5.39
X$68 18 M1_POLY2_CDNS_40661956134326
* cell instance $69 r90 *1 21.965,5.39
X$69 18 M1_POLY2_CDNS_40661956134326
* cell instance $70 r90 *1 23.185,5.39
X$70 18 M1_POLY2_CDNS_40661956134326
* cell instance $71 r90 *1 25.625,5.39
X$71 18 M1_POLY2_CDNS_40661956134326
* cell instance $72 r90 *1 17.585,5.39
X$72 18 M1_POLY2_CDNS_40661956134326
* cell instance $73 r90 *1 16.365,5.39
X$73 18 M1_POLY2_CDNS_40661956134326
* cell instance $74 r90 *1 18.805,5.39
X$74 18 M1_POLY2_CDNS_40661956134326
* cell instance $75 r90 *1 24.405,5.39
X$75 18 M1_POLY2_CDNS_40661956134326
* cell instance $76 r90 *1 21.265,8.01
X$76 18 M1_POLY2_CDNS_40661956134326
* cell instance $77 r90 *1 16.925,8.01
X$77 18 M1_POLY2_CDNS_40661956134326
* cell instance $78 r90 *1 18.145,8.01
X$78 18 M1_POLY2_CDNS_40661956134326
* cell instance $79 r90 *1 22.485,8.01
X$79 18 M1_POLY2_CDNS_40661956134326
* cell instance $80 r90 *1 3.54,4.78
X$80 19 36 M2_M1_CDNS_40661956134270
* cell instance $81 m0 *1 3.865,4.785
X$81 19 M1_POLY2_CDNS_40661956134326
* cell instance $82 m0 *1 2.645,4.785
X$82 19 M1_POLY2_CDNS_40661956134326
* cell instance $83 r0 *1 17.205,12.235
X$83 22 29 34 22 M1_NWELL_CDNS_40661956134421
* cell instance $84 r0 *1 0.64,9.885
X$84 22 29 34 22 M1_NWELL_CDNS_40661956134418
* cell instance $85 r0 *1 33.72,9.885
X$85 22 29 34 22 M1_NWELL_CDNS_40661956134418
* cell instance $86 r0 *1 -3.25,10.155
X$86 22 34 M1_NWELL_CDNS_40661956134423
* cell instance $87 r0 *1 18.455,11.14
X$87 23 30 M2_M1_CDNS_40661956134237
* cell instance $88 r0 *1 26.205,10.14
X$88 23 31 M2_M1_CDNS_40661956134270
* cell instance $89 r0 *1 23.085,10.14
X$89 23 31 M2_M1_CDNS_40661956134270
* cell instance $90 r0 *1 16.325,10.66
X$90 23 30 M2_M1_CDNS_40661956134270
* cell instance $91 r0 *1 20.665,10.14
X$91 23 31 M2_M1_CDNS_40661956134270
* device instance $1 r0 *1 29.505,4.405 nmos_6p0
M$1 17 11 6 35 nmos_6p0 L=0.7U W=1.5U AS=0.66P AD=0.66P PS=3.88U PD=3.88U
* device instance $2 r0 *1 6.2,3.85 nmos_6p0
M$2 1 9 8 35 nmos_6p0 L=0.7U W=1.5U AS=0.66P AD=0.66P PS=3.88U PD=3.88U
* device instance $3 r0 *1 31.445,4.405 nmos_6p0
M$3 8 11 17 35 nmos_6p0 L=0.7U W=1.5U AS=0.66P AD=0.66P PS=3.88U PD=3.88U
.ENDS comp018green_in_cms_smt

* cell M3_M2_CDNS_40661956134382
* pin
* pin
.SUBCKT M3_M2_CDNS_40661956134382 1 2
.ENDS M3_M2_CDNS_40661956134382

* cell M2_M1_CDNS_40661956134383
* pin
* pin
.SUBCKT M2_M1_CDNS_40661956134383 1 2
.ENDS M2_M1_CDNS_40661956134383

* cell M2_M1_CDNS_40661956134384
* pin
* pin
.SUBCKT M2_M1_CDNS_40661956134384 1 2
.ENDS M2_M1_CDNS_40661956134384

* cell M3_M2_CDNS_40661956134443
* pin
* pin
.SUBCKT M3_M2_CDNS_40661956134443 1 2
.ENDS M3_M2_CDNS_40661956134443

* cell M3_M2_CDNS_40661956134444
* pin
* pin
.SUBCKT M3_M2_CDNS_40661956134444 1 2
.ENDS M3_M2_CDNS_40661956134444

* cell M3_M2_CDNS_40661956134445
* pin
* pin
.SUBCKT M3_M2_CDNS_40661956134445 1 2
.ENDS M3_M2_CDNS_40661956134445

* cell M2_M1_CDNS_40661956134446
* pin
* pin
.SUBCKT M2_M1_CDNS_40661956134446 1 2
.ENDS M2_M1_CDNS_40661956134446

* cell M2_M1_CDNS_40661956134447
* pin
* pin
.SUBCKT M2_M1_CDNS_40661956134447 1 2
.ENDS M2_M1_CDNS_40661956134447

* cell comp018green_out_paddrv_4T_PMOS_GROUP
* pin
* pin
* pin
* pin
* pin
* pin
* pin
* pin
* pin
* pin
* pin
* pin
* pin
* pin
* pin
* pin
* pin
* pin
* pin
* pin
* pin
* pin
* pin
* pin
* pin
* pin
* pin
* pin
* pin
* pin
* pin
* pin
* pin
.SUBCKT comp018green_out_paddrv_4T_PMOS_GROUP 1 3 7 8 9 10 11 12 13 14 15 16 17
+ 18 21 22 23 24 25 26 27 28 29 30 31 35 49 50 51 52 53 54 56
* cell instance $1 r90 *1 30.955,-1.91
X$1 1 2 M1_PSUB_CDNS_40661956134465
* cell instance $2 r0 *1 58.725,74.545
X$2 1 43 M2_M1_CDNS_40661956134462
* cell instance $3 r0 *1 61.51,74.555
X$3 1 2 M1_PSUB_CDNS_40661956134460
* cell instance $4 r0 *1 58.725,70.44
X$4 1 43 M3_M2_CDNS_40661956134285
* cell instance $5 r0 *1 8.88,74.005
X$5 1 37 M2_M1_CDNS_40661956134458
* cell instance $6 r0 *1 8.86,72.33
X$6 1 2 M1_PSUB_CDNS_40661956134454
* cell instance $7 r0 *1 8.88,72.89
X$7 1 37 M3_M2_CDNS_40661956134461
* cell instance $8 r0 *1 44.255,74.005
X$8 1 41 M2_M1_CDNS_40661956134458
* cell instance $9 r0 *1 44.235,72.33
X$9 1 2 M1_PSUB_CDNS_40661956134454
* cell instance $10 r0 *1 44.255,72.89
X$10 1 41 M3_M2_CDNS_40661956134461
* cell instance $11 r0 *1 17.74,74.005
X$11 1 38 M2_M1_CDNS_40661956134458
* cell instance $12 r0 *1 17.72,72.33
X$12 1 2 M1_PSUB_CDNS_40661956134454
* cell instance $13 r0 *1 17.74,72.89
X$13 1 38 M3_M2_CDNS_40661956134461
* cell instance $14 r0 *1 26.565,74.005
X$14 1 39 M2_M1_CDNS_40661956134458
* cell instance $15 r0 *1 26.545,72.33
X$15 1 2 M1_PSUB_CDNS_40661956134454
* cell instance $16 r0 *1 26.565,72.89
X$16 1 39 M3_M2_CDNS_40661956134461
* cell instance $17 r0 *1 35.41,74.005
X$17 1 40 M2_M1_CDNS_40661956134458
* cell instance $18 r0 *1 35.39,72.33
X$18 1 2 M1_PSUB_CDNS_40661956134454
* cell instance $19 r0 *1 35.41,72.89
X$19 1 40 M3_M2_CDNS_40661956134461
* cell instance $20 r0 *1 53.085,74.005
X$20 1 42 M2_M1_CDNS_40661956134458
* cell instance $21 r0 *1 53.065,72.33
X$21 1 2 M1_PSUB_CDNS_40661956134454
* cell instance $22 r0 *1 53.085,72.89
X$22 1 42 M3_M2_CDNS_40661956134461
* cell instance $23 r0 *1 -3.09,-1.54
X$23 1 56 M2_M1_CDNS_40661956134449
* cell instance $24 m90 *1 -2.83,34.04
X$24 1 2 M1_PSUB_CDNS_40661956134387
* cell instance $25 r0 *1 -3.09,-1.54
X$25 1 56 M3_M2_CDNS_40661956134453
* cell instance $26 m90 *1 -1.27,34.04
X$26 1 2 M1_PSUB_CDNS_40661956134387
* cell instance $27 r0 *1 -2.925,70.44
X$27 1 35 M2_M1_CDNS_40661956134463
* cell instance $28 r0 *1 -2.925,70.44
X$28 1 35 M3_M2_CDNS_40661956134313
* cell instance $29 r0 *1 0.39,74.58
X$29 1 2 M1_PSUB_CDNS_40661956134460
* cell instance $30 r0 *1 3.08,74.545
X$30 1 36 M2_M1_CDNS_40661956134462
* cell instance $31 r0 *1 3.08,70.44
X$31 1 36 M3_M2_CDNS_40661956134285
* cell instance $32 m90 *1 64.845,-1.555
X$32 1 57 M2_M1_CDNS_40661956134450
* cell instance $33 r90 *1 30.95,-5.555
X$33 1 2 M1_PSUB_CDNS_40661956134452
* cell instance $34 m90 *1 64.845,-1.555
X$34 1 57 M3_M2_CDNS_40661956134313
* cell instance $35 m90 *1 64.73,34.04
X$35 1 2 M1_PSUB_CDNS_40661956134387
* cell instance $36 r0 *1 63.17,34.04
X$36 1 2 M1_PSUB_CDNS_40661956134387
* cell instance $37 m90 *1 1.38,35.225
X$37 3 4 3 34 M1_NWELL_CDNS_40661956134464
* cell instance $38 r0 *1 2.38,66.53
X$38 3 4 34 3 M1_NWELL_CDNS_40661956134448
* cell instance $39 r0 *1 59.52,66.53
X$39 3 4 34 3 M1_NWELL_CDNS_40661956134448
* cell instance $40 r0 *1 60.52,35.225
X$40 3 4 3 34 M1_NWELL_CDNS_40661956134464
* cell instance $41 r0 *1 58.755,61.695
X$41 3 32 M2_M1_CDNS_40661956134282
* cell instance $42 r0 *1 58.755,61.695
X$42 3 32 M3_M2_CDNS_40661956134466
* cell instance $43 r0 *1 3.655,14.2
X$43 17 18 25 3 3 34 24 55 comp018green_out_drv_pleg_4T_X
* cell instance $44 r0 *1 12.495,14.2
X$44 16 25 3 34 29 55 comp018green_out_drv_pleg_4T_Y
* cell instance $45 m90 *1 22.895,14.2
X$45 15 30 3 34 29 55 comp018green_out_drv_pleg_4T_Y
* cell instance $46 m90 *1 31.735,14.2
X$46 14 13 30 28 3 34 31 55 comp018green_out_drv_pleg_4T_X
* cell instance $47 r0 *1 30.175,14.2
X$47 11 12 26 28 3 34 27 55 comp018green_out_drv_pleg_4T_X
* cell instance $48 r0 *1 39.015,14.2
X$48 10 26 3 34 23 55 comp018green_out_drv_pleg_4T_Y
* cell instance $49 m90 *1 49.415,14.2
X$49 9 22 3 34 23 55 comp018green_out_drv_pleg_4T_Y
* cell instance $50 m90 *1 58.255,14.2
X$50 7 8 22 3 3 34 21 55 comp018green_out_drv_pleg_4T_X
* cell instance $51 r0 *1 4.045,14.86
X$51 20 51 3 24 PMOS_4T_metal_stack
* cell instance $52 m90 *1 57.865,14.86
X$52 19 50 3 21 PMOS_4T_metal_stack
* cell instance $53 r0 *1 3.11,61.695
X$53 3 33 M3_M2_CDNS_40661956134466
* cell instance $54 r0 *1 3.11,61.695
X$54 3 33 M2_M1_CDNS_40661956134282
* cell instance $55 r0 *1 3.11,7.54
X$55 3 6 M2_M1_CDNS_40661956134467
* cell instance $56 r90 *1 30.955,3.205
X$56 3 3 34 4 M1_NWELL_CDNS_40661956134390
* cell instance $57 r0 *1 3.11,7.54
X$57 3 6 M3_M2_CDNS_40661956134466
* cell instance $58 r0 *1 58.755,7.54
X$58 3 5 M2_M1_CDNS_40661956134467
* cell instance $59 r0 *1 58.755,7.54
X$59 3 5 M3_M2_CDNS_40661956134466
* cell instance $60 r0 *1 31.045,8.93
X$60 3 4 34 3 M1_NWELL_CDNS_40661956134455
* cell instance $61 r0 *1 2.85,52.875
X$61 3 20 M3_M2_CDNS_40661956134456
* cell instance $62 r0 *1 2.85,52.875
X$62 3 20 M2_M1_CDNS_40661956134457
* cell instance $63 r0 *1 59.06,52.875
X$63 3 19 M3_M2_CDNS_40661956134456
* cell instance $64 r0 *1 59.06,52.875
X$64 3 19 M2_M1_CDNS_40661956134457
* cell instance $65 r0 *1 59.06,42.37
X$65 3 19 M3_M2_CDNS_40661956134312
* cell instance $66 r0 *1 59.06,42.37
X$66 3 19 M2_M1_CDNS_40661956134451
* cell instance $67 r0 *1 2.85,26.46
X$67 3 20 M3_M2_CDNS_40661956134312
* cell instance $68 r0 *1 2.85,26.52
X$68 3 20 M2_M1_CDNS_40661956134451
* cell instance $69 r0 *1 2.85,42.37
X$69 3 20 M3_M2_CDNS_40661956134312
* cell instance $70 r0 *1 2.85,42.37
X$70 3 20 M2_M1_CDNS_40661956134451
* cell instance $71 r0 *1 59.06,26.46
X$71 3 19 M3_M2_CDNS_40661956134312
* cell instance $72 r0 *1 59.06,26.52
X$72 3 19 M2_M1_CDNS_40661956134451
* cell instance $73 r0 *1 59.06,16.405
X$73 3 19 M3_M2_CDNS_40661956134368
* cell instance $74 r0 *1 59.06,16.355
X$74 3 19 M2_M1_CDNS_40661956134459
* cell instance $75 r0 *1 2.85,16.405
X$75 3 20 M3_M2_CDNS_40661956134368
* cell instance $76 r0 *1 2.85,16.355
X$76 3 20 M2_M1_CDNS_40661956134459
* cell instance $77 r0 *1 49.6,14.21
X$77 7 M1_POLY2_CDNS_40661956134128
* cell instance $78 r0 *1 49.6,55.51
X$78 7 M1_POLY2_CDNS_40661956134128
* cell instance $79 r0 *1 56.53,14.21
X$79 8 M1_POLY2_CDNS_40661956134128
* cell instance $80 r0 *1 56.53,55.51
X$80 8 M1_POLY2_CDNS_40661956134128
* cell instance $81 r0 *1 47.665,14.21
X$81 9 M1_POLY2_CDNS_40661956134128
* cell instance $82 r0 *1 47.665,55.51
X$82 9 M1_POLY2_CDNS_40661956134128
* cell instance $83 r0 *1 40.77,14.21
X$83 10 M1_POLY2_CDNS_40661956134128
* cell instance $84 r0 *1 40.77,55.51
X$84 10 M1_POLY2_CDNS_40661956134128
* cell instance $85 r0 *1 38.835,14.21
X$85 11 M1_POLY2_CDNS_40661956134128
* cell instance $86 r0 *1 38.835,55.51
X$86 11 M1_POLY2_CDNS_40661956134128
* cell instance $87 r0 *1 31.925,14.21
X$87 12 M1_POLY2_CDNS_40661956134128
* cell instance $88 r0 *1 31.925,55.51
X$88 12 M1_POLY2_CDNS_40661956134128
* cell instance $89 r0 *1 29.985,14.21
X$89 13 M1_POLY2_CDNS_40661956134128
* cell instance $90 r0 *1 29.985,55.51
X$90 13 M1_POLY2_CDNS_40661956134128
* cell instance $91 r0 *1 23.08,14.21
X$91 14 M1_POLY2_CDNS_40661956134128
* cell instance $92 r0 *1 23.08,55.51
X$92 14 M1_POLY2_CDNS_40661956134128
* cell instance $93 r0 *1 21.125,14.21
X$93 15 M1_POLY2_CDNS_40661956134128
* cell instance $94 r0 *1 21.125,55.51
X$94 15 M1_POLY2_CDNS_40661956134128
* cell instance $95 r0 *1 14.255,14.21
X$95 16 M1_POLY2_CDNS_40661956134128
* cell instance $96 r0 *1 14.255,55.51
X$96 16 M1_POLY2_CDNS_40661956134128
* cell instance $97 r0 *1 12.325,14.21
X$97 17 M1_POLY2_CDNS_40661956134128
* cell instance $98 r0 *1 12.325,55.51
X$98 17 M1_POLY2_CDNS_40661956134128
* cell instance $99 r0 *1 5.395,14.21
X$99 18 M1_POLY2_CDNS_40661956134128
* cell instance $100 r0 *1 5.395,55.51
X$100 18 M1_POLY2_CDNS_40661956134128
* cell instance $101 r0 *1 48.245,14.86
X$101 45 50 22 21 PMOS_4T_metal_stack
* cell instance $102 r0 *1 39.405,14.86
X$102 47 53 26 23 PMOS_4T_metal_stack
* cell instance $103 r0 *1 12.885,14.86
X$103 44 49 25 29 PMOS_4T_metal_stack
* cell instance $104 r0 *1 30.565,14.86
X$104 46 52 28 27 PMOS_4T_metal_stack
* cell instance $105 r0 *1 21.725,14.86
X$105 48 54 30 31 PMOS_4T_metal_stack
* device instance $1 r0 *1 5.395,34.86 pmos_6p0_sab
M$1 24 18 3 3 pmos_6p0_sab L=0.7U W=40U AS=31.6P AD=124.4P PS=81.58U PD=46.22U
* device instance $2 r0 *1 12.315,34.86 pmos_6p0_sab
M$2 25 17 24 3 pmos_6p0_sab L=0.7U W=40U AS=124.4P AD=24.4P PS=46.22U PD=41.22U
* device instance $3 r0 *1 14.235,34.86 pmos_6p0_sab
M$3 29 16 25 3 pmos_6p0_sab L=0.7U W=40U AS=24.4P AD=124.4P PS=41.22U PD=46.22U
* device instance $4 r0 *1 21.155,34.86 pmos_6p0_sab
M$4 30 15 29 3 pmos_6p0_sab L=0.7U W=40U AS=124.4P AD=24.4P PS=46.22U PD=41.22U
* device instance $5 r0 *1 23.075,34.86 pmos_6p0_sab
M$5 31 14 30 3 pmos_6p0_sab L=0.7U W=40U AS=24.4P AD=124.4P PS=41.22U PD=46.22U
* device instance $6 r0 *1 29.995,34.86 pmos_6p0_sab
M$6 28 13 31 3 pmos_6p0_sab L=0.7U W=40U AS=124.4P AD=24.4P PS=46.22U PD=41.22U
* device instance $7 r0 *1 31.915,34.86 pmos_6p0_sab
M$7 27 12 28 3 pmos_6p0_sab L=0.7U W=40U AS=24.4P AD=124.4P PS=41.22U PD=46.22U
* device instance $8 r0 *1 38.835,34.86 pmos_6p0_sab
M$8 26 11 27 3 pmos_6p0_sab L=0.7U W=40U AS=124.4P AD=24.4P PS=46.22U PD=41.22U
* device instance $9 r0 *1 40.755,34.86 pmos_6p0_sab
M$9 23 10 26 3 pmos_6p0_sab L=0.7U W=40U AS=24.4P AD=124.4P PS=41.22U PD=46.22U
* device instance $10 r0 *1 47.675,34.86 pmos_6p0_sab
M$10 22 9 23 3 pmos_6p0_sab L=0.7U W=40U AS=124.4P AD=24.4P PS=46.22U PD=41.22U
* device instance $11 r0 *1 49.595,34.86 pmos_6p0_sab
M$11 21 7 22 3 pmos_6p0_sab L=0.7U W=40U AS=24.4P AD=124.4P PS=41.22U PD=46.22U
* device instance $12 r0 *1 56.515,34.86 pmos_6p0_sab
M$12 3 8 21 3 pmos_6p0_sab L=0.7U W=40U AS=124.4P AD=31.6P PS=46.22U PD=81.58U
.ENDS comp018green_out_paddrv_4T_PMOS_GROUP

* cell comp018green_out_paddrv_4T_NMOS_GROUP
* pin
* pin
* pin
* pin
* pin
* pin
* pin
* pin
* pin
* pin
* pin
* pin
* pin
* pin
* pin
* pin
* pin
* pin gf180mcu_gnd
* pin
* pin
* pin
* pin
* pin
* pin
* pin
* pin
.SUBCKT comp018green_out_paddrv_4T_NMOS_GROUP 1 2 3 4 5 6 7 8 9 10 11 12 13 14
+ 15 16 17 18 19 23 24 25 27 28 29 30
* net 18 gf180mcu_gnd
* cell instance $1 m45 *1 4.575,44.77
X$1 1 M1_POLY2_CDNS_40661956134326
* cell instance $2 m45 *1 4.575,5.41
X$2 1 M1_POLY2_CDNS_40661956134326
* cell instance $3 r0 *1 2.985,3.4
X$3 26 17 16 15 1 6 comp018green_out_drv_nleg_4T
* cell instance $4 m45 *1 49.185,44.77
X$4 2 M1_POLY2_CDNS_40661956134326
* cell instance $5 m45 *1 49.185,5.41
X$5 2 M1_POLY2_CDNS_40661956134326
* cell instance $6 r0 *1 38.205,3.4
X$6 26 11 10 9 5 2 comp018green_out_drv_nleg_4T
* cell instance $7 m45 *1 28.055,5.41
X$7 3 M1_POLY2_CDNS_40661956134326
* cell instance $8 r0 *1 26.465,3.4
X$8 26 12 14 11 3 4 comp018green_out_drv_nleg_4T
* cell instance $9 m45 *1 28.055,44.77
X$9 3 M1_POLY2_CDNS_40661956134326
* cell instance $10 m45 *1 37.425,5.41
X$10 4 M1_POLY2_CDNS_40661956134326
* cell instance $11 m45 *1 37.425,44.77
X$11 4 M1_POLY2_CDNS_40661956134326
* cell instance $12 m45 *1 39.82,5.41
X$12 5 M1_POLY2_CDNS_40661956134326
* cell instance $13 m45 *1 39.82,44.77
X$13 5 M1_POLY2_CDNS_40661956134326
* cell instance $14 m45 *1 13.945,44.77
X$14 6 M1_POLY2_CDNS_40661956134326
* cell instance $15 m45 *1 13.945,5.41
X$15 6 M1_POLY2_CDNS_40661956134326
* cell instance $16 m45 *1 16.315,44.77
X$16 7 M1_POLY2_CDNS_40661956134326
* cell instance $17 m45 *1 16.315,5.41
X$17 7 M1_POLY2_CDNS_40661956134326
* cell instance $18 r0 *1 14.725,3.4
X$18 26 15 13 12 7 8 comp018green_out_drv_nleg_4T
* cell instance $19 m45 *1 25.685,5.41
X$19 8 M1_POLY2_CDNS_40661956134326
* cell instance $20 m45 *1 25.685,44.77
X$20 8 M1_POLY2_CDNS_40661956134326
* cell instance $21 m90 *1 50.755,4.06
X$21 27 19 9 10 nmos_4T_metal_stack
* cell instance $22 r0 *1 38.235,4.06
X$22 27 20 11 10 nmos_4T_metal_stack
* cell instance $23 r0 *1 26.495,4.06
X$23 28 21 12 14 nmos_4T_metal_stack
* cell instance $24 r0 *1 14.755,4.06
X$24 29 22 15 13 nmos_4T_metal_stack
* cell instance $25 r0 *1 3.015,4.06
X$25 30 23 17 16 nmos_4T_metal_stack
* cell instance $26 r0 *1 1.815,2.18
X$26 24 25 GR_NMOS_4T
* device instance $1 r0 *1 4.59,25.06 nmos_6p0_sab
M$1 16 1 17 18 nmos_6p0_sab L=1.15U W=38U AS=30.02P AD=156.18P PS=77.58U
+ PD=46.22U
* device instance $2 r0 *1 13.96,25.06 nmos_6p0_sab
M$2 15 6 16 18 nmos_6p0_sab L=1.15U W=38U AS=156.18P AD=23.18P PS=46.22U
+ PD=39.22U
* device instance $3 r0 *1 16.33,25.06 nmos_6p0_sab
M$3 13 7 15 18 nmos_6p0_sab L=1.15U W=38U AS=23.18P AD=156.18P PS=39.22U
+ PD=46.22U
* device instance $4 r0 *1 25.7,25.06 nmos_6p0_sab
M$4 12 8 13 18 nmos_6p0_sab L=1.15U W=38U AS=156.18P AD=23.18P PS=46.22U
+ PD=39.22U
* device instance $5 r0 *1 28.07,25.06 nmos_6p0_sab
M$5 14 3 12 18 nmos_6p0_sab L=1.15U W=38U AS=23.18P AD=156.18P PS=39.22U
+ PD=46.22U
* device instance $6 r0 *1 37.44,25.06 nmos_6p0_sab
M$6 11 4 14 18 nmos_6p0_sab L=1.15U W=38U AS=156.18P AD=23.18P PS=46.22U
+ PD=39.22U
* device instance $7 r0 *1 39.81,25.06 nmos_6p0_sab
M$7 10 5 11 18 nmos_6p0_sab L=1.15U W=38U AS=23.18P AD=156.18P PS=39.22U
+ PD=46.22U
* device instance $8 r0 *1 49.18,25.06 nmos_6p0_sab
M$8 9 2 10 18 nmos_6p0_sab L=1.15U W=38U AS=156.18P AD=30.02P PS=46.22U
+ PD=77.58U
.ENDS comp018green_out_paddrv_4T_NMOS_GROUP

* cell M2_M1_CDNS_40661956134305
* pin
* pin
.SUBCKT M2_M1_CDNS_40661956134305 1 2
.ENDS M2_M1_CDNS_40661956134305

* cell M3_M2_CDNS_40661956134362
* pin
* pin
.SUBCKT M3_M2_CDNS_40661956134362 1 2
.ENDS M3_M2_CDNS_40661956134362

* cell M1_PACTIVE_CDNS_40661956134353
* pin
* pin
.SUBCKT M1_PACTIVE_CDNS_40661956134353 1 2
.ENDS M1_PACTIVE_CDNS_40661956134353

* cell M3_M2_CDNS_40661956134373
* pin
* pin
.SUBCKT M3_M2_CDNS_40661956134373 1 2
.ENDS M3_M2_CDNS_40661956134373

* cell M2_M1_CDNS_40661956134365
* pin
* pin
.SUBCKT M2_M1_CDNS_40661956134365 1 2
.ENDS M2_M1_CDNS_40661956134365

* cell M2_M1_CDNS_40661956134374
* pin
* pin
.SUBCKT M2_M1_CDNS_40661956134374 1 2
.ENDS M2_M1_CDNS_40661956134374

* cell M1_NACTIVE_CDNS_40661956134346
* pin
* pin
.SUBCKT M1_NACTIVE_CDNS_40661956134346 1 2
.ENDS M1_NACTIVE_CDNS_40661956134346

* cell M1_PACTIVE_CDNS_40661956134355
* pin
* pin
.SUBCKT M1_PACTIVE_CDNS_40661956134355 1 2
.ENDS M1_PACTIVE_CDNS_40661956134355

* cell M2_M1_CDNS_40661956134360
* pin
* pin
.SUBCKT M2_M1_CDNS_40661956134360 1 2
.ENDS M2_M1_CDNS_40661956134360

* cell M2_M1_CDNS_40661956134361
* pin
* pin
.SUBCKT M2_M1_CDNS_40661956134361 1 2
.ENDS M2_M1_CDNS_40661956134361

* cell M2_M1_CDNS_40661956134287
* pin
* pin
.SUBCKT M2_M1_CDNS_40661956134287 1 2
.ENDS M2_M1_CDNS_40661956134287

* cell M3_M2_CDNS_40661956134372
* pin
* pin
.SUBCKT M3_M2_CDNS_40661956134372 1 2
.ENDS M3_M2_CDNS_40661956134372

* cell M3_M2_CDNS_40661956134366
* pin
* pin
.SUBCKT M3_M2_CDNS_40661956134366 1 2
.ENDS M3_M2_CDNS_40661956134366

* cell M1_NACTIVE_CDNS_40661956134358
* pin
* pin
.SUBCKT M1_NACTIVE_CDNS_40661956134358 1 2
.ENDS M1_NACTIVE_CDNS_40661956134358

* cell ppolyf_u_CDNS_4066195613425
* pin
* pin
* pin gf180mcu_gnd
.SUBCKT ppolyf_u_CDNS_4066195613425 1 2 3
* net 3 gf180mcu_gnd
* device instance $1 r0 *1 1.91,1.25 ppolyf_u
R$1 2 1 3 392 ppolyf_u L=2.8U W=2.5U
.ENDS ppolyf_u_CDNS_4066195613425

* cell M3_M2_CDNS_40661956134369
* pin
* pin
.SUBCKT M3_M2_CDNS_40661956134369 1 2
.ENDS M3_M2_CDNS_40661956134369

* cell M2_M1_CDNS_40661956134370
* pin
* pin
.SUBCKT M2_M1_CDNS_40661956134370 1 2
.ENDS M2_M1_CDNS_40661956134370

* cell M2_M1_CDNS_40661956134371
* pin
* pin
.SUBCKT M2_M1_CDNS_40661956134371 1 2
.ENDS M2_M1_CDNS_40661956134371

* cell M2_M1_CDNS_40661956134343
* pin
* pin
.SUBCKT M2_M1_CDNS_40661956134343 1 2
.ENDS M2_M1_CDNS_40661956134343

* cell M1_PACTIVE_CDNS_40661956134344
* pin
* pin
.SUBCKT M1_PACTIVE_CDNS_40661956134344 1 2
.ENDS M1_PACTIVE_CDNS_40661956134344

* cell M1_NACTIVE_CDNS_40661956134345
* pin
* pin
.SUBCKT M1_NACTIVE_CDNS_40661956134345 1 2
.ENDS M1_NACTIVE_CDNS_40661956134345

* cell M1_NACTIVE_CDNS_40661956134347
* pin
* pin
.SUBCKT M1_NACTIVE_CDNS_40661956134347 1 2
.ENDS M1_NACTIVE_CDNS_40661956134347

* cell M1_NACTIVE_CDNS_40661956134348
* pin
* pin
.SUBCKT M1_NACTIVE_CDNS_40661956134348 1 2
.ENDS M1_NACTIVE_CDNS_40661956134348

* cell M1_NACTIVE_CDNS_40661956134349
* pin
* pin
.SUBCKT M1_NACTIVE_CDNS_40661956134349 1 2
.ENDS M1_NACTIVE_CDNS_40661956134349

* cell M1_NACTIVE_CDNS_40661956134350
* pin
* pin
.SUBCKT M1_NACTIVE_CDNS_40661956134350 1 2
.ENDS M1_NACTIVE_CDNS_40661956134350

* cell M2_M1_CDNS_40661956134351
* pin
* pin
.SUBCKT M2_M1_CDNS_40661956134351 1 2
.ENDS M2_M1_CDNS_40661956134351

* cell M1_PACTIVE_CDNS_40661956134352
* pin
* pin
.SUBCKT M1_PACTIVE_CDNS_40661956134352 1 2
.ENDS M1_PACTIVE_CDNS_40661956134352

* cell M1_PACTIVE_CDNS_40661956134354
* pin
* pin
.SUBCKT M1_PACTIVE_CDNS_40661956134354 1 2
.ENDS M1_PACTIVE_CDNS_40661956134354

* cell M1_PACTIVE_CDNS_40661956134356
* pin
* pin
.SUBCKT M1_PACTIVE_CDNS_40661956134356 1 2
.ENDS M1_PACTIVE_CDNS_40661956134356

* cell M1_PACTIVE_CDNS_40661956134357
* pin
* pin
.SUBCKT M1_PACTIVE_CDNS_40661956134357 1 2
.ENDS M1_PACTIVE_CDNS_40661956134357

* cell M1_NACTIVE_CDNS_40661956134359
* pin
* pin
.SUBCKT M1_NACTIVE_CDNS_40661956134359 1 2
.ENDS M1_NACTIVE_CDNS_40661956134359

* cell M2_M1_CDNS_40661956134363
* pin
* pin
.SUBCKT M2_M1_CDNS_40661956134363 1 2
.ENDS M2_M1_CDNS_40661956134363

* cell M2_M1_CDNS_40661956134364
* pin
* pin
.SUBCKT M2_M1_CDNS_40661956134364 1 2
.ENDS M2_M1_CDNS_40661956134364

* cell M3_M2_CDNS_40661956134367
* pin
* pin
.SUBCKT M3_M2_CDNS_40661956134367 1 2
.ENDS M3_M2_CDNS_40661956134367

* cell np_6p0_CDNS_4066195613426
* pin
.SUBCKT np_6p0_CDNS_4066195613426 1
.ENDS np_6p0_CDNS_4066195613426

* cell pn_6p0_CDNS_4066195613427
* pin
* pin
* pin
.SUBCKT pn_6p0_CDNS_4066195613427 1 3 4
.ENDS pn_6p0_CDNS_4066195613427

* cell M1_PSUB_CDNS_40661956134192
* pin
* pin
.SUBCKT M1_PSUB_CDNS_40661956134192 1 2
.ENDS M1_PSUB_CDNS_40661956134192

* cell M1_PSUB_CDNS_40661956134176
* pin
* pin
.SUBCKT M1_PSUB_CDNS_40661956134176 1 2
.ENDS M1_PSUB_CDNS_40661956134176

* cell M3_M2_CDNS_40661956134157
* pin
* pin
.SUBCKT M3_M2_CDNS_40661956134157 1 2
.ENDS M3_M2_CDNS_40661956134157

* cell M3_M2_CDNS_40661956134158
* pin
* pin
.SUBCKT M3_M2_CDNS_40661956134158 1 2
.ENDS M3_M2_CDNS_40661956134158

* cell M3_M2_CDNS_40661956134159
* pin
* pin
.SUBCKT M3_M2_CDNS_40661956134159 1 2
.ENDS M3_M2_CDNS_40661956134159

* cell M3_M2_CDNS_40661956134160
* pin
* pin
.SUBCKT M3_M2_CDNS_40661956134160 1 2
.ENDS M3_M2_CDNS_40661956134160

* cell M3_M2_CDNS_40661956134161
* pin
* pin
.SUBCKT M3_M2_CDNS_40661956134161 1 2
.ENDS M3_M2_CDNS_40661956134161

* cell M3_M2_CDNS_40661956134162
* pin
* pin
.SUBCKT M3_M2_CDNS_40661956134162 1 2
.ENDS M3_M2_CDNS_40661956134162

* cell M3_M2_CDNS_40661956134163
* pin
* pin
.SUBCKT M3_M2_CDNS_40661956134163 1 2
.ENDS M3_M2_CDNS_40661956134163

* cell M3_M2_CDNS_40661956134164
* pin
* pin
.SUBCKT M3_M2_CDNS_40661956134164 1 2
.ENDS M3_M2_CDNS_40661956134164

* cell M3_M2_CDNS_40661956134165
* pin
* pin
.SUBCKT M3_M2_CDNS_40661956134165 1 2
.ENDS M3_M2_CDNS_40661956134165

* cell M3_M2_CDNS_40661956134155
* pin
* pin
.SUBCKT M3_M2_CDNS_40661956134155 1 2
.ENDS M3_M2_CDNS_40661956134155

* cell M3_M2_CDNS_40661956134112
* pin
* pin
.SUBCKT M3_M2_CDNS_40661956134112 1 2
.ENDS M3_M2_CDNS_40661956134112

* cell M3_M2_CDNS_40661956134113
* pin
* pin
.SUBCKT M3_M2_CDNS_40661956134113 1 2
.ENDS M3_M2_CDNS_40661956134113

* cell M3_M2_CDNS_40661956134116
* pin
* pin
.SUBCKT M3_M2_CDNS_40661956134116 1 2
.ENDS M3_M2_CDNS_40661956134116

* cell M3_M2_CDNS_40661956134117
* pin
* pin
.SUBCKT M3_M2_CDNS_40661956134117 1 2
.ENDS M3_M2_CDNS_40661956134117

* cell M3_M2_CDNS_40661956134118
* pin
* pin
.SUBCKT M3_M2_CDNS_40661956134118 1 2
.ENDS M3_M2_CDNS_40661956134118

* cell M3_M2_CDNS_40661956134120
* pin
* pin
.SUBCKT M3_M2_CDNS_40661956134120 1 2
.ENDS M3_M2_CDNS_40661956134120

* cell M3_M2_CDNS_40661956134121
* pin
* pin
.SUBCKT M3_M2_CDNS_40661956134121 1 2
.ENDS M3_M2_CDNS_40661956134121

* cell M3_M2_CDNS_40661956134122
* pin
* pin
.SUBCKT M3_M2_CDNS_40661956134122 1 2
.ENDS M3_M2_CDNS_40661956134122

* cell M3_M2_CDNS_40661956134123
* pin
* pin
.SUBCKT M3_M2_CDNS_40661956134123 1 2
.ENDS M3_M2_CDNS_40661956134123

* cell M3_M2_CDNS_40661956134124
* pin
* pin
.SUBCKT M3_M2_CDNS_40661956134124 1 2
.ENDS M3_M2_CDNS_40661956134124

* cell M2_M1_CDNS_40661956134248
* pin
* pin
.SUBCKT M2_M1_CDNS_40661956134248 1 2
.ENDS M2_M1_CDNS_40661956134248

* cell M2_M1_CDNS_40661956134246
* pin
* pin
.SUBCKT M2_M1_CDNS_40661956134246 1 2
.ENDS M2_M1_CDNS_40661956134246

* cell M3_M2_CDNS_40661956134156
* pin
* pin
.SUBCKT M3_M2_CDNS_40661956134156 1 2
.ENDS M3_M2_CDNS_40661956134156

* cell M3_M2_CDNS_40661956134114
* pin
* pin
.SUBCKT M3_M2_CDNS_40661956134114 1 2
.ENDS M3_M2_CDNS_40661956134114

* cell M2_M1_CDNS_40661956134115
* pin
* pin
.SUBCKT M2_M1_CDNS_40661956134115 1 2
.ENDS M2_M1_CDNS_40661956134115

* cell M3_M2_CDNS_40661956134119
* pin
* pin
.SUBCKT M3_M2_CDNS_40661956134119 1 2
.ENDS M3_M2_CDNS_40661956134119

* cell M2_M1_CDNS_40661956134250
* pin
* pin
.SUBCKT M2_M1_CDNS_40661956134250 1 2
.ENDS M2_M1_CDNS_40661956134250

* cell M2_M1_CDNS_40661956134247
* pin
* pin
.SUBCKT M2_M1_CDNS_40661956134247 1 2
.ENDS M2_M1_CDNS_40661956134247

* cell M2_M1_CDNS_40661956134249
* pin
* pin
.SUBCKT M2_M1_CDNS_40661956134249 1 2
.ENDS M2_M1_CDNS_40661956134249

* cell M2_M1_CDNS_40661956134206
* pin
* pin
.SUBCKT M2_M1_CDNS_40661956134206 1 2
.ENDS M2_M1_CDNS_40661956134206

* cell M2_M1_CDNS_40661956134268
* pin
* pin
.SUBCKT M2_M1_CDNS_40661956134268 1 2
.ENDS M2_M1_CDNS_40661956134268

* cell M2_M1_CDNS_40661956134207
* pin
* pin
.SUBCKT M2_M1_CDNS_40661956134207 1 2
.ENDS M2_M1_CDNS_40661956134207

* cell M2_M1_CDNS_40661956134217
* pin
* pin
.SUBCKT M2_M1_CDNS_40661956134217 1 2
.ENDS M2_M1_CDNS_40661956134217

* cell M2_M1_CDNS_40661956134218
* pin
* pin
.SUBCKT M2_M1_CDNS_40661956134218 1 2
.ENDS M2_M1_CDNS_40661956134218

* cell M2_M1_CDNS_40661956134255
* pin
* pin
.SUBCKT M2_M1_CDNS_40661956134255 1 2
.ENDS M2_M1_CDNS_40661956134255

* cell top_route_1
* pin
* pin
* pin
* pin
* pin
* pin
* pin
* pin
* pin
* pin
* pin
.SUBCKT top_route_1 1 2 3 4 5 6 7 8 9 10 11
* cell instance $1 r0 *1 43.43,1.03
X$1 1 7 M2_M1_CDNS_40661956134152
* cell instance $2 r0 *1 61.625,1.03
X$2 1 9 M2_M1_CDNS_40661956134147
* cell instance $3 r0 *1 42.98,50.225
X$3 1 7 M2_M1_CDNS_40661956134150
* cell instance $4 r0 *1 42.98,19.77
X$4 1 7 M2_M1_CDNS_40661956134143
* cell instance $5 r0 *1 42.98,80.19
X$5 1 7 M2_M1_CDNS_40661956134143
* cell instance $6 r0 *1 3.04,17.43
X$6 11 2 M2_M1_CDNS_40661956134149
* cell instance $7 r0 *1 3.035,82.645
X$7 11 2 M2_M1_CDNS_40661956134166
* cell instance $8 r0 *1 11.76,50.225
X$8 10 3 M2_M1_CDNS_40661956134150
* cell instance $9 r0 *1 11.76,1.03
X$9 10 3 M2_M1_CDNS_40661956134143
* cell instance $10 r0 *1 11.76,80.19
X$10 10 3 M2_M1_CDNS_40661956134143
* cell instance $11 r0 *1 11.76,19.77
X$11 10 3 M2_M1_CDNS_40661956134143
* cell instance $12 r0 *1 21.4,17.43
X$12 11 4 M2_M1_CDNS_40661956134143
* cell instance $13 r0 *1 29.205,50.225
X$13 10 5 M2_M1_CDNS_40661956134151
* cell instance $14 r0 *1 29.205,80.19
X$14 10 5 M2_M1_CDNS_40661956134147
* cell instance $15 r0 *1 29.205,1.03
X$15 10 5 M2_M1_CDNS_40661956134147
* cell instance $16 r0 *1 29.205,19.77
X$16 10 5 M2_M1_CDNS_40661956134147
* cell instance $17 r0 *1 35.175,17.43
X$17 11 6 M2_M1_CDNS_40661956134147
* cell instance $18 r0 *1 52.62,17.43
X$18 11 8 M2_M1_CDNS_40661956134143
.ENDS top_route_1

* cell comp018green_esd_rc_v5p0
* pin VPLUS
* pin VRC
* pin VMINUS
* pin gf180mcu_gnd
.SUBCKT comp018green_esd_rc_v5p0 1 15 16 18
* net 1 VPLUS
* net 15 VRC
* net 16 VMINUS
* net 18 gf180mcu_gnd
* cell instance $1 m135 *1 34.185,3.095
X$1 1 10 1 11 M1_NWELL_CDNS_40661956134153
* cell instance $2 m0 *1 0.385,12.445
X$2 1 11 10 1 M1_NWELL_CDNS_40661956134154
* cell instance $3 m0 *1 1.765,5.145
X$3 4 1 18 ppolyf_u_CDNS_406619561345
* cell instance $4 m0 *1 67.985,12.445
X$4 1 11 10 1 M1_NWELL_CDNS_40661956134154
* cell instance $5 m90 *1 66.64,8.545
X$5 2 5 18 ppolyf_u_CDNS_406619561345
* cell instance $6 r0 *1 1.765,9.945
X$6 8 2 18 ppolyf_u_CDNS_406619561345
* cell instance $7 m90 *1 66.64,5.745
X$7 3 4 18 ppolyf_u_CDNS_406619561345
* cell instance $8 r0 *1 1.765,7.145
X$8 5 3 18 ppolyf_u_CDNS_406619561345
* cell instance $9 m90 *1 66.64,14.145
X$9 6 9 18 ppolyf_u_CDNS_406619561345
* cell instance $10 r0 *1 1.765,15.545
X$10 12 6 18 ppolyf_u_CDNS_406619561345
* cell instance $11 m90 *1 66.64,11.345
X$11 7 8 18 ppolyf_u_CDNS_406619561345
* cell instance $12 r0 *1 1.765,12.745
X$12 9 7 18 ppolyf_u_CDNS_406619561345
* cell instance $13 m90 *1 66.64,16.945
X$13 14 12 18 ppolyf_u_CDNS_406619561345
* cell instance $14 r0 *1 1.765,18.345
X$14 13 14 18 ppolyf_u_CDNS_406619561345
* cell instance $15 m90 *1 66.64,19.745
X$15 15 13 18 ppolyf_u_CDNS_406619561345
* cell instance $16 r0 *1 10.9,56.755
X$16 16 15 nmoscap_6p0_CDNS_406619561340
* cell instance $17 m0 *1 23.08,51.695
X$17 16 15 nmoscap_6p0_CDNS_406619561340
* cell instance $18 m0 *1 10.9,51.695
X$18 16 15 nmoscap_6p0_CDNS_406619561340
* cell instance $19 m0 *1 47.44,51.695
X$19 16 15 nmoscap_6p0_CDNS_406619561340
* cell instance $20 m0 *1 35.26,51.695
X$20 16 15 nmoscap_6p0_CDNS_406619561340
* cell instance $21 r0 *1 47.44,56.755
X$21 16 15 nmoscap_6p0_CDNS_406619561340
* cell instance $22 r0 *1 35.26,56.755
X$22 16 15 nmoscap_6p0_CDNS_406619561340
* cell instance $23 r0 *1 23.08,56.755
X$23 16 15 nmoscap_6p0_CDNS_406619561340
* cell instance $24 r0 *1 60.035,54.47
X$24 16 17 M1_PSUB_CDNS_406619561349
* cell instance $25 r90 *1 34.185,54.225
X$25 16 17 M1_PSUB_CDNS_4066195613411
* cell instance $26 r90 *1 34.185,84.68
X$26 16 17 M1_PSUB_CDNS_4066195613411
* cell instance $27 r90 *1 34.185,24.26
X$27 16 17 M1_PSUB_CDNS_4066195613411
.ENDS comp018green_esd_rc_v5p0

* cell top_route
* pin
* pin
* pin
* pin
* pin
* pin
* pin
* pin
* pin
* pin
* pin
.SUBCKT top_route 1 2 3 4 5 6 7 8 9 10 11
* cell instance $1 r0 *1 21.4,17.43
X$1 6 1 M2_M1_CDNS_40661956134143
* cell instance $2 r0 *1 29.205,1.03
X$2 7 2 M2_M1_CDNS_40661956134147
* cell instance $3 r0 *1 29.205,19.77
X$3 7 2 M2_M1_CDNS_40661956134147
* cell instance $4 r0 *1 29.205,80.19
X$4 7 2 M2_M1_CDNS_40661956134147
* cell instance $5 r0 *1 29.205,50.225
X$5 7 2 M2_M1_CDNS_40661956134151
* cell instance $6 r0 *1 52.62,17.43
X$6 6 3 M2_M1_CDNS_40661956134143
* cell instance $7 r0 *1 61.625,1.03
X$7 5 4 M2_M1_CDNS_40661956134147
* cell instance $8 r0 *1 42.98,50.225
X$8 5 11 M2_M1_CDNS_40661956134150
* cell instance $9 r0 *1 42.98,19.77
X$9 5 11 M2_M1_CDNS_40661956134143
* cell instance $10 r0 *1 42.98,80.19
X$10 5 11 M2_M1_CDNS_40661956134143
* cell instance $11 r0 *1 43.43,1.03
X$11 5 11 M2_M1_CDNS_40661956134152
* cell instance $12 r0 *1 3.04,17.43
X$12 6 8 M2_M1_CDNS_40661956134149
* cell instance $13 r0 *1 2.755,83.74
X$13 6 8 M2_M1_CDNS_40661956134147
* cell instance $14 r0 *1 35.175,17.43
X$14 6 10 M2_M1_CDNS_40661956134147
* cell instance $15 r0 *1 11.76,50.225
X$15 7 9 M2_M1_CDNS_40661956134150
* cell instance $16 r0 *1 11.76,1.03
X$16 7 9 M2_M1_CDNS_40661956134143
* cell instance $17 r0 *1 11.76,19.77
X$17 7 9 M2_M1_CDNS_40661956134143
* cell instance $18 r0 *1 11.76,80.19
X$18 7 9 M2_M1_CDNS_40661956134143
.ENDS top_route

* cell comp018green_esd_rc_v5p0_1
* pin VPLUS
* pin VRC
* pin VMINUS
* pin gf180mcu_gnd
.SUBCKT comp018green_esd_rc_v5p0_1 2 4 10 18
* net 2 VPLUS
* net 4 VRC
* net 10 VMINUS
* net 18 gf180mcu_gnd
* cell instance $1 r180 *1 -18.52,54.045
X$1 2 1 2 3 M1_NWELL_CDNS_40661956134153
* cell instance $2 r90 *1 -9.17,20.245
X$2 2 3 1 2 M1_NWELL_CDNS_40661956134154
* cell instance $3 r90 *1 -9.17,87.845
X$3 2 3 1 2 M1_NWELL_CDNS_40661956134154
* cell instance $4 r90 *1 -16.47,21.625
X$4 12 2 18 ppolyf_u_CDNS_406619561345
* cell instance $5 m0 *1 23.08,51.695
X$5 10 4 nmoscap_6p0_CDNS_406619561340
* cell instance $6 m0 *1 10.9,51.695
X$6 10 4 nmoscap_6p0_CDNS_406619561340
* cell instance $7 m0 *1 47.44,51.695
X$7 10 4 nmoscap_6p0_CDNS_406619561340
* cell instance $8 m0 *1 35.26,51.695
X$8 10 4 nmoscap_6p0_CDNS_406619561340
* cell instance $9 r0 *1 47.44,56.755
X$9 10 4 nmoscap_6p0_CDNS_406619561340
* cell instance $10 r0 *1 35.26,56.755
X$10 10 4 nmoscap_6p0_CDNS_406619561340
* cell instance $11 r0 *1 23.08,56.755
X$11 10 4 nmoscap_6p0_CDNS_406619561340
* cell instance $12 r0 *1 10.9,56.755
X$12 10 4 nmoscap_6p0_CDNS_406619561340
* cell instance $13 r270 *1 -1.87,86.5
X$13 4 17 18 ppolyf_u_CDNS_406619561345
* cell instance $14 r270 *1 -4.67,86.5
X$14 5 15 18 ppolyf_u_CDNS_406619561345
* cell instance $15 m45 *1 -3.27,21.625
X$15 17 5 18 ppolyf_u_CDNS_406619561345
* cell instance $16 r270 *1 -7.47,86.5
X$16 6 16 18 ppolyf_u_CDNS_406619561345
* cell instance $17 m45 *1 -6.07,21.625
X$17 15 6 18 ppolyf_u_CDNS_406619561345
* cell instance $18 r270 *1 -10.27,86.5
X$18 7 13 18 ppolyf_u_CDNS_406619561345
* cell instance $19 m45 *1 -8.87,21.625
X$19 16 7 18 ppolyf_u_CDNS_406619561345
* cell instance $20 r270 *1 -13.07,86.5
X$20 8 14 18 ppolyf_u_CDNS_406619561345
* cell instance $21 m45 *1 -11.67,21.625
X$21 13 8 18 ppolyf_u_CDNS_406619561345
* cell instance $22 r270 *1 -15.87,86.5
X$22 9 12 18 ppolyf_u_CDNS_406619561345
* cell instance $23 m45 *1 -14.47,21.625
X$23 14 9 18 ppolyf_u_CDNS_406619561345
* cell instance $24 r90 *1 34.185,84.68
X$24 10 11 M1_PSUB_CDNS_4066195613411
* cell instance $25 r90 *1 34.185,24.26
X$25 10 11 M1_PSUB_CDNS_4066195613411
* cell instance $26 r90 *1 34.185,54.225
X$26 10 11 M1_PSUB_CDNS_4066195613411
* cell instance $27 r0 *1 60.035,54.47
X$27 10 11 M1_PSUB_CDNS_406619561349
.ENDS comp018green_esd_rc_v5p0_1

* cell nmos_clamp_20_50_4
* pin
* pin
* pin
* pin
* pin
* pin
* pin
* pin
* pin
* pin
* pin
* pin
* pin
* pin gf180mcu_gnd
.SUBCKT nmos_clamp_20_50_4 1 3 5 6 7 8 9 10 11 12 13 14 15 16
* net 16 gf180mcu_gnd
* cell instance $1 r90 *1 57.405,7.405
X$1 3 5 3 5 3 5 3 5 3 5 3 5 3 5 3 5 3 5 3 5 3 1 1 1 1 1 1 1 1 1 1 1 1 1 1 1 1 1
+ 1 1 1 16 nmos_6p0_CDNS_406619561341
* cell instance $2 r90 *1 57.405,36.765
X$2 3 5 3 5 3 5 3 5 3 5 3 5 3 5 3 5 3 5 3 5 3 1 1 1 1 1 1 1 1 1 1 1 1 1 1 1 1 1
+ 1 1 1 16 nmos_6p0_CDNS_406619561341
* cell instance $3 r90 *1 57.405,66.125
X$3 3 5 3 5 3 5 3 5 3 5 3 5 3 5 3 5 3 5 3 5 3 1 1 1 1 1 1 1 1 1 1 1 1 1 1 1 1 1
+ 1 1 1 16 nmos_6p0_CDNS_406619561341
* cell instance $4 r90 *1 57.405,95.485
X$4 3 5 3 5 3 5 3 5 3 5 3 5 3 5 3 5 3 5 3 5 3 1 1 1 1 1 1 1 1 1 1 1 1 1 1 1 1 1
+ 1 1 1 16 nmos_6p0_CDNS_406619561341
* cell instance $5 r0 *1 6.645,19.345
X$5 1 M1_POLY2_CDNS_40661956134136
* cell instance $6 r0 *1 6.565,19.345
X$6 1 7 M2_M1_CDNS_40661956134141
* cell instance $7 r0 *1 58.245,107.425
X$7 1 13 M2_M1_CDNS_40661956134141
* cell instance $8 m90 *1 58.165,107.425
X$8 1 M1_POLY2_CDNS_40661956134136
* cell instance $9 r0 *1 58.245,78.065
X$9 1 13 M2_M1_CDNS_40661956134141
* cell instance $10 m90 *1 58.165,78.065
X$10 1 M1_POLY2_CDNS_40661956134136
* cell instance $11 r0 *1 58.245,19.345
X$11 1 13 M2_M1_CDNS_40661956134141
* cell instance $12 m90 *1 58.165,19.345
X$12 1 M1_POLY2_CDNS_40661956134136
* cell instance $13 r0 *1 58.245,48.705
X$13 1 13 M2_M1_CDNS_40661956134141
* cell instance $14 m90 *1 58.165,48.705
X$14 1 M1_POLY2_CDNS_40661956134136
* cell instance $15 r0 *1 6.645,107.425
X$15 1 M1_POLY2_CDNS_40661956134136
* cell instance $16 r0 *1 6.565,107.425
X$16 1 7 M2_M1_CDNS_40661956134141
* cell instance $17 r0 *1 6.645,48.705
X$17 1 M1_POLY2_CDNS_40661956134136
* cell instance $18 r0 *1 6.565,48.705
X$18 1 7 M2_M1_CDNS_40661956134141
* cell instance $19 r0 *1 6.645,78.065
X$19 1 M1_POLY2_CDNS_40661956134136
* cell instance $20 r0 *1 6.565,78.065
X$20 1 7 M2_M1_CDNS_40661956134141
* cell instance $21 r0 *1 1.135,63.385
X$21 3 2 3 17 M1_NWELL_CDNS_40661956134135
* cell instance $22 r0 *1 32.405,1.135
X$22 3 3 17 2 M1_NWELL_CDNS_40661956134139
* cell instance $23 r0 *1 32.405,125.635
X$23 3 3 17 2 M1_NWELL_CDNS_40661956134139
* cell instance $24 r0 *1 63.675,63.385
X$24 3 2 3 17 M1_NWELL_CDNS_40661956134135
* cell instance $25 r0 *1 21.615,7.145
X$25 3 10 M2_M1_CDNS_40661956134140
* cell instance $26 r0 *1 35.39,7.145
X$26 3 11 M2_M1_CDNS_40661956134142
* cell instance $27 r0 *1 52.835,7.145
X$27 3 14 M2_M1_CDNS_40661956134140
* cell instance $28 r0 *1 21.615,80.505
X$28 3 10 M2_M1_CDNS_40661956134140
* cell instance $29 r0 *1 35.39,80.505
X$29 3 11 M2_M1_CDNS_40661956134142
* cell instance $30 r0 *1 52.835,80.505
X$30 3 14 M2_M1_CDNS_40661956134140
* cell instance $31 r0 *1 21.615,68.305
X$31 3 10 M2_M1_CDNS_40661956134140
* cell instance $32 r0 *1 35.39,68.305
X$32 3 11 M2_M1_CDNS_40661956134142
* cell instance $33 r0 *1 52.835,68.305
X$33 3 14 M2_M1_CDNS_40661956134140
* cell instance $34 r0 *1 21.615,95.225
X$34 3 10 M2_M1_CDNS_40661956134140
* cell instance $35 r0 *1 35.39,95.225
X$35 3 11 M2_M1_CDNS_40661956134142
* cell instance $36 r0 *1 52.835,95.225
X$36 3 14 M2_M1_CDNS_40661956134140
* cell instance $37 r0 *1 21.615,65.865
X$37 3 10 M2_M1_CDNS_40661956134140
* cell instance $38 r0 *1 35.39,65.865
X$38 3 11 M2_M1_CDNS_40661956134142
* cell instance $39 r0 *1 52.835,65.865
X$39 3 14 M2_M1_CDNS_40661956134140
* cell instance $40 r0 *1 21.615,70.745
X$40 3 10 M2_M1_CDNS_40661956134140
* cell instance $41 r0 *1 35.39,70.745
X$41 3 11 M2_M1_CDNS_40661956134142
* cell instance $42 r0 *1 52.835,70.745
X$42 3 14 M2_M1_CDNS_40661956134140
* cell instance $43 r0 *1 21.615,73.185
X$43 3 10 M2_M1_CDNS_40661956134140
* cell instance $44 r0 *1 35.39,73.185
X$44 3 11 M2_M1_CDNS_40661956134142
* cell instance $45 r0 *1 52.835,73.185
X$45 3 14 M2_M1_CDNS_40661956134140
* cell instance $46 r0 *1 21.615,78.065
X$46 3 10 M2_M1_CDNS_40661956134140
* cell instance $47 r0 *1 35.39,78.065
X$47 3 11 M2_M1_CDNS_40661956134142
* cell instance $48 r0 *1 52.835,78.065
X$48 3 14 M2_M1_CDNS_40661956134140
* cell instance $49 r0 *1 21.615,75.625
X$49 3 10 M2_M1_CDNS_40661956134140
* cell instance $50 r0 *1 35.39,75.625
X$50 3 11 M2_M1_CDNS_40661956134142
* cell instance $51 r0 *1 52.835,75.625
X$51 3 14 M2_M1_CDNS_40661956134140
* cell instance $52 r0 *1 21.615,119.625
X$52 3 10 M2_M1_CDNS_40661956134140
* cell instance $53 r0 *1 35.39,119.625
X$53 3 11 M2_M1_CDNS_40661956134142
* cell instance $54 r0 *1 52.835,119.625
X$54 3 14 M2_M1_CDNS_40661956134140
* cell instance $55 r0 *1 21.615,117.185
X$55 3 10 M2_M1_CDNS_40661956134140
* cell instance $56 r0 *1 35.39,117.185
X$56 3 11 M2_M1_CDNS_40661956134142
* cell instance $57 r0 *1 52.835,117.185
X$57 3 14 M2_M1_CDNS_40661956134140
* cell instance $58 r0 *1 21.615,114.745
X$58 3 10 M2_M1_CDNS_40661956134140
* cell instance $59 r0 *1 35.39,114.745
X$59 3 11 M2_M1_CDNS_40661956134142
* cell instance $60 r0 *1 52.835,114.745
X$60 3 14 M2_M1_CDNS_40661956134140
* cell instance $61 r0 *1 21.615,112.305
X$61 3 10 M2_M1_CDNS_40661956134140
* cell instance $62 r0 *1 35.39,112.305
X$62 3 11 M2_M1_CDNS_40661956134142
* cell instance $63 r0 *1 52.835,112.305
X$63 3 14 M2_M1_CDNS_40661956134140
* cell instance $64 r0 *1 21.615,26.665
X$64 3 10 M2_M1_CDNS_40661956134140
* cell instance $65 r0 *1 35.39,26.665
X$65 3 11 M2_M1_CDNS_40661956134142
* cell instance $66 r0 *1 52.835,26.665
X$66 3 14 M2_M1_CDNS_40661956134140
* cell instance $67 r0 *1 21.615,24.225
X$67 3 10 M2_M1_CDNS_40661956134140
* cell instance $68 r0 *1 35.39,24.225
X$68 3 11 M2_M1_CDNS_40661956134142
* cell instance $69 r0 *1 52.835,24.225
X$69 3 14 M2_M1_CDNS_40661956134140
* cell instance $70 r0 *1 21.615,21.785
X$70 3 10 M2_M1_CDNS_40661956134140
* cell instance $71 r0 *1 35.39,21.785
X$71 3 11 M2_M1_CDNS_40661956134142
* cell instance $72 r0 *1 52.835,21.785
X$72 3 14 M2_M1_CDNS_40661956134140
* cell instance $73 r0 *1 21.615,19.345
X$73 3 10 M2_M1_CDNS_40661956134140
* cell instance $74 r0 *1 35.39,19.345
X$74 3 11 M2_M1_CDNS_40661956134142
* cell instance $75 r0 *1 52.835,19.345
X$75 3 14 M2_M1_CDNS_40661956134140
* cell instance $76 r0 *1 21.615,16.905
X$76 3 10 M2_M1_CDNS_40661956134140
* cell instance $77 r0 *1 35.39,16.905
X$77 3 11 M2_M1_CDNS_40661956134142
* cell instance $78 r0 *1 52.835,16.905
X$78 3 14 M2_M1_CDNS_40661956134140
* cell instance $79 r0 *1 21.615,14.465
X$79 3 10 M2_M1_CDNS_40661956134140
* cell instance $80 r0 *1 35.39,14.465
X$80 3 11 M2_M1_CDNS_40661956134142
* cell instance $81 r0 *1 52.835,14.465
X$81 3 14 M2_M1_CDNS_40661956134140
* cell instance $82 r0 *1 21.615,12.025
X$82 3 10 M2_M1_CDNS_40661956134140
* cell instance $83 r0 *1 35.39,12.025
X$83 3 11 M2_M1_CDNS_40661956134142
* cell instance $84 r0 *1 52.835,12.025
X$84 3 14 M2_M1_CDNS_40661956134140
* cell instance $85 r0 *1 21.615,9.585
X$85 3 10 M2_M1_CDNS_40661956134140
* cell instance $86 r0 *1 35.39,9.585
X$86 3 11 M2_M1_CDNS_40661956134142
* cell instance $87 r0 *1 52.835,9.585
X$87 3 14 M2_M1_CDNS_40661956134140
* cell instance $88 r0 *1 21.615,29.105
X$88 3 10 M2_M1_CDNS_40661956134140
* cell instance $89 r0 *1 35.39,29.105
X$89 3 11 M2_M1_CDNS_40661956134142
* cell instance $90 r0 *1 52.835,29.105
X$90 3 14 M2_M1_CDNS_40661956134140
* cell instance $91 r0 *1 21.615,31.545
X$91 3 10 M2_M1_CDNS_40661956134140
* cell instance $92 r0 *1 35.39,31.545
X$92 3 11 M2_M1_CDNS_40661956134142
* cell instance $93 r0 *1 52.835,31.545
X$93 3 14 M2_M1_CDNS_40661956134140
* cell instance $94 r0 *1 21.615,109.865
X$94 3 10 M2_M1_CDNS_40661956134140
* cell instance $95 r0 *1 35.39,109.865
X$95 3 11 M2_M1_CDNS_40661956134142
* cell instance $96 r0 *1 52.835,109.865
X$96 3 14 M2_M1_CDNS_40661956134140
* cell instance $97 r0 *1 21.615,107.425
X$97 3 10 M2_M1_CDNS_40661956134140
* cell instance $98 r0 *1 35.39,107.425
X$98 3 11 M2_M1_CDNS_40661956134142
* cell instance $99 r0 *1 52.835,107.425
X$99 3 14 M2_M1_CDNS_40661956134140
* cell instance $100 r0 *1 21.615,102.545
X$100 3 10 M2_M1_CDNS_40661956134140
* cell instance $101 r0 *1 35.39,102.545
X$101 3 11 M2_M1_CDNS_40661956134142
* cell instance $102 r0 *1 52.835,102.545
X$102 3 14 M2_M1_CDNS_40661956134140
* cell instance $103 r0 *1 21.615,100.105
X$103 3 10 M2_M1_CDNS_40661956134140
* cell instance $104 r0 *1 35.39,100.105
X$104 3 11 M2_M1_CDNS_40661956134142
* cell instance $105 r0 *1 52.835,100.105
X$105 3 14 M2_M1_CDNS_40661956134140
* cell instance $106 r0 *1 21.615,97.665
X$106 3 10 M2_M1_CDNS_40661956134140
* cell instance $107 r0 *1 35.39,97.665
X$107 3 11 M2_M1_CDNS_40661956134142
* cell instance $108 r0 *1 52.835,97.665
X$108 3 14 M2_M1_CDNS_40661956134140
* cell instance $109 r0 *1 21.615,90.265
X$109 3 10 M2_M1_CDNS_40661956134140
* cell instance $110 r0 *1 35.39,90.265
X$110 3 11 M2_M1_CDNS_40661956134142
* cell instance $111 r0 *1 52.835,90.265
X$111 3 14 M2_M1_CDNS_40661956134140
* cell instance $112 r0 *1 21.615,87.825
X$112 3 10 M2_M1_CDNS_40661956134140
* cell instance $113 r0 *1 35.39,87.825
X$113 3 11 M2_M1_CDNS_40661956134142
* cell instance $114 r0 *1 52.835,87.825
X$114 3 14 M2_M1_CDNS_40661956134140
* cell instance $115 r0 *1 21.615,85.385
X$115 3 10 M2_M1_CDNS_40661956134140
* cell instance $116 r0 *1 35.39,85.385
X$116 3 11 M2_M1_CDNS_40661956134142
* cell instance $117 r0 *1 52.835,85.385
X$117 3 14 M2_M1_CDNS_40661956134140
* cell instance $118 r0 *1 21.615,104.985
X$118 3 10 M2_M1_CDNS_40661956134140
* cell instance $119 r0 *1 35.39,104.985
X$119 3 11 M2_M1_CDNS_40661956134142
* cell instance $120 r0 *1 52.835,104.985
X$120 3 14 M2_M1_CDNS_40661956134140
* cell instance $121 r0 *1 21.615,82.945
X$121 3 10 M2_M1_CDNS_40661956134140
* cell instance $122 r0 *1 35.39,82.945
X$122 3 11 M2_M1_CDNS_40661956134142
* cell instance $123 r0 *1 52.835,82.945
X$123 3 14 M2_M1_CDNS_40661956134140
* cell instance $124 r0 *1 21.615,58.465
X$124 3 10 M2_M1_CDNS_40661956134140
* cell instance $125 r0 *1 35.39,58.465
X$125 3 11 M2_M1_CDNS_40661956134142
* cell instance $126 r0 *1 52.835,58.465
X$126 3 14 M2_M1_CDNS_40661956134140
* cell instance $127 r0 *1 21.615,56.025
X$127 3 10 M2_M1_CDNS_40661956134140
* cell instance $128 r0 *1 35.39,56.025
X$128 3 11 M2_M1_CDNS_40661956134142
* cell instance $129 r0 *1 52.835,56.025
X$129 3 14 M2_M1_CDNS_40661956134140
* cell instance $130 r0 *1 21.615,53.585
X$130 3 10 M2_M1_CDNS_40661956134140
* cell instance $131 r0 *1 35.39,53.585
X$131 3 11 M2_M1_CDNS_40661956134142
* cell instance $132 r0 *1 52.835,53.585
X$132 3 14 M2_M1_CDNS_40661956134140
* cell instance $133 r0 *1 21.615,51.145
X$133 3 10 M2_M1_CDNS_40661956134140
* cell instance $134 r0 *1 35.39,51.145
X$134 3 11 M2_M1_CDNS_40661956134142
* cell instance $135 r0 *1 52.835,51.145
X$135 3 14 M2_M1_CDNS_40661956134140
* cell instance $136 r0 *1 21.615,48.705
X$136 3 10 M2_M1_CDNS_40661956134140
* cell instance $137 r0 *1 35.39,48.705
X$137 3 11 M2_M1_CDNS_40661956134142
* cell instance $138 r0 *1 52.835,48.705
X$138 3 14 M2_M1_CDNS_40661956134140
* cell instance $139 r0 *1 21.615,46.265
X$139 3 10 M2_M1_CDNS_40661956134140
* cell instance $140 r0 *1 35.39,46.265
X$140 3 11 M2_M1_CDNS_40661956134142
* cell instance $141 r0 *1 52.835,46.265
X$141 3 14 M2_M1_CDNS_40661956134140
* cell instance $142 r0 *1 21.615,43.825
X$142 3 10 M2_M1_CDNS_40661956134140
* cell instance $143 r0 *1 35.39,43.825
X$143 3 11 M2_M1_CDNS_40661956134142
* cell instance $144 r0 *1 52.835,43.825
X$144 3 14 M2_M1_CDNS_40661956134140
* cell instance $145 r0 *1 21.615,41.385
X$145 3 10 M2_M1_CDNS_40661956134140
* cell instance $146 r0 *1 35.39,41.385
X$146 3 11 M2_M1_CDNS_40661956134142
* cell instance $147 r0 *1 52.835,41.385
X$147 3 14 M2_M1_CDNS_40661956134140
* cell instance $148 r0 *1 21.615,38.945
X$148 3 10 M2_M1_CDNS_40661956134140
* cell instance $149 r0 *1 35.39,38.945
X$149 3 11 M2_M1_CDNS_40661956134142
* cell instance $150 r0 *1 52.835,38.945
X$150 3 14 M2_M1_CDNS_40661956134140
* cell instance $151 r0 *1 21.615,36.505
X$151 3 10 M2_M1_CDNS_40661956134140
* cell instance $152 r0 *1 35.39,36.505
X$152 3 11 M2_M1_CDNS_40661956134142
* cell instance $153 r0 *1 52.835,36.505
X$153 3 14 M2_M1_CDNS_40661956134140
* cell instance $154 r0 *1 21.615,60.905
X$154 3 10 M2_M1_CDNS_40661956134140
* cell instance $155 r0 *1 35.39,60.905
X$155 3 11 M2_M1_CDNS_40661956134142
* cell instance $156 r0 *1 52.835,60.905
X$156 3 14 M2_M1_CDNS_40661956134140
* cell instance $157 r0 *1 2.97,1.135
X$157 3 6 M2_M1_CDNS_40661956134145
* cell instance $158 r0 *1 21.615,1.135
X$158 3 10 M2_M1_CDNS_40661956134144
* cell instance $159 r0 *1 35.39,1.135
X$159 3 11 M2_M1_CDNS_40661956134145
* cell instance $160 r0 *1 52.835,1.135
X$160 3 14 M2_M1_CDNS_40661956134144
* cell instance $161 r0 *1 1.135,63.385
X$161 3 6 M2_M1_CDNS_40661956134148
* cell instance $162 r0 *1 2.97,125.635
X$162 3 6 M2_M1_CDNS_40661956134145
* cell instance $163 r0 *1 21.615,125.635
X$163 3 10 M2_M1_CDNS_40661956134144
* cell instance $164 r0 *1 35.39,125.635
X$164 3 11 M2_M1_CDNS_40661956134145
* cell instance $165 r0 *1 52.835,125.635
X$165 3 14 M2_M1_CDNS_40661956134144
* cell instance $166 r0 *1 3.885,63.385
X$166 5 4 M1_PSUB_CDNS_40661956134137
* cell instance $167 r0 *1 32.405,4.135
X$167 5 4 M1_PSUB_CDNS_40661956134138
* cell instance $168 r0 *1 32.405,34.025
X$168 5 4 M1_PSUB_CDNS_40661956134134
* cell instance $169 r0 *1 32.405,92.745
X$169 5 4 M1_PSUB_CDNS_40661956134134
* cell instance $170 r0 *1 32.405,63.385
X$170 5 4 M1_PSUB_CDNS_40661956134134
* cell instance $171 r0 *1 32.405,122.635
X$171 5 4 M1_PSUB_CDNS_40661956134138
* cell instance $172 r0 *1 60.925,63.385
X$172 5 4 M1_PSUB_CDNS_40661956134137
* cell instance $173 r0 *1 60.925,63.385
X$173 5 15 M2_M1_CDNS_40661956134146
* cell instance $174 r0 *1 11.975,69.525
X$174 5 8 M2_M1_CDNS_40661956134140
* cell instance $175 r0 *1 29.42,69.525
X$175 5 9 M2_M1_CDNS_40661956134142
* cell instance $176 r0 *1 43.195,69.525
X$176 5 12 M2_M1_CDNS_40661956134140
* cell instance $177 r0 *1 11.975,81.725
X$177 5 8 M2_M1_CDNS_40661956134140
* cell instance $178 r0 *1 29.42,81.725
X$178 5 9 M2_M1_CDNS_40661956134142
* cell instance $179 r0 *1 43.195,81.725
X$179 5 12 M2_M1_CDNS_40661956134140
* cell instance $180 r0 *1 11.975,71.965
X$180 5 8 M2_M1_CDNS_40661956134140
* cell instance $181 r0 *1 29.42,71.965
X$181 5 9 M2_M1_CDNS_40661956134142
* cell instance $182 r0 *1 43.195,71.965
X$182 5 12 M2_M1_CDNS_40661956134140
* cell instance $183 r0 *1 11.975,76.845
X$183 5 8 M2_M1_CDNS_40661956134140
* cell instance $184 r0 *1 29.42,76.845
X$184 5 9 M2_M1_CDNS_40661956134142
* cell instance $185 r0 *1 43.195,76.845
X$185 5 12 M2_M1_CDNS_40661956134140
* cell instance $186 r0 *1 11.975,74.405
X$186 5 8 M2_M1_CDNS_40661956134140
* cell instance $187 r0 *1 29.42,74.405
X$187 5 9 M2_M1_CDNS_40661956134142
* cell instance $188 r0 *1 43.195,74.405
X$188 5 12 M2_M1_CDNS_40661956134140
* cell instance $189 r0 *1 11.975,79.285
X$189 5 8 M2_M1_CDNS_40661956134140
* cell instance $190 r0 *1 29.42,79.285
X$190 5 9 M2_M1_CDNS_40661956134142
* cell instance $191 r0 *1 43.195,79.285
X$191 5 12 M2_M1_CDNS_40661956134140
* cell instance $192 r0 *1 11.975,67.085
X$192 5 8 M2_M1_CDNS_40661956134140
* cell instance $193 r0 *1 29.42,67.085
X$193 5 9 M2_M1_CDNS_40661956134142
* cell instance $194 r0 *1 43.195,67.085
X$194 5 12 M2_M1_CDNS_40661956134140
* cell instance $195 r0 *1 11.975,118.405
X$195 5 8 M2_M1_CDNS_40661956134140
* cell instance $196 r0 *1 29.42,118.405
X$196 5 9 M2_M1_CDNS_40661956134142
* cell instance $197 r0 *1 43.195,118.405
X$197 5 12 M2_M1_CDNS_40661956134140
* cell instance $198 r0 *1 11.975,115.965
X$198 5 8 M2_M1_CDNS_40661956134140
* cell instance $199 r0 *1 29.42,115.965
X$199 5 9 M2_M1_CDNS_40661956134142
* cell instance $200 r0 *1 43.195,115.965
X$200 5 12 M2_M1_CDNS_40661956134140
* cell instance $201 r0 *1 11.975,113.525
X$201 5 8 M2_M1_CDNS_40661956134140
* cell instance $202 r0 *1 29.42,113.525
X$202 5 9 M2_M1_CDNS_40661956134142
* cell instance $203 r0 *1 43.195,113.525
X$203 5 12 M2_M1_CDNS_40661956134140
* cell instance $204 r0 *1 11.975,111.085
X$204 5 8 M2_M1_CDNS_40661956134140
* cell instance $205 r0 *1 29.42,111.085
X$205 5 9 M2_M1_CDNS_40661956134142
* cell instance $206 r0 *1 43.195,111.085
X$206 5 12 M2_M1_CDNS_40661956134140
* cell instance $207 r0 *1 11.975,30.325
X$207 5 8 M2_M1_CDNS_40661956134140
* cell instance $208 r0 *1 29.42,30.325
X$208 5 9 M2_M1_CDNS_40661956134142
* cell instance $209 r0 *1 43.195,30.325
X$209 5 12 M2_M1_CDNS_40661956134140
* cell instance $210 r0 *1 11.975,23.005
X$210 5 8 M2_M1_CDNS_40661956134140
* cell instance $211 r0 *1 29.42,23.005
X$211 5 9 M2_M1_CDNS_40661956134142
* cell instance $212 r0 *1 43.195,23.005
X$212 5 12 M2_M1_CDNS_40661956134140
* cell instance $213 r0 *1 11.975,20.565
X$213 5 8 M2_M1_CDNS_40661956134140
* cell instance $214 r0 *1 29.42,20.565
X$214 5 9 M2_M1_CDNS_40661956134142
* cell instance $215 r0 *1 43.195,20.565
X$215 5 12 M2_M1_CDNS_40661956134140
* cell instance $216 r0 *1 11.975,18.125
X$216 5 8 M2_M1_CDNS_40661956134140
* cell instance $217 r0 *1 29.42,18.125
X$217 5 9 M2_M1_CDNS_40661956134142
* cell instance $218 r0 *1 43.195,18.125
X$218 5 12 M2_M1_CDNS_40661956134140
* cell instance $219 r0 *1 11.975,15.685
X$219 5 8 M2_M1_CDNS_40661956134140
* cell instance $220 r0 *1 29.42,15.685
X$220 5 9 M2_M1_CDNS_40661956134142
* cell instance $221 r0 *1 43.195,15.685
X$221 5 12 M2_M1_CDNS_40661956134140
* cell instance $222 r0 *1 11.975,13.245
X$222 5 8 M2_M1_CDNS_40661956134140
* cell instance $223 r0 *1 29.42,13.245
X$223 5 9 M2_M1_CDNS_40661956134142
* cell instance $224 r0 *1 43.195,13.245
X$224 5 12 M2_M1_CDNS_40661956134140
* cell instance $225 r0 *1 11.975,10.805
X$225 5 8 M2_M1_CDNS_40661956134140
* cell instance $226 r0 *1 29.42,10.805
X$226 5 9 M2_M1_CDNS_40661956134142
* cell instance $227 r0 *1 43.195,10.805
X$227 5 12 M2_M1_CDNS_40661956134140
* cell instance $228 r0 *1 11.975,8.365
X$228 5 8 M2_M1_CDNS_40661956134140
* cell instance $229 r0 *1 29.42,8.365
X$229 5 9 M2_M1_CDNS_40661956134142
* cell instance $230 r0 *1 43.195,8.365
X$230 5 12 M2_M1_CDNS_40661956134140
* cell instance $231 r0 *1 11.975,96.445
X$231 5 8 M2_M1_CDNS_40661956134140
* cell instance $232 r0 *1 29.42,96.445
X$232 5 9 M2_M1_CDNS_40661956134142
* cell instance $233 r0 *1 43.195,96.445
X$233 5 12 M2_M1_CDNS_40661956134140
* cell instance $234 r0 *1 11.975,106.205
X$234 5 8 M2_M1_CDNS_40661956134140
* cell instance $235 r0 *1 29.42,106.205
X$235 5 9 M2_M1_CDNS_40661956134142
* cell instance $236 r0 *1 43.195,106.205
X$236 5 12 M2_M1_CDNS_40661956134140
* cell instance $237 r0 *1 11.975,25.445
X$237 5 8 M2_M1_CDNS_40661956134140
* cell instance $238 r0 *1 29.42,25.445
X$238 5 9 M2_M1_CDNS_40661956134142
* cell instance $239 r0 *1 43.195,25.445
X$239 5 12 M2_M1_CDNS_40661956134140
* cell instance $240 r0 *1 11.975,101.325
X$240 5 8 M2_M1_CDNS_40661956134140
* cell instance $241 r0 *1 29.42,101.325
X$241 5 9 M2_M1_CDNS_40661956134142
* cell instance $242 r0 *1 43.195,101.325
X$242 5 12 M2_M1_CDNS_40661956134140
* cell instance $243 r0 *1 11.975,98.885
X$243 5 8 M2_M1_CDNS_40661956134140
* cell instance $244 r0 *1 29.42,98.885
X$244 5 9 M2_M1_CDNS_40661956134142
* cell instance $245 r0 *1 43.195,98.885
X$245 5 12 M2_M1_CDNS_40661956134140
* cell instance $246 r0 *1 11.975,108.645
X$246 5 8 M2_M1_CDNS_40661956134140
* cell instance $247 r0 *1 29.42,108.645
X$247 5 9 M2_M1_CDNS_40661956134142
* cell instance $248 r0 *1 43.195,108.645
X$248 5 12 M2_M1_CDNS_40661956134140
* cell instance $249 r0 *1 11.975,89.045
X$249 5 8 M2_M1_CDNS_40661956134140
* cell instance $250 r0 *1 29.42,89.045
X$250 5 9 M2_M1_CDNS_40661956134142
* cell instance $251 r0 *1 43.195,89.045
X$251 5 12 M2_M1_CDNS_40661956134140
* cell instance $252 r0 *1 11.975,86.605
X$252 5 8 M2_M1_CDNS_40661956134140
* cell instance $253 r0 *1 29.42,86.605
X$253 5 9 M2_M1_CDNS_40661956134142
* cell instance $254 r0 *1 43.195,86.605
X$254 5 12 M2_M1_CDNS_40661956134140
* cell instance $255 r0 *1 11.975,84.165
X$255 5 8 M2_M1_CDNS_40661956134140
* cell instance $256 r0 *1 29.42,84.165
X$256 5 9 M2_M1_CDNS_40661956134142
* cell instance $257 r0 *1 43.195,84.165
X$257 5 12 M2_M1_CDNS_40661956134140
* cell instance $258 r0 *1 11.975,103.765
X$258 5 8 M2_M1_CDNS_40661956134140
* cell instance $259 r0 *1 29.42,103.765
X$259 5 9 M2_M1_CDNS_40661956134142
* cell instance $260 r0 *1 43.195,103.765
X$260 5 12 M2_M1_CDNS_40661956134140
* cell instance $261 r0 *1 11.975,59.685
X$261 5 8 M2_M1_CDNS_40661956134140
* cell instance $262 r0 *1 29.42,59.685
X$262 5 9 M2_M1_CDNS_40661956134142
* cell instance $263 r0 *1 43.195,59.685
X$263 5 12 M2_M1_CDNS_40661956134140
* cell instance $264 r0 *1 11.975,57.245
X$264 5 8 M2_M1_CDNS_40661956134140
* cell instance $265 r0 *1 29.42,57.245
X$265 5 9 M2_M1_CDNS_40661956134142
* cell instance $266 r0 *1 43.195,57.245
X$266 5 12 M2_M1_CDNS_40661956134140
* cell instance $267 r0 *1 11.975,54.805
X$267 5 8 M2_M1_CDNS_40661956134140
* cell instance $268 r0 *1 29.42,54.805
X$268 5 9 M2_M1_CDNS_40661956134142
* cell instance $269 r0 *1 43.195,54.805
X$269 5 12 M2_M1_CDNS_40661956134140
* cell instance $270 r0 *1 11.975,52.365
X$270 5 8 M2_M1_CDNS_40661956134140
* cell instance $271 r0 *1 29.42,52.365
X$271 5 9 M2_M1_CDNS_40661956134142
* cell instance $272 r0 *1 43.195,52.365
X$272 5 12 M2_M1_CDNS_40661956134140
* cell instance $273 r0 *1 11.975,47.485
X$273 5 8 M2_M1_CDNS_40661956134140
* cell instance $274 r0 *1 29.42,47.485
X$274 5 9 M2_M1_CDNS_40661956134142
* cell instance $275 r0 *1 43.195,47.485
X$275 5 12 M2_M1_CDNS_40661956134140
* cell instance $276 r0 *1 11.975,45.045
X$276 5 8 M2_M1_CDNS_40661956134140
* cell instance $277 r0 *1 29.42,45.045
X$277 5 9 M2_M1_CDNS_40661956134142
* cell instance $278 r0 *1 43.195,45.045
X$278 5 12 M2_M1_CDNS_40661956134140
* cell instance $279 r0 *1 11.975,27.885
X$279 5 8 M2_M1_CDNS_40661956134140
* cell instance $280 r0 *1 29.42,27.885
X$280 5 9 M2_M1_CDNS_40661956134142
* cell instance $281 r0 *1 43.195,27.885
X$281 5 12 M2_M1_CDNS_40661956134140
* cell instance $282 r0 *1 11.975,42.605
X$282 5 8 M2_M1_CDNS_40661956134140
* cell instance $283 r0 *1 29.42,42.605
X$283 5 9 M2_M1_CDNS_40661956134142
* cell instance $284 r0 *1 43.195,42.605
X$284 5 12 M2_M1_CDNS_40661956134140
* cell instance $285 r0 *1 11.975,40.165
X$285 5 8 M2_M1_CDNS_40661956134140
* cell instance $286 r0 *1 29.42,40.165
X$286 5 9 M2_M1_CDNS_40661956134142
* cell instance $287 r0 *1 43.195,40.165
X$287 5 12 M2_M1_CDNS_40661956134140
* cell instance $288 r0 *1 11.975,37.725
X$288 5 8 M2_M1_CDNS_40661956134140
* cell instance $289 r0 *1 29.42,37.725
X$289 5 9 M2_M1_CDNS_40661956134142
* cell instance $290 r0 *1 43.195,37.725
X$290 5 12 M2_M1_CDNS_40661956134140
* cell instance $291 r0 *1 11.975,49.925
X$291 5 8 M2_M1_CDNS_40661956134140
* cell instance $292 r0 *1 29.42,49.925
X$292 5 9 M2_M1_CDNS_40661956134142
* cell instance $293 r0 *1 43.195,49.925
X$293 5 12 M2_M1_CDNS_40661956134140
* cell instance $294 r0 *1 11.975,4.135
X$294 5 8 M2_M1_CDNS_40661956134144
* cell instance $295 r0 *1 29.42,4.135
X$295 5 9 M2_M1_CDNS_40661956134145
* cell instance $296 r0 *1 43.195,4.135
X$296 5 12 M2_M1_CDNS_40661956134144
* cell instance $297 r0 *1 11.975,122.635
X$297 5 8 M2_M1_CDNS_40661956134144
* cell instance $298 r0 *1 29.42,122.635
X$298 5 9 M2_M1_CDNS_40661956134145
* cell instance $299 r0 *1 43.195,122.635
X$299 5 12 M2_M1_CDNS_40661956134144
* cell instance $300 r0 *1 11.975,63.385
X$300 5 8 M2_M1_CDNS_40661956134143
* cell instance $301 r0 *1 29.42,63.385
X$301 5 9 M2_M1_CDNS_40661956134147
* cell instance $302 r0 *1 43.195,63.385
X$302 5 12 M2_M1_CDNS_40661956134143
* cell instance $303 r0 *1 11.975,34.025
X$303 5 8 M2_M1_CDNS_40661956134143
* cell instance $304 r0 *1 29.42,34.025
X$304 5 9 M2_M1_CDNS_40661956134147
* cell instance $305 r0 *1 43.195,34.025
X$305 5 12 M2_M1_CDNS_40661956134143
* cell instance $306 r0 *1 11.975,92.745
X$306 5 8 M2_M1_CDNS_40661956134143
* cell instance $307 r0 *1 29.42,92.745
X$307 5 9 M2_M1_CDNS_40661956134147
* cell instance $308 r0 *1 43.195,92.745
X$308 5 12 M2_M1_CDNS_40661956134143
.ENDS nmos_clamp_20_50_4

* cell M1_PSUB_CDNS_40661956134125
* pin
* pin
.SUBCKT M1_PSUB_CDNS_40661956134125 1 2
.ENDS M1_PSUB_CDNS_40661956134125

* cell M2_M1_CDNS_40661956134126
* pin
* pin
.SUBCKT M2_M1_CDNS_40661956134126 1 2
.ENDS M2_M1_CDNS_40661956134126

* cell M1_POLY2_CDNS_40661956134127
* pin
.SUBCKT M1_POLY2_CDNS_40661956134127 1
.ENDS M1_POLY2_CDNS_40661956134127

* cell M1_NWELL_CDNS_40661956134129
* pin
* pin
* pin
* pin
.SUBCKT M1_NWELL_CDNS_40661956134129 1 2 3 4
.ENDS M1_NWELL_CDNS_40661956134129

* cell M1_POLY2_CDNS_40661956134130
* pin
.SUBCKT M1_POLY2_CDNS_40661956134130 1
.ENDS M1_POLY2_CDNS_40661956134130

* cell M1_POLY2_CDNS_40661956134131
* pin
.SUBCKT M1_POLY2_CDNS_40661956134131 1
.ENDS M1_POLY2_CDNS_40661956134131

* cell M1_POLY2_CDNS_40661956134132
* pin
.SUBCKT M1_POLY2_CDNS_40661956134132 1
.ENDS M1_POLY2_CDNS_40661956134132

* cell pmos_6p0_CDNS_406619561342
* pin
* pin
* pin
* pin
* pin
* pin
* pin
* pin
* pin
* pin
* pin
* pin
* pin
* pin
* pin
* pin
* pin
* pin
* pin
* pin
* pin
* pin
* pin
* pin
* pin
* pin
* pin
* pin
* pin
* pin
* pin
* pin
* pin
* pin
* pin
* pin
* pin
* pin
* pin
* pin
* pin
* pin
* pin
* pin
* pin
* pin
* pin
* pin
* pin
* pin
* pin
.SUBCKT pmos_6p0_CDNS_406619561342 2 3 4 5 6 7 8 9 10 11 12 13 14 15 16 17 18
+ 19 20 21 22 23 24 25 26 27 28 29 30 31 32 33 34 35 36 37 38 39 40 41 42 43 44
+ 45 46 47 48 49 50 51 52
.ENDS pmos_6p0_CDNS_406619561342

* cell pmos_6p0_CDNS_406619561343
* pin
* pin
* pin
* pin
* pin
* pin
* pin
* pin
* pin
* pin
.SUBCKT pmos_6p0_CDNS_406619561343 1 2 3 4 5 6 7 8 9 10
.ENDS pmos_6p0_CDNS_406619561343

* cell pmos_6p0_CDNS_406619561344
* pin
* pin
* pin
* pin
* pin
* pin
* pin
* pin
* pin
* pin
* pin
* pin
.SUBCKT pmos_6p0_CDNS_406619561344 1 2 3 4 5 6 7 8 9 10 11 12
.ENDS pmos_6p0_CDNS_406619561344

* cell nmos_6p0_CDNS_406619561346
* pin
* pin
* pin
* pin
* pin
* pin
* pin
* pin
* pin
* pin
* pin
* pin
* pin
* pin
.SUBCKT nmos_6p0_CDNS_406619561346 1 2 3 4 5 6 7 8 9 10 11 12 13 14
.ENDS nmos_6p0_CDNS_406619561346

* cell nmos_6p0_CDNS_406619561347
* pin
* pin
* pin
* pin gf180mcu_gnd
.SUBCKT nmos_6p0_CDNS_406619561347 2 3 4 5
* net 5 gf180mcu_gnd
* device instance $1 r0 *1 0.35,2.5 nmos_6p0
M$1 3 4 2 5 nmos_6p0 L=0.7U W=5U AS=2.2P AD=2.2P PS=10.88U PD=10.88U
.ENDS nmos_6p0_CDNS_406619561347

* cell M1_NWELL_CDNS_40661956134133
* pin
* pin
* pin
* pin
.SUBCKT M1_NWELL_CDNS_40661956134133 1 2 3 4
.ENDS M1_NWELL_CDNS_40661956134133

* cell M1_NWELL_CDNS_40661956134419
* pin
* pin
* pin
* pin
.SUBCKT M1_NWELL_CDNS_40661956134419 1 2 3 4
.ENDS M1_NWELL_CDNS_40661956134419

* cell ppolyf_u_CDNS_4066195613432
* pin
* pin
* pin gf180mcu_gnd
.SUBCKT ppolyf_u_CDNS_4066195613432 1 2 3
* net 3 gf180mcu_gnd
* device instance $1 r0 *1 12.01,0.4 ppolyf_u
R$1 2 1 3 10062.5 ppolyf_u L=23U W=0.8U
.ENDS ppolyf_u_CDNS_4066195613432

* cell ppolyf_u_CDNS_4066195613433
* pin
* pin
* pin gf180mcu_gnd
.SUBCKT ppolyf_u_CDNS_4066195613433 1 2 3
* net 3 gf180mcu_gnd
* device instance $1 r0 *1 18.36,0.4 ppolyf_u
R$1 2 1 3 15618.75 ppolyf_u L=35.7U W=0.8U
.ENDS ppolyf_u_CDNS_4066195613433

* cell M1_NWELL_CDNS_40661956134335
* pin
* pin
* pin
* pin
.SUBCKT M1_NWELL_CDNS_40661956134335 1 2 3 4
.ENDS M1_NWELL_CDNS_40661956134335

* cell M1_NWELL_CDNS_40661956134428
* pin
* pin
* pin
* pin
.SUBCKT M1_NWELL_CDNS_40661956134428 1 2 3 4
.ENDS M1_NWELL_CDNS_40661956134428

* cell M1_NWELL_CDNS_40661956134431
* pin
* pin
* pin
* pin
.SUBCKT M1_NWELL_CDNS_40661956134431 1 2 3 4
.ENDS M1_NWELL_CDNS_40661956134431

* cell pmos_6p0_CDNS_4066195613448
* pin
* pin
* pin
* pin
* pin
* pin
* pin
* pin
* pin
* pin
* pin
* pin
* pin
* pin
* pin
.SUBCKT pmos_6p0_CDNS_4066195613448 2 3 4 5 6 7 8 9 10 11 12 13 14 15 16
* device instance $1 r0 *1 0.35,1.75 pmos_6p0
M$1 2 11 7 16 pmos_6p0 L=0.7U W=3.5U AS=1.54P AD=0.91P PS=7.88U PD=4.02U
* device instance $2 r0 *1 1.57,1.75 pmos_6p0
M$2 3 10 2 16 pmos_6p0 L=0.7U W=3.5U AS=0.91P AD=0.91P PS=4.02U PD=4.02U
* device instance $3 r0 *1 2.79,1.75 pmos_6p0
M$3 4 9 3 16 pmos_6p0 L=0.7U W=3.5U AS=0.91P AD=0.91P PS=4.02U PD=4.02U
* device instance $4 r0 *1 4.01,1.75 pmos_6p0
M$4 5 12 4 16 pmos_6p0 L=0.7U W=3.5U AS=0.91P AD=0.91P PS=4.02U PD=4.02U
* device instance $5 r0 *1 5.23,1.75 pmos_6p0
M$5 6 13 5 16 pmos_6p0 L=0.7U W=3.5U AS=0.91P AD=0.91P PS=4.02U PD=4.02U
* device instance $6 r0 *1 6.45,1.75 pmos_6p0
M$6 8 14 6 16 pmos_6p0 L=0.7U W=3.5U AS=0.91P AD=1.54P PS=4.02U PD=7.88U
.ENDS pmos_6p0_CDNS_4066195613448

* cell pmos_6p0_CDNS_4066195613446
* pin
* pin
* pin
* pin
* pin
* pin
* pin
* pin
* pin
* pin
* pin
.SUBCKT pmos_6p0_CDNS_4066195613446 2 3 4 5 6 7 8 9 10 11 12
* device instance $1 r0 *1 0.35,1.25 pmos_6p0
M$1 2 7 5 12 pmos_6p0 L=0.7U W=2.5U AS=1.1P AD=0.65P PS=5.88U PD=3.02U
* device instance $2 r0 *1 1.57,1.25 pmos_6p0
M$2 3 9 2 12 pmos_6p0 L=0.7U W=2.5U AS=0.65P AD=0.65P PS=3.02U PD=3.02U
* device instance $3 r0 *1 2.79,1.25 pmos_6p0
M$3 4 8 3 12 pmos_6p0 L=0.7U W=2.5U AS=0.65P AD=0.65P PS=3.02U PD=3.02U
* device instance $4 r0 *1 4.01,1.25 pmos_6p0
M$4 6 10 4 12 pmos_6p0 L=0.7U W=2.5U AS=0.65P AD=1.1P PS=3.02U PD=5.88U
.ENDS pmos_6p0_CDNS_4066195613446

* cell M1_PSUB_CDNS_40661956134325
* pin
* pin
.SUBCKT M1_PSUB_CDNS_40661956134325 1 2
.ENDS M1_PSUB_CDNS_40661956134325

* cell nmos_6p0_CDNS_4066195613449
* pin
* pin
* pin
* pin
* pin
* pin
* pin
* pin
* pin
* pin
* pin
* pin
* pin
* pin gf180mcu_gnd
.SUBCKT nmos_6p0_CDNS_4066195613449 2 3 4 5 6 7 8 9 10 11 12 13 14 15
* net 15 gf180mcu_gnd
* device instance $1 r0 *1 0.35,0.75 nmos_6p0
M$1 2 10 7 15 nmos_6p0 L=0.7U W=1.5U AS=0.66P AD=0.39P PS=3.88U PD=2.02U
* device instance $2 r0 *1 1.57,0.75 nmos_6p0
M$2 3 9 2 15 nmos_6p0 L=0.7U W=1.5U AS=0.39P AD=0.39P PS=2.02U PD=2.02U
* device instance $3 r0 *1 2.79,0.75 nmos_6p0
M$3 4 11 3 15 nmos_6p0 L=0.7U W=1.5U AS=0.39P AD=0.39P PS=2.02U PD=2.02U
* device instance $4 r0 *1 4.01,0.75 nmos_6p0
M$4 5 12 4 15 nmos_6p0 L=0.7U W=1.5U AS=0.39P AD=0.39P PS=2.02U PD=2.02U
* device instance $5 r0 *1 5.23,0.75 nmos_6p0
M$5 6 13 5 15 nmos_6p0 L=0.7U W=1.5U AS=0.39P AD=0.39P PS=2.02U PD=2.02U
* device instance $6 r0 *1 6.45,0.75 nmos_6p0
M$6 8 14 6 15 nmos_6p0 L=0.7U W=1.5U AS=0.39P AD=0.66P PS=2.02U PD=3.88U
.ENDS nmos_6p0_CDNS_4066195613449

* cell nmos_6p0_CDNS_4066195613450
* pin
* pin
* pin
* pin
* pin
* pin gf180mcu_gnd
.SUBCKT nmos_6p0_CDNS_4066195613450 2 3 4 5 6 7
* net 7 gf180mcu_gnd
* device instance $1 r0 *1 0.35,0.625 nmos_6p0
M$1 2 5 3 7 nmos_6p0 L=0.7U W=1.25U AS=0.55P AD=0.325P PS=3.38U PD=1.77U
* device instance $2 r0 *1 1.57,0.625 nmos_6p0
M$2 4 6 2 7 nmos_6p0 L=0.7U W=1.25U AS=0.325P AD=0.55P PS=1.77U PD=3.38U
.ENDS nmos_6p0_CDNS_4066195613450

* cell nmos_6p0_CDNS_4066195613447
* pin
* pin
* pin
* pin
* pin
* pin gf180mcu_gnd
.SUBCKT nmos_6p0_CDNS_4066195613447 2 3 4 5 6 7
* net 7 gf180mcu_gnd
* device instance $1 r0 *1 0.35,2 nmos_6p0
M$1 2 5 3 7 nmos_6p0 L=0.7U W=4U AS=1.76P AD=1.04P PS=8.88U PD=4.52U
* device instance $2 r0 *1 1.57,2 nmos_6p0
M$2 4 6 2 7 nmos_6p0 L=0.7U W=4U AS=1.04P AD=1.76P PS=4.52U PD=8.88U
.ENDS nmos_6p0_CDNS_4066195613447

* cell M2_M1_CDNS_40661956134320
* pin
* pin
.SUBCKT M2_M1_CDNS_40661956134320 1 2
.ENDS M2_M1_CDNS_40661956134320

* cell M1_PSUB_CDNS_40661956134429
* pin
* pin
.SUBCKT M1_PSUB_CDNS_40661956134429 1 2
.ENDS M1_PSUB_CDNS_40661956134429

* cell M1_PSUB_CDNS_40661956134430
* pin
* pin
.SUBCKT M1_PSUB_CDNS_40661956134430 1 2
.ENDS M1_PSUB_CDNS_40661956134430

* cell comp018green_std_nand2
* pin Z
* pin
* pin
* pin
* pin VDD
* pin VSS
* pin A
* pin B
* pin
* pin gf180mcu_gnd
.SUBCKT comp018green_std_nand2 1 2 3 4 5 6 7 8 10 11
* net 1 Z
* net 5 VDD
* net 6 VSS
* net 7 A
* net 8 B
* net 11 gf180mcu_gnd
* cell instance $1 m90 *1 3.6,8.165
X$1 12 5 1 8 4 10 pmos_6p0_CDNS_4066195613412
* cell instance $2 r0 *1 1.68,8.165
X$2 12 5 1 7 4 10 pmos_6p0_CDNS_4066195613412
* cell instance $3 r0 *1 2.9,1.405
X$3 13 9 1 8 nmos_6p0_CDNS_4066195613411
* cell instance $4 r0 *1 5.055,9.94
X$4 5 2 4 10 M1_NWELL_CDNS_40661956134418
* cell instance $5 r0 *1 2.64,12.29
X$5 5 2 4 10 M1_NWELL_CDNS_40661956134322
* cell instance $6 r0 *1 0.225,9.94
X$6 5 2 4 10 M1_NWELL_CDNS_40661956134418
* cell instance $7 m0 *1 5.055,2.63
X$7 6 3 M1_PSUB_CDNS_40661956134330
* cell instance $8 m0 *1 2.64,0.28
X$8 6 3 M1_PSUB_CDNS_40661956134328
* cell instance $9 m0 *1 0.225,2.63
X$9 6 3 M1_PSUB_CDNS_40661956134330
* cell instance $10 r0 *1 1.68,1.405
X$10 13 6 9 7 nmos_6p0_CDNS_4066195613411
* cell instance $11 r0 *1 2.03,6.315
X$11 7 M1_POLY2_CDNS_40661956134326
* cell instance $12 r0 *1 3.25,6.315
X$12 8 M1_POLY2_CDNS_40661956134326
* device instance $1 r0 *1 2.03,9.665 pmos_6p0
M$1 1 7 5 10 pmos_6p0 L=0.7U W=3U AS=1.32P AD=0.78P PS=6.88U PD=3.52U
* device instance $2 r0 *1 3.25,9.665 pmos_6p0
M$2 5 8 1 10 pmos_6p0 L=0.7U W=3U AS=0.78P AD=1.32P PS=3.52U PD=6.88U
* device instance $3 r0 *1 2.03,2.905 nmos_6p0
M$3 9 7 6 11 nmos_6p0 L=0.7U W=3U AS=1.32P AD=0.78P PS=6.88U PD=3.52U
* device instance $4 r0 *1 3.25,2.905 nmos_6p0
M$4 1 8 9 11 nmos_6p0 L=0.7U W=3U AS=0.78P AD=1.32P PS=3.52U PD=6.88U
.ENDS comp018green_std_nand2

* cell comp018green_std_xor2
* pin
* pin A
* pin B
* pin Z
* pin VDD
* pin VSS
* pin gf180mcu_gnd
.SUBCKT comp018green_std_xor2 1 2 3 4 7 13 14
* net 2 A
* net 3 B
* net 4 Z
* net 7 VDD
* net 13 VSS
* net 14 gf180mcu_gnd
* cell instance $1 r0 *1 5.35,7.88
X$1 4 1 M2_M1_CDNS_40661956134270
* cell instance $2 r0 *1 5.35,2.82
X$2 4 1 M2_M1_CDNS_40661956134270
* cell instance $3 r0 *1 2.31,1.77
X$3 13 5 2 nmos_6p0_CDNS_4066195613430
* cell instance $4 r180 *1 5.09,3.27
X$4 4 2 6 nmos_6p0_CDNS_4066195613430
* cell instance $5 r0 *1 2.66,5.045
X$5 2 M1_POLY2_CDNS_40661956134326
* cell instance $6 r0 *1 2.31,7.43
X$6 18 7 5 2 10 7 pmos_6p0_CDNS_4066195613412
* cell instance $7 m90 *1 5.09,7.43
X$7 15 4 2 3 10 7 pmos_6p0_CDNS_4066195613412
* cell instance $8 r180 *1 9.25,3.27
X$8 13 6 3 nmos_6p0_CDNS_4066195613430
* cell instance $9 r0 *1 6.47,1.77
X$9 4 5 3 nmos_6p0_CDNS_4066195613430
* cell instance $10 r0 *1 4.76,6.155
X$10 3 12 M2_M1_CDNS_40661956134270
* cell instance $11 r0 *1 4.74,6.155
X$11 3 M1_POLY2_CDNS_40661956134326
* cell instance $12 r0 *1 8.9,6.155
X$12 3 M1_POLY2_CDNS_40661956134326
* cell instance $13 r0 *1 8.92,6.155
X$13 3 12 M2_M1_CDNS_40661956134270
* cell instance $14 r180 *1 9.25,10.43
X$14 17 7 6 3 10 7 pmos_6p0_CDNS_4066195613412
* cell instance $15 m0 *1 6.47,10.43
X$15 16 4 5 6 10 7 pmos_6p0_CDNS_4066195613412
* cell instance $16 r0 *1 3.27,2.82
X$16 5 11 M2_M1_CDNS_40661956134270
* cell instance $17 r0 *1 3.27,7.88
X$17 5 11 M2_M1_CDNS_40661956134270
* cell instance $18 r0 *1 4.74,4.53
X$18 6 M1_POLY2_CDNS_40661956134326
* cell instance $19 r0 *1 6.82,6.155
X$19 6 M1_POLY2_CDNS_40661956134326
* cell instance $20 r0 *1 5.695,12.235
X$20 7 9 10 7 M1_NWELL_CDNS_40661956134426
* cell instance $21 r0 *1 0.225,9.885
X$21 7 9 10 7 M1_NWELL_CDNS_40661956134418
* cell instance $22 r0 *1 11.165,9.885
X$22 7 9 10 7 M1_NWELL_CDNS_40661956134418
* cell instance $23 m0 *1 5.695,0.225
X$23 13 8 M1_PSUB_CDNS_40661956134427
* cell instance $24 m0 *1 11.165,2.575
X$24 13 8 M1_PSUB_CDNS_40661956134330
* cell instance $25 m0 *1 0.225,2.575
X$25 13 8 M1_PSUB_CDNS_40661956134330
* device instance $1 r0 *1 8.9,8.93 pmos_6p0
M$1 7 3 6 7 pmos_6p0 L=0.7U W=3U AS=1.32P AD=1.32P PS=6.88U PD=6.88U
* device instance $2 r0 *1 6.82,8.93 pmos_6p0
M$2 5 6 4 7 pmos_6p0 L=0.7U W=3U AS=1.32P AD=1.32P PS=6.88U PD=6.88U
* device instance $3 r0 *1 4.74,8.93 pmos_6p0
M$3 4 3 2 7 pmos_6p0 L=0.7U W=3U AS=1.32P AD=1.32P PS=6.88U PD=6.88U
* device instance $4 r0 *1 2.66,8.93 pmos_6p0
M$4 5 2 7 7 pmos_6p0 L=0.7U W=3U AS=1.32P AD=1.32P PS=6.88U PD=6.88U
* device instance $5 r0 *1 8.9,2.52 nmos_6p0
M$5 13 3 6 14 nmos_6p0 L=0.7U W=1.5U AS=0.66P AD=0.66P PS=3.88U PD=3.88U
* device instance $6 r0 *1 6.82,2.52 nmos_6p0
M$6 5 3 4 14 nmos_6p0 L=0.7U W=1.5U AS=0.66P AD=0.66P PS=3.88U PD=3.88U
* device instance $7 r0 *1 4.74,2.52 nmos_6p0
M$7 4 6 2 14 nmos_6p0 L=0.7U W=1.5U AS=0.66P AD=0.66P PS=3.88U PD=3.88U
* device instance $8 r0 *1 2.66,2.52 nmos_6p0
M$8 5 2 13 14 nmos_6p0 L=0.7U W=1.5U AS=0.66P AD=0.66P PS=3.88U PD=3.88U
.ENDS comp018green_std_xor2

* cell M1_PSUB_CDNS_40661956134332
* pin
* pin
.SUBCKT M1_PSUB_CDNS_40661956134332 1 2
.ENDS M1_PSUB_CDNS_40661956134332

* cell M1_PSUB_CDNS_40661956134341
* pin
* pin
.SUBCKT M1_PSUB_CDNS_40661956134341 1 2
.ENDS M1_PSUB_CDNS_40661956134341

* cell M1_NWELL_CDNS_40661956134377
* pin
* pin
* pin
* pin
.SUBCKT M1_NWELL_CDNS_40661956134377 1 2 3 4
.ENDS M1_NWELL_CDNS_40661956134377

* cell pmos_6p0_CDNS_4066195613429
* pin
* pin
* pin
* pin
* pin
* pin
* pin
* pin
.SUBCKT pmos_6p0_CDNS_4066195613429 1 2 3 4 5 6 7 8
.ENDS pmos_6p0_CDNS_4066195613429

* cell M1_PSUB_CDNS_40661956134424
* pin
* pin
.SUBCKT M1_PSUB_CDNS_40661956134424 1 2
.ENDS M1_PSUB_CDNS_40661956134424

* cell M1_NWELL_CDNS_40661956134425
* pin
* pin
* pin
* pin
.SUBCKT M1_NWELL_CDNS_40661956134425 1 2 3 4
.ENDS M1_NWELL_CDNS_40661956134425

* cell nmos_6p0_CDNS_4066195613431
* pin
* pin
* pin
* pin
* pin
* pin
.SUBCKT nmos_6p0_CDNS_4066195613431 1 2 3 4 5 6
.ENDS nmos_6p0_CDNS_4066195613431

* cell M1_PSUB_CDNS_40661956134420
* pin
* pin
.SUBCKT M1_PSUB_CDNS_40661956134420 1 2
.ENDS M1_PSUB_CDNS_40661956134420

* cell M1_NWELL_CDNS_40661956134421
* pin
* pin
* pin
* pin
.SUBCKT M1_NWELL_CDNS_40661956134421 1 2 3 4
.ENDS M1_NWELL_CDNS_40661956134421

* cell M1_PSUB_CDNS_40661956134422
* pin
.SUBCKT M1_PSUB_CDNS_40661956134422 1
.ENDS M1_PSUB_CDNS_40661956134422

* cell M1_NWELL_CDNS_40661956134423
* pin
* pin
.SUBCKT M1_NWELL_CDNS_40661956134423 1 3
.ENDS M1_NWELL_CDNS_40661956134423

* cell pmos_6p0_CDNS_4066195613434
* pin
* pin
* pin
* pin
* pin
* pin
* pin
.SUBCKT pmos_6p0_CDNS_4066195613434 2 3 4 5 6 7 8
* device instance $1 r0 *1 0.35,0.75 pmos_6p0
M$1 2 5 3 8 pmos_6p0 L=0.7U W=1.5U AS=0.66P AD=0.39P PS=3.88U PD=2.02U
* device instance $2 r0 *1 1.57,0.75 pmos_6p0
M$2 4 6 2 8 pmos_6p0 L=0.7U W=1.5U AS=0.39P AD=0.66P PS=2.02U PD=3.88U
.ENDS pmos_6p0_CDNS_4066195613434

* cell nmos_6p0_CDNS_4066195613435
* pin
* pin
* pin
* pin
* pin
* pin gf180mcu_gnd
.SUBCKT nmos_6p0_CDNS_4066195613435 2 3 4 5 6 7
* net 7 gf180mcu_gnd
* device instance $1 r0 *1 0.35,1 nmos_6p0
M$1 2 5 3 7 nmos_6p0 L=0.7U W=2U AS=0.88P AD=0.52P PS=4.88U PD=2.52U
* device instance $2 r0 *1 1.57,1 nmos_6p0
M$2 4 6 2 7 nmos_6p0 L=0.7U W=2U AS=0.52P AD=0.88P PS=2.52U PD=4.88U
.ENDS nmos_6p0_CDNS_4066195613435

* cell nmos_6p0_CDNS_4066195613436
* pin
* pin
* pin
.SUBCKT nmos_6p0_CDNS_4066195613436 2 3 4
.ENDS nmos_6p0_CDNS_4066195613436

* cell nmos_6p0_CDNS_4066195613437
* pin
* pin
* pin
* pin
* pin
* pin
* pin
* pin
* pin
* pin
* pin
* pin gf180mcu_gnd
.SUBCKT nmos_6p0_CDNS_4066195613437 2 3 4 5 6 7 8 9 10 11 12 13
* net 13 gf180mcu_gnd
* device instance $1 r0 *1 0.35,1.6 nmos_6p0
M$1 2 8 6 13 nmos_6p0 L=0.7U W=3.2U AS=1.408P AD=0.832P PS=7.28U PD=3.72U
* device instance $2 r0 *1 1.57,1.6 nmos_6p0
M$2 3 9 2 13 nmos_6p0 L=0.7U W=3.2U AS=0.832P AD=0.832P PS=3.72U PD=3.72U
* device instance $3 r0 *1 2.79,1.6 nmos_6p0
M$3 4 10 3 13 nmos_6p0 L=0.7U W=3.2U AS=0.832P AD=0.832P PS=3.72U PD=3.72U
* device instance $4 r0 *1 4.01,1.6 nmos_6p0
M$4 5 11 4 13 nmos_6p0 L=0.7U W=3.2U AS=0.832P AD=0.832P PS=3.72U PD=3.72U
* device instance $5 r0 *1 5.23,1.6 nmos_6p0
M$5 7 12 5 13 nmos_6p0 L=0.7U W=3.2U AS=0.832P AD=1.408P PS=3.72U PD=7.28U
.ENDS nmos_6p0_CDNS_4066195613437

* cell pmos_6p0_CDNS_4066195613438
* pin
* pin
* pin
* pin
* pin
* pin
* pin
.SUBCKT pmos_6p0_CDNS_4066195613438 2 3 4 5 6 7 8
* device instance $1 r0 *1 0.35,1.075 pmos_6p0
M$1 2 5 3 8 pmos_6p0 L=0.7U W=2.15U AS=0.946P AD=0.559P PS=5.18U PD=2.67U
* device instance $2 r0 *1 1.57,1.075 pmos_6p0
M$2 4 6 2 8 pmos_6p0 L=0.7U W=2.15U AS=0.559P AD=0.946P PS=2.67U PD=5.18U
.ENDS pmos_6p0_CDNS_4066195613438

* cell pmos_6p0_CDNS_4066195613439
* pin
* pin
* pin
* pin
* pin
.SUBCKT pmos_6p0_CDNS_4066195613439 2 3 4 5 6
* device instance $1 r0 *1 0.35,1 pmos_6p0
M$1 3 4 2 6 pmos_6p0 L=0.7U W=2U AS=0.88P AD=0.88P PS=4.88U PD=4.88U
.ENDS pmos_6p0_CDNS_4066195613439

* cell nmos_6p0_CDNS_4066195613440
* pin
* pin
* pin
* pin gf180mcu_gnd
.SUBCKT nmos_6p0_CDNS_4066195613440 2 3 4 5
* net 5 gf180mcu_gnd
* device instance $1 r0 *1 0.35,0.65 nmos_6p0
M$1 3 4 2 5 nmos_6p0 L=0.7U W=1.3U AS=0.572P AD=0.572P PS=3.48U PD=3.48U
.ENDS nmos_6p0_CDNS_4066195613440

* cell nmos_6p0_CDNS_4066195613441
* pin
* pin
* pin
* pin
* pin
* pin
* pin
* pin
* pin
* pin gf180mcu_gnd
.SUBCKT nmos_6p0_CDNS_4066195613441 2 3 4 5 6 7 8 9 10 11
* net 11 gf180mcu_gnd
* device instance $1 r0 *1 0.35,1.325 nmos_6p0
M$1 2 7 5 11 nmos_6p0 L=0.7U W=2.65U AS=1.166P AD=0.689P PS=6.18U PD=3.17U
* device instance $2 r0 *1 1.57,1.325 nmos_6p0
M$2 3 8 2 11 nmos_6p0 L=0.7U W=2.65U AS=0.689P AD=0.689P PS=3.17U PD=3.17U
* device instance $3 r0 *1 2.79,1.325 nmos_6p0
M$3 4 9 3 11 nmos_6p0 L=0.7U W=2.65U AS=0.689P AD=0.689P PS=3.17U PD=3.17U
* device instance $4 r0 *1 4.01,1.325 nmos_6p0
M$4 6 10 4 11 nmos_6p0 L=0.7U W=2.65U AS=0.689P AD=1.166P PS=3.17U PD=6.18U
.ENDS nmos_6p0_CDNS_4066195613441

* cell nmos_6p0_CDNS_4066195613442
* pin
* pin
* pin
* pin
* pin
* pin
* pin
* pin
* pin
* pin gf180mcu_gnd
.SUBCKT nmos_6p0_CDNS_4066195613442 2 3 4 5 6 7 8 9 10 11
* net 11 gf180mcu_gnd
* device instance $1 r0 *1 0.35,1.5 nmos_6p0
M$1 2 7 5 11 nmos_6p0 L=0.7U W=3U AS=1.32P AD=0.78P PS=6.88U PD=3.52U
* device instance $2 r0 *1 1.57,1.5 nmos_6p0
M$2 3 8 2 11 nmos_6p0 L=0.7U W=3U AS=0.78P AD=0.78P PS=3.52U PD=3.52U
* device instance $3 r0 *1 2.79,1.5 nmos_6p0
M$3 4 9 3 11 nmos_6p0 L=0.7U W=3U AS=0.78P AD=0.78P PS=3.52U PD=3.52U
* device instance $4 r0 *1 4.01,1.5 nmos_6p0
M$4 6 10 4 11 nmos_6p0 L=0.7U W=3U AS=0.78P AD=1.32P PS=3.52U PD=6.88U
.ENDS nmos_6p0_CDNS_4066195613442

* cell pmos_6p0_CDNS_4066195613443
* pin
* pin
* pin
* pin
* pin
* pin
* pin
* pin
* pin
.SUBCKT pmos_6p0_CDNS_4066195613443 2 3 4 5 6 7 8 9 10
* device instance $1 r0 *1 0.35,1 pmos_6p0
M$1 2 6 4 10 pmos_6p0 L=0.7U W=2U AS=0.88P AD=0.52P PS=4.88U PD=2.52U
* device instance $2 r0 *1 1.57,1 pmos_6p0
M$2 3 7 2 10 pmos_6p0 L=0.7U W=2U AS=0.52P AD=0.52P PS=2.52U PD=2.52U
* device instance $3 r0 *1 2.79,1 pmos_6p0
M$3 5 8 3 10 pmos_6p0 L=0.7U W=2U AS=0.52P AD=0.88P PS=2.52U PD=4.88U
.ENDS pmos_6p0_CDNS_4066195613443

* cell pmos_6p0_CDNS_4066195613444
* pin
* pin
* pin
* pin
* pin
* pin
* pin
.SUBCKT pmos_6p0_CDNS_4066195613444 2 3 4 5 6 7 8
* device instance $1 r0 *1 0.35,0.95 pmos_6p0
M$1 2 5 3 8 pmos_6p0 L=0.7U W=1.9U AS=0.836P AD=0.494P PS=4.68U PD=2.42U
* device instance $2 r0 *1 1.57,0.95 pmos_6p0
M$2 4 6 2 8 pmos_6p0 L=0.7U W=1.9U AS=0.494P AD=0.836P PS=2.42U PD=4.68U
.ENDS pmos_6p0_CDNS_4066195613444

* cell pmos_6p0_CDNS_4066195613445
* pin
* pin
* pin
* pin
* pin
* pin
* pin
.SUBCKT pmos_6p0_CDNS_4066195613445 2 3 4 5 6 7 8
* device instance $1 r0 *1 0.35,2 pmos_6p0
M$1 2 5 3 8 pmos_6p0 L=0.7U W=4U AS=1.76P AD=1.04P PS=8.88U PD=4.52U
* device instance $2 r0 *1 1.57,2 pmos_6p0
M$2 4 6 2 8 pmos_6p0 L=0.7U W=4U AS=1.04P AD=1.76P PS=4.52U PD=8.88U
.ENDS pmos_6p0_CDNS_4066195613445

* cell M2_M1_CDNS_40661956134237
* pin
* pin
.SUBCKT M2_M1_CDNS_40661956134237 1 2
.ENDS M2_M1_CDNS_40661956134237

* cell M2_M1_CDNS_40661956134450
* pin
* pin
.SUBCKT M2_M1_CDNS_40661956134450 1 2
.ENDS M2_M1_CDNS_40661956134450

* cell M3_M2_CDNS_40661956134453
* pin
* pin
.SUBCKT M3_M2_CDNS_40661956134453 1 2
.ENDS M3_M2_CDNS_40661956134453

* cell M2_M1_CDNS_40661956134467
* pin
* pin
.SUBCKT M2_M1_CDNS_40661956134467 1 2
.ENDS M2_M1_CDNS_40661956134467

* cell M2_M1_CDNS_40661956134449
* pin
* pin
.SUBCKT M2_M1_CDNS_40661956134449 1 2
.ENDS M2_M1_CDNS_40661956134449

* cell M2_M1_CDNS_40661956134459
* pin
* pin
.SUBCKT M2_M1_CDNS_40661956134459 1 2
.ENDS M2_M1_CDNS_40661956134459

* cell M2_M1_CDNS_40661956134463
* pin
* pin
.SUBCKT M2_M1_CDNS_40661956134463 1 2
.ENDS M2_M1_CDNS_40661956134463

* cell M3_M2_CDNS_40661956134313
* pin
* pin
.SUBCKT M3_M2_CDNS_40661956134313 1 2
.ENDS M3_M2_CDNS_40661956134313

* cell M3_M2_CDNS_40661956134466
* pin
* pin
.SUBCKT M3_M2_CDNS_40661956134466 1 2
.ENDS M3_M2_CDNS_40661956134466

* cell M3_M2_CDNS_40661956134461
* pin
* pin
.SUBCKT M3_M2_CDNS_40661956134461 1 2
.ENDS M3_M2_CDNS_40661956134461

* cell M2_M1_CDNS_40661956134282
* pin
* pin
.SUBCKT M2_M1_CDNS_40661956134282 1 2
.ENDS M2_M1_CDNS_40661956134282

* cell M2_M1_CDNS_40661956134458
* pin
* pin
.SUBCKT M2_M1_CDNS_40661956134458 1 2
.ENDS M2_M1_CDNS_40661956134458

* cell M2_M1_CDNS_40661956134457
* pin
* pin
.SUBCKT M2_M1_CDNS_40661956134457 1 2
.ENDS M2_M1_CDNS_40661956134457

* cell M2_M1_CDNS_40661956134451
* pin
* pin
.SUBCKT M2_M1_CDNS_40661956134451 1 2
.ENDS M2_M1_CDNS_40661956134451

* cell M2_M1_CDNS_40661956134462
* pin
* pin
.SUBCKT M2_M1_CDNS_40661956134462 1 2
.ENDS M2_M1_CDNS_40661956134462

* cell M1_PSUB_CDNS_40661956134460
* pin
* pin
.SUBCKT M1_PSUB_CDNS_40661956134460 1 2
.ENDS M1_PSUB_CDNS_40661956134460

* cell M1_PSUB_CDNS_40661956134454
* pin
* pin
.SUBCKT M1_PSUB_CDNS_40661956134454 1 2
.ENDS M1_PSUB_CDNS_40661956134454

* cell M1_POLY2_CDNS_40661956134128
* pin
.SUBCKT M1_POLY2_CDNS_40661956134128 1
.ENDS M1_POLY2_CDNS_40661956134128

* cell M1_NWELL_CDNS_40661956134448
* pin
* pin
* pin
* pin
.SUBCKT M1_NWELL_CDNS_40661956134448 1 2 3 4
.ENDS M1_NWELL_CDNS_40661956134448

* cell comp018green_out_drv_pleg_4T_Y
* pin
* pin
* pin
* pin
* pin
* pin
.SUBCKT comp018green_out_drv_pleg_4T_Y 1 2 3 4 5 6
* cell instance $1 r0 *1 0,0
X$1 6 2 5 1 4 3 pmos_6p0_esd_40
.ENDS comp018green_out_drv_pleg_4T_Y

* cell comp018green_out_drv_pleg_4T_X
* pin
* pin
* pin
* pin
* pin
* pin
* pin
* pin
.SUBCKT comp018green_out_drv_pleg_4T_X 1 2 3 4 5 6 7 8
* cell instance $1 m90 *1 10.4,0
X$1 8 3 7 1 6 5 pmos_6p0_esd_40
* cell instance $2 r0 *1 0,0
X$2 8 4 7 2 6 5 pmos_6p0_esd_40
.ENDS comp018green_out_drv_pleg_4T_X

* cell M1_PSUB_CDNS_40661956134387
* pin
* pin
.SUBCKT M1_PSUB_CDNS_40661956134387 1 2
.ENDS M1_PSUB_CDNS_40661956134387

* cell M1_NWELL_CDNS_40661956134390
* pin
* pin
* pin
* pin
.SUBCKT M1_NWELL_CDNS_40661956134390 1 2 3 4
.ENDS M1_NWELL_CDNS_40661956134390

* cell PMOS_4T_metal_stack
* pin
* pin
* pin
* pin
.SUBCKT PMOS_4T_metal_stack 1 2 3 4
* cell instance $1 r0 *1 0.39,1.545
X$1 3 1 M3_M2_CDNS_40661956134368
* cell instance $2 r0 *1 0.39,19.97
X$2 3 1 M2_M1_CDNS_40661956134468
* cell instance $3 r0 *1 0.39,27.51
X$3 3 1 M3_M2_CDNS_40661956134312
* cell instance $4 r0 *1 0.39,11.575
X$4 3 1 M3_M2_CDNS_40661956134312
* cell instance $5 r0 *1 0.39,38.015
X$5 3 1 M3_M2_CDNS_40661956134456
* cell instance $6 r0 *1 4.81,19.97
X$6 4 2 M2_M1_CDNS_40661956134469
.ENDS PMOS_4T_metal_stack

* cell M1_PSUB_CDNS_40661956134465
* pin
* pin
.SUBCKT M1_PSUB_CDNS_40661956134465 1 2
.ENDS M1_PSUB_CDNS_40661956134465

* cell M1_PSUB_CDNS_40661956134452
* pin
* pin
.SUBCKT M1_PSUB_CDNS_40661956134452 1 2
.ENDS M1_PSUB_CDNS_40661956134452

* cell M1_NWELL_CDNS_40661956134464
* pin
* pin
* pin
* pin
.SUBCKT M1_NWELL_CDNS_40661956134464 1 2 3 4
.ENDS M1_NWELL_CDNS_40661956134464

* cell M1_NWELL_CDNS_40661956134455
* pin
* pin
* pin
* pin
.SUBCKT M1_NWELL_CDNS_40661956134455 1 2 3 4
.ENDS M1_NWELL_CDNS_40661956134455

* cell comp018green_out_drv_nleg_4T
* pin
* pin
* pin
* pin
* pin
* pin
.SUBCKT comp018green_out_drv_nleg_4T 1 2 3 4 5 6
.ENDS comp018green_out_drv_nleg_4T

* cell nmos_4T_metal_stack
* pin
* pin
* pin
* pin
.SUBCKT nmos_4T_metal_stack 1 2 3 4
* cell instance $1 r0 *1 6.26,20.995
X$1 4 1 M2_M1_CDNS_40661956134471
* cell instance $2 r0 *1 0.4,6.7
X$2 3 2 M3_M2_CDNS_40661956134474
* cell instance $3 r0 *1 0.39,21.035
X$3 3 2 M2_M1_CDNS_40661956134470
* cell instance $4 r0 *1 0.4,19.895
X$4 3 2 M3_M2_CDNS_40661956134473
* cell instance $5 r0 *1 0.4,34.2
X$5 3 2 M3_M2_CDNS_40661956134472
.ENDS nmos_4T_metal_stack

* cell GR_NMOS_4T
* pin
* pin
.SUBCKT GR_NMOS_4T 1 4
* cell instance $1 r0 *1 25.185,-1.495
X$1 1 1 5 2 M1_NWELL_CDNS_40661956134476
* cell instance $2 r0 *1 25.185,49.945
X$2 1 1 5 2 M1_NWELL_CDNS_40661956134477
* cell instance $3 r0 *1 -1.365,20.885
X$3 4 3 M1_PSUB_CDNS_40661956134475
* cell instance $4 r0 *1 51.73,20.885
X$4 4 3 M1_PSUB_CDNS_40661956134478
* cell instance $5 r90 *1 25.17,0.885
X$5 4 3 M1_PSUB_CDNS_40661956134479
.ENDS GR_NMOS_4T

* cell M2_M1_CDNS_40661956134235
* pin
* pin
.SUBCKT M2_M1_CDNS_40661956134235 1 2
.ENDS M2_M1_CDNS_40661956134235

* cell M3_M2_CDNS_40661956134285
* pin
* pin
.SUBCKT M3_M2_CDNS_40661956134285 1 2
.ENDS M3_M2_CDNS_40661956134285

* cell M2_M1_CDNS_40661956134166
* pin
* pin
.SUBCKT M2_M1_CDNS_40661956134166 1 2
.ENDS M2_M1_CDNS_40661956134166

* cell M2_M1_CDNS_40661956134149
* pin
* pin
.SUBCKT M2_M1_CDNS_40661956134149 1 2
.ENDS M2_M1_CDNS_40661956134149

* cell M2_M1_CDNS_40661956134150
* pin
* pin
.SUBCKT M2_M1_CDNS_40661956134150 1 2
.ENDS M2_M1_CDNS_40661956134150

* cell M2_M1_CDNS_40661956134151
* pin
* pin
.SUBCKT M2_M1_CDNS_40661956134151 1 2
.ENDS M2_M1_CDNS_40661956134151

* cell M2_M1_CDNS_40661956134468
* pin
* pin
.SUBCKT M2_M1_CDNS_40661956134468 1 2
.ENDS M2_M1_CDNS_40661956134468

* cell M2_M1_CDNS_40661956134469
* pin
* pin
.SUBCKT M2_M1_CDNS_40661956134469 1 2
.ENDS M2_M1_CDNS_40661956134469

* cell M2_M1_CDNS_40661956134470
* pin
* pin
.SUBCKT M2_M1_CDNS_40661956134470 1 2
.ENDS M2_M1_CDNS_40661956134470

* cell M2_M1_CDNS_40661956134471
* pin
* pin
.SUBCKT M2_M1_CDNS_40661956134471 1 2
.ENDS M2_M1_CDNS_40661956134471

* cell M3_M2_CDNS_40661956134472
* pin
* pin
.SUBCKT M3_M2_CDNS_40661956134472 1 2
.ENDS M3_M2_CDNS_40661956134472

* cell M3_M2_CDNS_40661956134473
* pin
* pin
.SUBCKT M3_M2_CDNS_40661956134473 1 2
.ENDS M3_M2_CDNS_40661956134473

* cell M3_M2_CDNS_40661956134474
* pin
* pin
.SUBCKT M3_M2_CDNS_40661956134474 1 2
.ENDS M3_M2_CDNS_40661956134474

* cell M2_M1_CDNS_40661956134152
* pin
* pin
.SUBCKT M2_M1_CDNS_40661956134152 1 2
.ENDS M2_M1_CDNS_40661956134152

* cell ppolyf_u_CDNS_406619561345
* pin
* pin
* pin gf180mcu_gnd
.SUBCKT ppolyf_u_CDNS_406619561345 1 2 3
* net 3 gf180mcu_gnd
* device instance $1 r0 *1 32.437,0.4 ppolyf_u
R$1 2 1 3 27936.5625 ppolyf_u L=63.855U W=0.8U
.ENDS ppolyf_u_CDNS_406619561345

* cell nmoscap_6p0_CDNS_406619561340
* pin
* pin
.SUBCKT nmoscap_6p0_CDNS_406619561340 1 2
* device instance $1 r0 *1 5,12.5 nmoscap_6p0
C$1 2 1 5.75e-13 nmoscap_6p0 A=250P P=70U
.ENDS nmoscap_6p0_CDNS_406619561340

* cell M1_PSUB_CDNS_4066195613411
* pin
* pin
.SUBCKT M1_PSUB_CDNS_4066195613411 1 2
.ENDS M1_PSUB_CDNS_4066195613411

* cell M1_PSUB_CDNS_406619561349
* pin
* pin
.SUBCKT M1_PSUB_CDNS_406619561349 1 2
.ENDS M1_PSUB_CDNS_406619561349

* cell M1_NWELL_CDNS_40661956134154
* pin
* pin
* pin
* pin
.SUBCKT M1_NWELL_CDNS_40661956134154 1 2 3 4
.ENDS M1_NWELL_CDNS_40661956134154

* cell M1_NWELL_CDNS_40661956134153
* pin
* pin
* pin
* pin
.SUBCKT M1_NWELL_CDNS_40661956134153 1 2 3 4
.ENDS M1_NWELL_CDNS_40661956134153

* cell M2_M1_CDNS_40661956134142
* pin
* pin
.SUBCKT M2_M1_CDNS_40661956134142 1 2
.ENDS M2_M1_CDNS_40661956134142

* cell M2_M1_CDNS_40661956134144
* pin
* pin
.SUBCKT M2_M1_CDNS_40661956134144 1 2
.ENDS M2_M1_CDNS_40661956134144

* cell M2_M1_CDNS_40661956134141
* pin
* pin
.SUBCKT M2_M1_CDNS_40661956134141 1 2
.ENDS M2_M1_CDNS_40661956134141

* cell M1_POLY2_CDNS_40661956134136
* pin
.SUBCKT M1_POLY2_CDNS_40661956134136 1
.ENDS M1_POLY2_CDNS_40661956134136

* cell M2_M1_CDNS_40661956134145
* pin
* pin
.SUBCKT M2_M1_CDNS_40661956134145 1 2
.ENDS M2_M1_CDNS_40661956134145

* cell M2_M1_CDNS_40661956134140
* pin
* pin
.SUBCKT M2_M1_CDNS_40661956134140 1 2
.ENDS M2_M1_CDNS_40661956134140

* cell M2_M1_CDNS_40661956134146
* pin
* pin
.SUBCKT M2_M1_CDNS_40661956134146 1 2
.ENDS M2_M1_CDNS_40661956134146

* cell M2_M1_CDNS_40661956134148
* pin
* pin
.SUBCKT M2_M1_CDNS_40661956134148 1 2
.ENDS M2_M1_CDNS_40661956134148

* cell M2_M1_CDNS_40661956134143
* pin
* pin
.SUBCKT M2_M1_CDNS_40661956134143 1 2
.ENDS M2_M1_CDNS_40661956134143

* cell M2_M1_CDNS_40661956134147
* pin
* pin
.SUBCKT M2_M1_CDNS_40661956134147 1 2
.ENDS M2_M1_CDNS_40661956134147

* cell nmos_6p0_CDNS_406619561341
* pin
* pin
* pin
* pin
* pin
* pin
* pin
* pin
* pin
* pin
* pin
* pin
* pin
* pin
* pin
* pin
* pin
* pin
* pin
* pin
* pin
* pin
* pin
* pin
* pin
* pin
* pin
* pin
* pin
* pin
* pin
* pin
* pin
* pin
* pin
* pin
* pin
* pin
* pin
* pin
* pin
* pin gf180mcu_gnd
.SUBCKT nmos_6p0_CDNS_406619561341 2 3 4 5 6 7 8 9 10 11 12 13 14 15 16 17 18
+ 19 20 21 22 23 24 25 26 27 28 29 30 31 32 33 34 35 36 37 38 39 40 41 42 43
* net 43 gf180mcu_gnd
* device instance $1 r0 *1 0.35,25 nmos_6p0
M$1 3 23 2 43 nmos_6p0 L=0.7U W=50U AS=22P AD=13P PS=100.88U PD=50.52U
* device instance $2 r0 *1 1.57,25 nmos_6p0
M$2 4 24 3 43 nmos_6p0 L=0.7U W=50U AS=13P AD=13P PS=50.52U PD=50.52U
* device instance $3 r0 *1 2.79,25 nmos_6p0
M$3 5 25 4 43 nmos_6p0 L=0.7U W=50U AS=13P AD=13P PS=50.52U PD=50.52U
* device instance $4 r0 *1 4.01,25 nmos_6p0
M$4 6 26 5 43 nmos_6p0 L=0.7U W=50U AS=13P AD=13P PS=50.52U PD=50.52U
* device instance $5 r0 *1 5.23,25 nmos_6p0
M$5 7 27 6 43 nmos_6p0 L=0.7U W=50U AS=13P AD=13P PS=50.52U PD=50.52U
* device instance $6 r0 *1 6.45,25 nmos_6p0
M$6 8 28 7 43 nmos_6p0 L=0.7U W=50U AS=13P AD=13P PS=50.52U PD=50.52U
* device instance $7 r0 *1 7.67,25 nmos_6p0
M$7 9 29 8 43 nmos_6p0 L=0.7U W=50U AS=13P AD=13P PS=50.52U PD=50.52U
* device instance $8 r0 *1 8.89,25 nmos_6p0
M$8 10 30 9 43 nmos_6p0 L=0.7U W=50U AS=13P AD=13P PS=50.52U PD=50.52U
* device instance $9 r0 *1 10.11,25 nmos_6p0
M$9 11 31 10 43 nmos_6p0 L=0.7U W=50U AS=13P AD=13P PS=50.52U PD=50.52U
* device instance $10 r0 *1 11.33,25 nmos_6p0
M$10 12 32 11 43 nmos_6p0 L=0.7U W=50U AS=13P AD=13P PS=50.52U PD=50.52U
* device instance $11 r0 *1 12.55,25 nmos_6p0
M$11 13 33 12 43 nmos_6p0 L=0.7U W=50U AS=13P AD=13P PS=50.52U PD=50.52U
* device instance $12 r0 *1 13.77,25 nmos_6p0
M$12 14 34 13 43 nmos_6p0 L=0.7U W=50U AS=13P AD=13P PS=50.52U PD=50.52U
* device instance $13 r0 *1 14.99,25 nmos_6p0
M$13 15 35 14 43 nmos_6p0 L=0.7U W=50U AS=13P AD=13P PS=50.52U PD=50.52U
* device instance $14 r0 *1 16.21,25 nmos_6p0
M$14 16 36 15 43 nmos_6p0 L=0.7U W=50U AS=13P AD=13P PS=50.52U PD=50.52U
* device instance $15 r0 *1 17.43,25 nmos_6p0
M$15 17 37 16 43 nmos_6p0 L=0.7U W=50U AS=13P AD=13P PS=50.52U PD=50.52U
* device instance $16 r0 *1 18.65,25 nmos_6p0
M$16 18 38 17 43 nmos_6p0 L=0.7U W=50U AS=13P AD=13P PS=50.52U PD=50.52U
* device instance $17 r0 *1 19.87,25 nmos_6p0
M$17 19 39 18 43 nmos_6p0 L=0.7U W=50U AS=13P AD=13P PS=50.52U PD=50.52U
* device instance $18 r0 *1 21.09,25 nmos_6p0
M$18 20 40 19 43 nmos_6p0 L=0.7U W=50U AS=13P AD=13P PS=50.52U PD=50.52U
* device instance $19 r0 *1 22.31,25 nmos_6p0
M$19 21 41 20 43 nmos_6p0 L=0.7U W=50U AS=13P AD=13P PS=50.52U PD=50.52U
* device instance $20 r0 *1 23.53,25 nmos_6p0
M$20 22 42 21 43 nmos_6p0 L=0.7U W=50U AS=13P AD=22P PS=50.52U PD=100.88U
.ENDS nmos_6p0_CDNS_406619561341

* cell M1_PSUB_CDNS_40661956134138
* pin
* pin
.SUBCKT M1_PSUB_CDNS_40661956134138 1 2
.ENDS M1_PSUB_CDNS_40661956134138

* cell M1_PSUB_CDNS_40661956134137
* pin
* pin
.SUBCKT M1_PSUB_CDNS_40661956134137 1 2
.ENDS M1_PSUB_CDNS_40661956134137

* cell M1_PSUB_CDNS_40661956134134
* pin
* pin
.SUBCKT M1_PSUB_CDNS_40661956134134 1 2
.ENDS M1_PSUB_CDNS_40661956134134

* cell M1_NWELL_CDNS_40661956134139
* pin
* pin
* pin
* pin
.SUBCKT M1_NWELL_CDNS_40661956134139 1 2 3 4
.ENDS M1_NWELL_CDNS_40661956134139

* cell M1_NWELL_CDNS_40661956134135
* pin
* pin
* pin
* pin
.SUBCKT M1_NWELL_CDNS_40661956134135 1 2 3 4
.ENDS M1_NWELL_CDNS_40661956134135

* cell M1_NWELL_CDNS_40661956134322
* pin
* pin
* pin
* pin
.SUBCKT M1_NWELL_CDNS_40661956134322 1 2 3 4
.ENDS M1_NWELL_CDNS_40661956134322

* cell M1_PSUB_CDNS_40661956134328
* pin
* pin
.SUBCKT M1_PSUB_CDNS_40661956134328 1 2
.ENDS M1_PSUB_CDNS_40661956134328

* cell nmos_6p0_CDNS_4066195613411
* pin
* pin
* pin
* pin
.SUBCKT nmos_6p0_CDNS_4066195613411 1 2 3 4
.ENDS nmos_6p0_CDNS_4066195613411

* cell M1_NWELL_CDNS_40661956134426
* pin
* pin
* pin
* pin
.SUBCKT M1_NWELL_CDNS_40661956134426 1 2 3 4
.ENDS M1_NWELL_CDNS_40661956134426

* cell M1_PSUB_CDNS_40661956134427
* pin
* pin
.SUBCKT M1_PSUB_CDNS_40661956134427 1 2
.ENDS M1_PSUB_CDNS_40661956134427

* cell pmos_6p0_CDNS_4066195613412
* pin
* pin
* pin
* pin
* pin
* pin
.SUBCKT pmos_6p0_CDNS_4066195613412 1 2 3 4 5 6
.ENDS pmos_6p0_CDNS_4066195613412

* cell M1_PSUB_CDNS_40661956134330
* pin
* pin
.SUBCKT M1_PSUB_CDNS_40661956134330 1 2
.ENDS M1_PSUB_CDNS_40661956134330

* cell nmos_6p0_CDNS_4066195613430
* pin
* pin
* pin
.SUBCKT nmos_6p0_CDNS_4066195613430 2 3 4
.ENDS nmos_6p0_CDNS_4066195613430

* cell M1_NWELL_CDNS_40661956134418
* pin
* pin
* pin
* pin
.SUBCKT M1_NWELL_CDNS_40661956134418 1 2 3 4
.ENDS M1_NWELL_CDNS_40661956134418

* cell M3_M2_CDNS_40661956134312
* pin
* pin
.SUBCKT M3_M2_CDNS_40661956134312 1 2
.ENDS M3_M2_CDNS_40661956134312

* cell M3_M2_CDNS_40661956134456
* pin
* pin
.SUBCKT M3_M2_CDNS_40661956134456 1 2
.ENDS M3_M2_CDNS_40661956134456

* cell pmos_6p0_esd_40
* pin
* pin
* pin
* pin
* pin
* pin
.SUBCKT pmos_6p0_esd_40 1 2 3 4 5 6
.ENDS pmos_6p0_esd_40

* cell M1_PSUB_CDNS_40661956134479
* pin
* pin
.SUBCKT M1_PSUB_CDNS_40661956134479 1 2
.ENDS M1_PSUB_CDNS_40661956134479

* cell M1_PSUB_CDNS_40661956134478
* pin
* pin
.SUBCKT M1_PSUB_CDNS_40661956134478 1 2
.ENDS M1_PSUB_CDNS_40661956134478

* cell M1_PSUB_CDNS_40661956134475
* pin
* pin
.SUBCKT M1_PSUB_CDNS_40661956134475 1 2
.ENDS M1_PSUB_CDNS_40661956134475

* cell M1_NWELL_CDNS_40661956134477
* pin
* pin
* pin
* pin
.SUBCKT M1_NWELL_CDNS_40661956134477 1 2 3 4
.ENDS M1_NWELL_CDNS_40661956134477

* cell M1_NWELL_CDNS_40661956134476
* pin
* pin
* pin
* pin
.SUBCKT M1_NWELL_CDNS_40661956134476 1 2 3 4
.ENDS M1_NWELL_CDNS_40661956134476

* cell M1_POLY2_CDNS_40661956134326
* pin
.SUBCKT M1_POLY2_CDNS_40661956134326 1
.ENDS M1_POLY2_CDNS_40661956134326

* cell M2_M1_CDNS_40661956134270
* pin
* pin
.SUBCKT M2_M1_CDNS_40661956134270 1 2
.ENDS M2_M1_CDNS_40661956134270

* cell M3_M2_CDNS_40661956134368
* pin
* pin
.SUBCKT M3_M2_CDNS_40661956134368 1 2
.ENDS M3_M2_CDNS_40661956134368
